// Fifth-order Butterworth LC ladder low-pass, 50 ohm, 100 MHz, with source and load
// Doubly terminated: source resistor RS, shunt C1, series L2, shunt C3, series L4, shunt C5, load RL.
// @RNL(type="header") { @USE-PACKAGE(name="rnl-std-all", version="0.4"); @USE-PACKAGE(name="rnl-std-semantics", version="0.4"); @VERSION("0.4")}
simulator lang=spectre

VS (src 0) vsource dc=0 mag=2
RS (src in) resistor r=50
C1 (in 0) capacitor c=19.7p
L2 (in n2) inductor l=128.8n
C3 (n2 0) capacitor c=63.7p
L4 (n2 out) inductor l=128.8n
C5 (out 0) capacitor c=19.7p
RL (out 0) resistor r=50
// @RNL {
//   #VS @SET-SYMBOL $SINE_VOLTAGE_SOURCE;
//   $NET_LABEL @ATTACH &out => %pout;
//   %routed_nets = # @SELECT-NET;
//   %routed_nets @ROUTE-NET;
//
//   /* what the circuit is: a doubly terminated fifth-order LC ladder, shunt C1, series L2, shunt C3, series L4, shunt C5,
//      between the source resistor RS and the load RL */
//   %pi1 = #C1(shunt1) #L2(series) #C3(shunt2) @AS $PI_NETWORK;
//   %pi2 = #C3(shunt1) #L4(series) #C5(shunt2) @AS $PI_NETWORK;
//   %t1 = #L2(series1) #C3(shunt) #L4(series2) @AS $T_NETWORK;
//   {#C1 #C5} @AS $MATCHED_CAPACITOR;
//   {#L2 #L4} @AS $MATCHED;
//   {#RS #RL} @AS $MATCHED_RESISTOR;
//   %flow = {#RS #C1 #L2 #C3 #L4 #C5}(path) {#VS}(source) {#RL %pout}(load) @AS $SIGNAL_FLOW;
//
//   /* no branch here (nothing carries DC): the ladder is laid out by hand.
//      The series path is one row, lying: source resistor, L2, L4 */
//   %series_row = {#RS #L2 #L4} @ALIGN("y");
//
//   /* from left to right the source, the series parts alternating with the shunt capacitors, the load and the output
//      tag; the shunt capacitors and the load in one row below the series row */
//   %ladder_order = {#VS #RS #C1 #L2 #C3 #L4 #C5 #RL %pout} @ORDER("left-to-right");
//   %shunt_row = {#C1 #C3 #C5 #RL} @ALIGN("y");
//   %shunt_below_series = {#C1 #C3 #C5} {#RS #L2 #L4} @DISTANCE("bottom-to-top", min=3);
//
//   /* the source and the load stand upright */
//   %upright_parts = {#VS #RL} @ORIENT("R0");
// }
// @RNL(type="generated", priority="high", author="rnl-solver 0.1", hash="sig2:aa4507965a9a05da.1275580c3a1bf202", numbering="9543ad0fdf8c9c79") {
//   %ground_stub_VS_n = $GROUND_STUB @ATTACH(gap=3) #VS::n;
//   %ground_stub_C1_n = $GROUND_STUB @ATTACH(gap=3) #C1::n;
//   %ground_stub_C3_n = $GROUND_STUB @ATTACH(gap=3) #C3::n;
//   %ground_stub_C5_n = $GROUND_STUB @ATTACH(gap=3) #C5::n;
//   %ground_stub_RL_n = $GROUND_STUB @ATTACH(gap=3) #RL::n;
//   %rt1 = (10, 7);
//   %rt2 = (18, 7);
//   %rt3 = (25, 7);
//   %rt4 = (31, 7);
//   #VS @PLACE(0, 4) => @ORIENT("R0");
//   #RS @PLACE(6, 7) => @ORIENT("R90");
//   #C1 @PLACE(10, 0) => @ORIENT("R0");
//   #L2 @PLACE(14, 7) => @ORIENT("R90");
//   #C3 @PLACE(18, 0) => @ORIENT("R0");
//   #L4 @PLACE(22, 7) => @ORIENT("R90");
//   #C5 @PLACE(25, 0) => @ORIENT("R0");
//   #RL @PLACE(31, 0) => @ORIENT("R0");
//   %pout @PLACE(33, 7) => @ORIENT("MY");
//   %pi1 @PLACE(10, 0);
//   %pi2 @PLACE(10, 0);
//   %t1 @PLACE(10, 0);
//   %#1 @PLACE(10, 0);
//   %#2 @PLACE(10, 0);
//   %#3 @PLACE(10, 0);
//   %#4 @PLACE(10, 0);
//   %#5 @PLACE(10, 0);
//   %flow @PLACE(10, 0);
//   %ground_stub_VS_n @PLACE(10, 0);
//   %ground_stub_VS_n::g @PLACE(0, 0) => @ORIENT("R0");
//   %ground_stub_C1_n @PLACE(10, 0);
//   %ground_stub_C1_n::g @PLACE(10, -4) => @ORIENT("R0");
//   %ground_stub_C3_n @PLACE(10, 0);
//   %ground_stub_C3_n::g @PLACE(18, -4) => @ORIENT("R0");
//   %ground_stub_C5_n @PLACE(10, 0);
//   %ground_stub_C5_n::g @PLACE(25, -4) => @ORIENT("R0");
//   %ground_stub_RL_n @PLACE(10, 0);
//   %ground_stub_RL_n::g @PLACE(31, -4) => @ORIENT("R0");
//   &src @WIRE(mode="straight") {#VS::p (0, 7) #RS::p};
//   &in @WIRE(mode="straight") {#RS::n %rt1};
//   &in @WIRE(mode="straight") {#C1::p %rt1};
//   &in @WIRE(mode="straight") {%rt1 #L2::p};
//   &n2 @WIRE(mode="straight") {#L2::n %rt2};
//   &n2 @WIRE(mode="straight") {#C3::p %rt2};
//   &n2 @WIRE(mode="straight") {%rt2 #L4::p};
//   &out @WIRE(mode="straight") {#L4::n %rt3};
//   &out @WIRE(mode="straight") {#C5::p %rt3};
//   &out @WIRE(mode="straight") {%rt3 %rt4};
//   &out @WIRE(mode="straight") {#RL::p %rt4};
//   &out @WIRE(mode="straight") {%rt4 %pout::pin};
//   $JUNCTION @ATTACH %rt1 => @PLACE(10, 7);
//   $JUNCTION @ATTACH %rt2 => @PLACE(18, 7);
//   $JUNCTION @ATTACH %rt3 => @PLACE(25, 7);
//   $JUNCTION @ATTACH %rt4 => @PLACE(31, 7)
// }
