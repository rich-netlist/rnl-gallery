// RNL cell RISCA_JL/LB_crossbar_cell
// @RNL(type="header") {
//   @VERSION("0.3");
//   @USE-PACKAGE(name="eda-symbol", version="0.1", path="eda-symbol.rnl");
//   @USE-PACKAGE(name="eda-style", version="0.1", path="eda-style.rnl")
// }
subckt LB_crossbar_cell COL GND PRE ROW SCK SDI SDO VDD BUS REP
    M22 (BUS REP SDO GND) nch_mac l=30n w=600n multi=1 nf=2 sd=100n \
        ad=3e-14 as=4.5e-14 pd=800n ps=1.5u nrd=0.910886 nrs=0.910886 \
        sa=112.742n sb=112.742n sa1=93.6047n sa2=112.078n sa3=163.715n \
        sa4=110.059n sb1=93.6047n sb2=112.078n sb3=163.715n spa=100n \
        spa1=100n spa2=100n spa3=100n sap=104.359n sapb=125.813n \
        spba=115.715n spba1=117.043n dfm_flag=0 spmt=1.11111e+15 spomt=0 \
        spomt1=1.11111e+60 spmb=1.11111e+15 spomb=0 spomb1=1.11111e+60
    M0 (ROW net1 GND GND) nch_mac l=30n w=240.0n multi=1 nf=1 sd=100n \
        ad=1.8e-14 as=1.8e-14 pd=630.0n ps=630.0n nrd=1.326151 \
        nrs=1.326151 sa=75.0n sb=75.0n sa1=75.0n sa2=75.0n sa3=75.0n \
        sa4=75.0n sb1=75.0n sb2=75.0n sb3=75.0n spa=100n spa1=100n \
        spa2=100n spa3=100n sap=91.9776n sapb=114.444n spba=115.715n \
        spba1=117.043n dfm_flag=0 spmt=1.11111e+15 spomt=0 \
        spomt1=1.11111e+60 spmb=1.11111e+15 spomb=0 spomb1=1.11111e+60
    M3 (net1 SDO COL GND) nch_mac l=30n w=200n multi=1 nf=1 sd=100n \
        ad=1.5e-14 as=1.5e-14 pd=550.0n ps=550.0n nrd=2.828877 \
        nrs=2.828877 sa=75.0n sb=75.0n sa1=75.0n sa2=75.0n sa3=75.0n \
        sa4=75.0n sb1=75.0n sb2=75.0n sb3=75.0n spa=100n spa1=100n \
        spa2=100n spa3=100n sap=91.9776n sapb=114.444n spba=115.715n \
        spba1=117.043n dfm_flag=0 spmt=1.11111e+15 spomt=0 \
        spomt1=1.11111e+60 spmb=1.11111e+15 spomb=0 spomb1=1.11111e+60
    M5 (net4 net3 COL GND) nch_mac l=30n w=200n multi=1 nf=1 sd=100n \
        ad=1.5e-14 as=1.5e-14 pd=550.0n ps=550.0n nrd=2.828877 \
        nrs=2.828877 sa=75.0n sb=75.0n sa1=75.0n sa2=75.0n sa3=75.0n \
        sa4=75.0n sb1=75.0n sb2=75.0n sb3=75.0n spa=100n spa1=100n \
        spa2=100n spa3=100n sap=91.9776n sapb=114.444n spba=115.715n \
        spba1=117.043n dfm_flag=0 spmt=1.11111e+15 spomt=0 \
        spomt1=1.11111e+60 spmb=1.11111e+15 spomb=0 spomb1=1.11111e+60
    M7 (net4 net2 GND GND) nch_mac l=30n w=200n multi=1 nf=1 sd=100n \
        ad=1.5e-14 as=1.5e-14 pd=550.0n ps=550.0n nrd=2.828877 \
        nrs=2.828877 sa=75.0n sb=75.0n sa1=75.0n sa2=75.0n sa3=75.0n \
        sa4=75.0n sb1=75.0n sb2=75.0n sb3=75.0n spa=100n spa1=100n \
        spa2=100n spa3=100n sap=91.9776n sapb=114.444n spba=115.715n \
        spba1=117.043n dfm_flag=0 spmt=1.11111e+15 spomt=0 \
        spomt1=1.11111e+60 spmb=1.11111e+15 spomb=0 spomb1=1.11111e+60
    M6 (net1 SDB GND GND) nch_mac l=30n w=200n multi=1 nf=1 sd=100n \
        ad=1.5e-14 as=1.5e-14 pd=550.0n ps=550.0n nrd=2.828877 \
        nrs=2.828877 sa=75.0n sb=75.0n sa1=75.0n sa2=75.0n sa3=75.0n \
        sa4=75.0n sb1=75.0n sb2=75.0n sb3=75.0n spa=100n spa1=100n \
        spa2=100n spa3=100n sap=91.9776n sapb=114.444n spba=115.715n \
        spba1=117.043n dfm_flag=0 spmt=1.11111e+15 spomt=0 \
        spomt1=1.11111e+60 spmb=1.11111e+15 spomb=0 spomb1=1.11111e+60
    I22 (VDD GND) DCAP4BWP12T30P140
    I20 (PRE SDB net2 VDD GND) ND2D0BWP12T30P140
    I15 (net4 net5 VDD GND) INVD0BWP12T30P140
    I23 (net2 net3 VDD GND) INVD0BWP12T30P140
    M2 (COL SDB net1 VDD) pch_mac l=30n w=260.0n multi=1 nf=1 sd=100n \
        ad=1.95e-14 as=1.95e-14 pd=670.0n ps=670.0n nrd=0.789742 \
        nrs=0.789742 sa=75.0n sb=75.0n sa1=75.0n sa2=75.0n sa3=75.0n \
        sa4=75.0n sb1=75.0n sb2=75.0n sb3=75.0n spa=100n spa1=100n \
        spa2=100n spa3=100n sap=91.9776n sapb=114.444n spba=115.715n \
        spba1=117.043n dfm_flag=0 spmt=1.11111e+15 spomt=0 \
        spomt1=1.11111e+60 spmb=1.11111e+15 spomb=0 spomb1=1.11111e+60
    M4 (COL net2 net4 VDD) pch_mac l=30n w=260.0n multi=1 nf=1 sd=100n \
        ad=1.95e-14 as=1.95e-14 pd=670.0n ps=670.0n nrd=0.789742 \
        nrs=0.789742 sa=75.0n sb=75.0n sa1=75.0n sa2=75.0n sa3=75.0n \
        sa4=75.0n sb1=75.0n sb2=75.0n sb3=75.0n spa=100n spa1=100n \
        spa2=100n spa3=100n sap=91.9776n sapb=114.444n spba=115.715n \
        spba1=117.043n dfm_flag=0 spmt=1.11111e+15 spomt=0 \
        spomt1=1.11111e+60 spmb=1.11111e+15 spomb=0 spomb1=1.11111e+60
    M1 (ROW net5 VDD VDD) pch_mac l=30n w=350.0n multi=1 nf=1 sd=100n \
        ad=2.625e-14 as=2.625e-14 pd=850.0n ps=850.0n nrd=0.503816 \
        nrs=0.503816 sa=75.0n sb=75.0n sa1=75.0n sa2=75.0n sa3=75.0n \
        sa4=75.0n sb1=75.0n sb2=75.0n sb3=75.0n spa=100n spa1=100n \
        spa2=100n spa3=100n sap=91.9776n sapb=114.444n spba=115.715n \
        spba1=117.043n dfm_flag=0 spmt=1.11111e+15 spomt=0 \
        spomt1=1.11111e+60 spmb=1.11111e+15 spomb=0 spomb1=1.11111e+60
    I21 (SDI SCK SDO SDB VDD GND) DFD1BWP12T30P140
// @RNL(author="rnl-virtuoso") {
//   %block_symbol = @DEFINE-SYMBOL(box=[-2, -9, 18, 3]) {
//     @LINE {(-2, -3) (2, -3)};
//     @LINE {(4, -9) (4, -5)};
//     @LINE {(16, 3) (16, -1)};
//     @LINE {(16, -9) (16, -5)};
//     @RECTANGLE {(2, -5) (18, -1)};
//     @LINE {(-2, -3) (2, -3)};
//     @LINE {(14, -9) (14, -5)};
//     @LINE {(12, 3) (12, -1)};
//     @LINE {(6, -9) (6, -5)};
//     @LINE {(10, 3) (10, -1)};
//     @LINE {(14, 3) (14, -1)};
//     @LINE {(8, 3) (8, -1)};
//     ? @TEXT("${name}", size=1, halign="start", valign="middle", key="name") => @PLACE(-2, 2);
//     ? @TEXT("${model}", size=1, halign="middle", valign="middle", key="model") => @PLACE(12, -3.5);
//     (12, 3) @PIN(terminal="SDI");
//     (11, 2.4) @TEXT("SDI", size=1, halign="end", valign="middle", rotate=90);
//     (-2, -3) @PIN(terminal="ROW");
//     (-1.4, -2) @TEXT("ROW", size=1, halign="start", valign="middle");
//     (4, -9) @PIN(terminal="COL");
//     (3, -5.6) @TEXT("COL", size=1, halign="end", valign="middle", rotate=90);
//     (16, -9) @PIN(terminal="GND");
//     (15, -8.4) @TEXT("GND", size=1, halign="start", valign="middle", rotate=90);
//     (10, 3) @PIN(terminal="PRE");
//     (9, 2.4) @TEXT("PRE", size=1, halign="end", valign="middle", rotate=90);
//     (14, -9) @PIN(terminal="SCK");
//     (13, -8.4) @TEXT("SCK", size=1, halign="start", valign="middle", rotate=90);
//     (14, 3) @PIN(terminal="SDO");
//     (13, 2.4) @TEXT("SDO", size=1, halign="end", valign="middle", rotate=90);
//     (6, -9) @PIN(terminal="REP");
//     (5, -5.6) @TEXT("REP", size=1, halign="end", valign="middle", rotate=90);
//     (16, 3) @PIN(terminal="VDD");
//     (15, -0.4) @TEXT("VDD", size=1, halign="start", valign="middle", rotate=90);
//     (8, 3) @PIN(terminal="BUS");
//     (7, 2.4) @TEXT("BUS", size=1, halign="end", valign="middle", rotate=90)
//   };
//   # @SET-SYMBOL %block_symbol;
//   %symbol_0 = @DEFINE-SYMBOL(box=[-0.1, -2.8, 3.8, 2.8]) {
//     @LINE {(0, 0) (0.7, 0)};
//     @LINE {(1.5, 1.5) (1.5, -1.5)};
//     @LINE {(2, -1.5) (4, -1.5) (4, -3)};
//     @LINE {(2, 1.5) (4, 1.5) (4, 3)};
//     (1.1, 0) @CIRCLE(radius=0.4);
//     @LINE {(3.7, 2) (2.7, 1.5) (3.7, 1)};
//     @LINE {(2, -1.5) (2, 1.5)};
//     ? @TEXT("${name}", size=0.8, halign="start", valign="baseline", key="name") => @PLACE(4.9, 3.4);
//     ? @TEXT("${model}", size=0.8, halign="end", valign="baseline", key="model") => @PLACE(3.3, 3.2);
//     (4, 3) @PIN(terminal=3);
//     (4, 1) @PIN(terminal=4);
//     (0, 0) @PIN(terminal=2);
//     (4, -3) @PIN(terminal=1)
//   };
//   #"M1" @SET-SYMBOL %symbol_0;
//   #"M1" @PLACE(72, 25) => @ORIENT("R0");
//   %symbol_1 = @DEFINE-SYMBOL(box=[-0.1, -2.8, 3.8, 2.8]) {
//     @LINE {(2, 1.5) (4, 1.5) (4, 3)};
//     @LINE {(2, -1.5) (2, 1.5)};
//     @LINE {(3, -1) (4, -1.5) (3, -2)};
//     @LINE {(0, 0) (1.5, 0)};
//     @LINE {(1.5, 1.5) (1.5, -1.5)};
//     @LINE {(2, -1.5) (4, -1.5) (4, -3)};
//     ? @TEXT("${name}", size=0.8, halign="start", valign="baseline", key="name") => @PLACE(5, 3.5);
//     ? @TEXT("${model}", size=0.8, halign="end", valign="baseline", key="model") => @PLACE(3.2, 3.2);
//     (4, -1) @PIN(terminal=4);
//     (4, -3) @PIN(terminal=3);
//     (4, 3) @PIN(terminal=1);
//     (0, 0) @PIN(terminal=2)
//   };
//   #"M3" @SET-SYMBOL %symbol_1;
//   #"M3" @PLACE(53, 1) => @ORIENT("R270");
//   #"M22" @SET-SYMBOL %symbol_1;
//   #"M22" @PLACE(-16, -3) => @ORIENT("R0");
//   #"M0" @SET-SYMBOL %symbol_1;
//   #"M0" @PLACE(72, -6) => @ORIENT("R0");
//   #"M2" @SET-SYMBOL %symbol_0;
//   #"M2" @PLACE(53, -13) => @ORIENT("MXR90");
//   #"M4" @SET-SYMBOL %symbol_0;
//   #"M4" @PLACE(48, 18) => @ORIENT("MXR90");
//   %symbol_2 = @DEFINE-SYMBOL(box=[11, -2, 21, 10]) {
//     (19.5, 1) @CIRCLE(radius=0.5);
//     @LINE {(13, 2) (14, 1) (13, 0)};
//     @LINE {(19, 6) (21, 6)};
//     @LINE {(16, -1) (16, -2)};
//     @RECTANGLE {(13, -1) (19, 9)};
//     @LINE {(11, 6) (13, 6)};
//     @LINE {(16, 10) (16, 9)};
//     @LINE {(11, 1) (13, 1)};
//     @LINE {(20, 1) (21, 1)};
//     ? @TEXT("${model}", size=0.4, halign="end", valign="baseline", key="model") => @PLACE(21, -2);
//     ? @TEXT("${name}", size=0.4, halign="end", valign="top", key="name") => @PLACE(21, 10);
//     (16, -2) @PIN(terminal=6);
//     (16.5, -2) @TEXT("VSS", size=0.4, halign="start", valign="middle");
//     (16, 10) @PIN(terminal=5);
//     (16.9, 10) @TEXT("VDD", size=0.4, halign="start", valign="middle");
//     (21, 6) @PIN(terminal=3);
//     (18.6, 6) @TEXT("Q", size=0.4, halign="end", valign="middle");
//     (21, 1) @PIN(terminal=4);
//     (18.6, 1) @TEXT("QN", size=0.4, halign="end", valign="middle");
//     (11, 6) @PIN(terminal=1);
//     (13.4, 6) @TEXT("D", size=0.4, halign="start", valign="middle");
//     (11, 1) @PIN(terminal=2);
//     (14.4, 1) @TEXT("CP", size=0.4, halign="start", valign="middle")
//   };
//   #"I21" @SET-SYMBOL %symbol_2;
//   #"I21" @PLACE(-28, 18) => @ORIENT("R0");
//   #"M7" @SET-SYMBOL %symbol_1;
//   #"M7" @PLACE(53, 18) => @ORIENT("R0");
//   %symbol_3 = @DEFINE-SYMBOL(box=[-8, -8, -1, -2]) {
//     @LINE {(-6, -3) (-6, -7)};
//     @LINE {(-8, -5) (-6, -5)};
//     @LINE {(-6, -3) (-3, -5)};
//     @LINE {(-6, -7) (-3, -5)};
//     @LINE {(-2, -5) (-1, -5)};
//     @LINE {(-5, -2) (-5, -3.7)};
//     @LINE {(-5, -8) (-5, -6.4)};
//     (-2.5, -5) @CIRCLE(radius=0.5);
//     ? @TEXT("${model}", size=0.4, halign="end", valign="baseline", key="model") => @PLACE(-1, -8);
//     ? @TEXT("${name}", size=0.4, halign="end", valign="top", key="name") => @PLACE(-1, -2);
//     (-5, -8) @PIN(terminal=4);
//     (-4.1, -8) @TEXT("VSS", size=0.4, halign="start", valign="middle");
//     (-5, -2) @PIN(terminal=3);
//     (-4.1, -2) @TEXT("VDD", size=0.4, halign="start", valign="middle");
//     (-1, -5) @PIN(terminal=2);
//     (-3.4, -5) @TEXT("ZN", size=0.4, halign="end", valign="middle");
//     (-8, -5) @PIN(terminal=1);
//     (-5.8, -5) @TEXT("I", size=0.4, halign="start", valign="middle")
//   };
//   #"I15" @SET-SYMBOL %symbol_3;
//   #"I15" @PLACE(71, 30) => @ORIENT("R0");
//   %symbol_4 = @DEFINE-SYMBOL(box=[-9, -3, 0, 5]) {
//     @LINE {(-6, 5) (-6, 3)};
//     @LINE {(-2, 1) (-1, 1)};
//     @LINE {(-6, -3) (-6, -1)};
//     @LINE {(-7, 3) (-7, -1)};
//     @LINE {(-7, 3) (-5, 3)};
//     @LINE {(-7, -1) (-5, -1)};
//     @ARC {(-5, -1) (-3, 1) (-5, 3)};
//     @LINE {(-9, 2) (-7, 2)};
//     @LINE {(-9, 0) (-7, 0)};
//     @LINE {(-1, 1) (0, 1)};
//     (-2.5, 1) @CIRCLE(radius=0.5);
//     ? @TEXT("${name}", size=0.4, halign="end", valign="top", key="name") => @PLACE(0, 5);
//     ? @TEXT("${model}", size=0.4, halign="end", valign="baseline", key="model") => @PLACE(0, -3);
//     (0, 1) @PIN(terminal=3);
//     (-3.4, 1) @TEXT("ZN", size=0.4, halign="end", valign="middle");
//     (-6, -3) @PIN(terminal=5);
//     (-5.1, -3) @TEXT("VSS", size=0.4, halign="start", valign="middle");
//     (-6, 5) @PIN(terminal=4);
//     (-5.1, 5) @TEXT("VDD", size=0.4, halign="start", valign="middle");
//     (-9, 2) @PIN(terminal=1);
//     (-6.6, 2) @TEXT("A1", size=0.4, halign="start", valign="middle");
//     (-9, 0) @PIN(terminal=2);
//     (-6.6, 0) @TEXT("A2", size=0.4, halign="start", valign="middle")
//   };
//   #"I20" @SET-SYMBOL %symbol_4;
//   #"I20" @PLACE(19, 24) => @ORIENT("R0");
//   #"M6" @SET-SYMBOL %symbol_1;
//   #"M6" @PLACE(62, -13) => @ORIENT("R0");
//   #"M5" @SET-SYMBOL %symbol_1;
//   #"M5" @PLACE(48, 32) => @ORIENT("R270");
//   #"I23" @SET-SYMBOL %symbol_3;
//   #"I23" @PLACE(32, 30) => @ORIENT("R0");
//   %symbol_5 = @DEFINE-SYMBOL(box=[1, 3, 3, 6]) {
//     @LINE {(2, 3) (2, 4)};
//     @LINE {(1, 5) (3, 5)};
//     @LINE {(2, 6) (2, 5)};
//     @LINE {(1, 4) (3, 4)};
//     ? @TEXT("${name}", size=0.4, halign="end", valign="top", key="name") => @PLACE(3, 6);
//     ? @TEXT("${model}", size=0.4, halign="end", valign="baseline", key="model") => @PLACE(3, 3);
//     (2, 6) @PIN(terminal=1);
//     (2.9, 6) @TEXT("VDD", size=0.4, halign="start", valign="middle");
//     (2, 3) @PIN(terminal=2);
//     (2.9, 3) @TEXT("VSS", size=0.4, halign="start", valign="middle")
//   };
//   #"I22" @SET-SYMBOL %symbol_5;
//   #"I22" @PLACE(6, -8) => @ORIENT("R0");
//   %port_0 = $IO_PORT @ATTACH &"GND" => @PLACE(-30, 26) => @ORIENT("R0");
//   %input_port_symbol = @DEFINE-SYMBOL(box=[-2, -1, 0, 1]) {
//       @LINE(fill="linecolor", linestyle="none") {(-2, -0.9) (-2, 0.9) (-0.9, 0.9) (0, 0) (-0.9, -0.9) (-2, -0.9)};
//       (0, 0) @PIN(terminal=1, direction="right");
//       ? @TEXT("${name}", key="name", halign="middle") => @PLACE(-1, 1.6)
//     };
//   %port_1 = $IO_PORT @ATTACH &"SDI" => @PLACE(-29, 22) => @ORIENT("R0");
//   %port_1 @SET-SYMBOL %input_port_symbol;
//   %port_1 @TEXT("SDI", key="name");
//   %output_port_symbol = @DEFINE-SYMBOL(box=[0, -1, 2, 1]) {
//       @LINE(fill="linecolor", linestyle="none") {(0, -0.9) (0, 0.9) (1.1, 0.9) (2, 0) (1.1, -0.9) (0, -0.9)};
//       (0, 0) @PIN(terminal=1, direction="left");
//       ? @TEXT("${name}", key="name", halign="middle") => @PLACE(1, 1.6)
//     };
//   %port_2 = $IO_PORT @ATTACH &"SDO" => @PLACE(-31, 14) => @ORIENT("R0");
//   %port_2 @SET-SYMBOL %output_port_symbol;
//   %port_2 @TEXT("SDO", key="name");
//   %port_3 = $IO_PORT @ATTACH &"ROW" => @PLACE(-29, 6) => @ORIENT("R0");
//   %port_3 @SET-SYMBOL %input_port_symbol;
//   %port_3 @TEXT("ROW", key="name");
//   %port_4 = $IO_PORT @ATTACH &"BUS" => @PLACE(-30, -6) => @ORIENT("R0");
//   %port_5 = $IO_PORT @ATTACH &"COL" => @PLACE(-30, 2) => @ORIENT("R0");
//   %port_6 = $IO_PORT @ATTACH &"SCK" => @PLACE(-29, 18) => @ORIENT("R0");
//   %port_6 @SET-SYMBOL %input_port_symbol;
//   %port_6 @TEXT("SCK", key="name");
//   %port_7 = $IO_PORT @ATTACH &"PRE" => @PLACE(-29, 10) => @ORIENT("R0");
//   %port_7 @SET-SYMBOL %input_port_symbol;
//   %port_7 @TEXT("PRE", key="name");
//   %port_8 = $IO_PORT @ATTACH &"REP" => @PLACE(-29, -2) => @ORIENT("R0");
//   %port_8 @SET-SYMBOL %input_port_symbol;
//   %port_8 @TEXT("REP", key="name");
//   %port_9 = $IO_PORT @ATTACH &"VDD" => @PLACE(-30, 30) => @ORIENT("R0");
//   %p0 = (66, -6);
//   %wire_0 = &"net1" @WIRE(mode="straight") {#"M6":1 %p0};
//   %p1 = (56, -6);
//   %wire_1 = &"net1" @WIRE(mode="straight") {%p1 #"M3":1};
//   %wire_2 = &"net1" @WIRE(mode="straight") {%p0 #"M0":2};
//   %wire_3 = &"net1" @WIRE(mode="straight") {%p1 %p0};
//   %wire_4 = &"net1" @WIRE(mode="straight") {#"M2":3 %p1};
//   %p2 = (21, 18);
//   %wire_5 = &"net2" @WIRE(mode="straight") {%p2 #"M4":2};
//   %p3 = (21, 25);
//   %wire_6 = &"net2" @WIRE(mode="straight") {#"I20":3 %p3};
//   %wire_7 = &"net2" @WIRE(mode="straight") {%p2 %p3};
//   %wire_8 = &"net2" @WIRE(mode="straight") {#"M4":2 #"M7":2};
//   %wire_9 = &"net2" @WIRE(mode="straight") {%p3 #"I23":1};
//   %p4 = (6, 26);
//   %wire_10 = &"PRE" @WIRE(mode="straight") {%p4 #"I20":1};
//   %wire_10 @TEXT("PRE", size=1, halign="middle", valign="baseline") => @PLACE(7, 26.7);
//   %p5 = (34, 32);
//   %wire_11 = &"net3" @WIRE(mode="straight") {%p5 #"M5":2};
//   %p6 = (34, 25);
//   %wire_12 = &"net3" @WIRE(mode="straight") {%p6 %p5};
//   %wire_13 = &"net3" @WIRE(mode="straight") {#"I23":2 %p6};
//   %p7 = (57, 25);
//   %wire_14 = &"net4" @WIRE(mode="straight") {%p7 #"I15":1};
//   %wire_15 = &"net4" @WIRE(mode="straight") {#"M7":1 %p7};
//   %p8 = (51, 25);
//   %wire_16 = &"net4" @WIRE(mode="straight") {%p8 #"M5":1};
//   %wire_17 = &"net4" @WIRE(mode="straight") {%p8 %p7};
//   %wire_18 = &"net4" @WIRE(mode="straight") {#"M4":3 %p8};
//   %wire_19 = &"net5" @WIRE(mode="straight") {#"I15":2 #"M1":2};
//   %p9 = (-22, -3);
//   %wire_20 = &"REP" @WIRE(mode="straight") {%p9 #"M22":2};
//   %wire_20 @TEXT("REP", size=1, halign="middle", valign="baseline") => @PLACE(-20, -2.3);
//   %p10 = (-12, 4);
//   %wire_21 = &"BUS" @WIRE(mode="straight") {#"M22":1 %p10};
//   %wire_21 @TEXT("BUS", size=1, halign="middle", valign="baseline", rotate=90) => @PLACE(-12.7, 2);
//   %p11 = (8, 2);
//   %wire_22 = &"VDD" @WIRE(mode="straight") {#"I22":1 %p11};
//   %p12 = (76, 36);
//   %wire_23 = &"VDD" @WIRE(mode="straight") {#"M1":3 %p12};
//   %p13 = (27, 36);
//   %p14 = (66, 36);
//   %wire_24 = &"VDD" @WIRE(mode="straight") {%p13 %p14};
//   %p15 = (54, -6);
//   %wire_25 = &"VDD" @WIRE(mode="straight") {#"M2":4 %p15};
//   %p16 = (78, 28);
//   %wire_26 = &"VDD" @WIRE(mode="straight") {#"M1":3 %p16};
//   %p17 = (13, 36);
//   %wire_27 = &"VDD" @WIRE(mode="straight") {%p17 %p13};
//   %wire_28 = &"VDD" @WIRE(mode="straight") {#"I20":4 %p17};
//   %wire_29 = &"VDD" @WIRE(mode="straight") {#"I23":3 %p13};
//   %wire_30 = &"VDD" @WIRE(mode="straight") {%p14 %p12};
//   %p18 = (-12, 32);
//   %wire_31 = &"VDD" @WIRE(mode="straight") {#"I21":5 %p18};
//   %p19 = (78, 26);
//   %wire_32 = &"VDD" @WIRE(mode="straight") {%p19 %p16};
//   %wire_33 = &"VDD" @WIRE(mode="straight") {#"I15":3 %p14};
//   %p20 = (49, 25);
//   %wire_34 = &"VDD" @WIRE(mode="straight") {#"M4":4 %p20};
//   %wire_35 = &"VDD" @WIRE(mode="straight") {#"M1":4 %p19};
//   %wire_31 @TEXT("VDD", size=1, halign="middle", valign="baseline", rotate=90) => @PLACE(-12.7, 32);
//   %wire_34 @TEXT("VDD", size=1, halign="middle", valign="top", rotate=90) => @PLACE(49.7, 23);
//   %wire_24 @TEXT("VDD", size=1, halign="middle", valign="baseline") => @PLACE(33, 36.7);
//   %wire_25 @TEXT("VDD", size=1, halign="middle", valign="top", rotate=90) => @PLACE(54.7, -8);
//   %wire_22 @TEXT("VDD", size=1, halign="middle", valign="baseline", rotate=90) => @PLACE(7.3, 0);
//   %p21 = (-22, 19);
//   %wire_36 = &"SCK" @WIRE(mode="straight") {%p21 #"I21":2};
//   %wire_36 @TEXT("SCK", size=1, halign="middle", valign="baseline") => @PLACE(-20, 19.7);
//   %p22 = (40, -6);
//   %p23 = (40, 25);
//   %wire_37 = &"COL" @WIRE(mode="straight") {%p22 %p23};
//   %p24 = (50, -6);
//   %wire_38 = &"COL" @WIRE(mode="straight") {%p22 %p24};
//   %p25 = (45, 25);
//   %wire_39 = &"COL" @WIRE(mode="straight") {%p25 #"M5":3};
//   %wire_40 = &"COL" @WIRE(mode="straight") {%p23 %p25};
//   %p26 = (30, -6);
//   %wire_41 = &"COL" @WIRE(mode="straight") {%p26 %p22};
//   %wire_42 = &"COL" @WIRE(mode="straight") {#"M4":1 %p25};
//   %wire_43 = &"COL" @WIRE(mode="straight") {#"M2":1 %p24};
//   %wire_44 = &"COL" @WIRE(mode="straight") {%p24 #"M3":3};
//   %wire_41 @TEXT("COL", size=1, halign="middle", valign="baseline") => @PLACE(32, -5.3);
//   %wire_45 = &"SDB" @WIRE(mode="straight") {#"M2":2 #"M6":2};
//   %p27 = (0, 19);
//   %wire_46 = &"SDB" @WIRE(mode="straight") {#"I21":4 %p27};
//   %p28 = (45, -13);
//   %wire_47 = &"SDB" @WIRE(mode="straight") {%p28 #"M2":2};
//   %p29 = (6, 24);
//   %wire_48 = &"SDB" @WIRE(mode="straight") {%p29 #"I20":2};
//   %wire_48 @TEXT("SDB", size=1, halign="middle", valign="baseline") => @PLACE(7, 24.7);
//   %wire_46 @TEXT("SDB", size=1, halign="middle", valign="baseline") => @PLACE(-3, 19.7);
//   %wire_47 @TEXT("SDB", size=1, halign="middle", valign="baseline") => @PLACE(47, -12.3);
//   %p30 = (76, 9);
//   %p31 = (87, 9);
//   %wire_49 = &"ROW" @WIRE(mode="straight") {%p30 %p31};
//   %wire_50 = &"ROW" @WIRE(mode="straight") {#"M0":1 %p30};
//   %wire_51 = &"ROW" @WIRE(mode="straight") {%p30 #"M1":1};
//   %wire_49 @TEXT("ROW", size=1, halign="middle", valign="baseline") => @PLACE(82, 9.7);
//   %p32 = (-12, -11);
//   %wire_52 = &"SDO" @WIRE(mode="straight") {%p32 #"M22":3};
//   %p33 = (0, 24);
//   %wire_53 = &"SDO" @WIRE(mode="straight") {#"I21":3 %p33};
//   %p34 = (45, 1);
//   %wire_54 = &"SDO" @WIRE(mode="straight") {%p34 #"M3":2};
//   %wire_54 @TEXT("SDO", size=1, halign="middle", valign="baseline") => @PLACE(46.7, 1.7);
//   %wire_53 @TEXT("SDO", size=1, halign="middle", valign="baseline") => @PLACE(-3, 24.7);
//   %wire_52 @TEXT("SDO", size=1, halign="middle", valign="baseline", rotate=90) => @PLACE(-12.7, -9);
//   %p35 = (-22, 24);
//   %wire_55 = &"SDI" @WIRE(mode="straight") {%p35 #"I21":1};
//   %wire_55 @TEXT("SDI", size=1, halign="middle", valign="baseline") => @PLACE(-20, 24.7);
//   %p36 = (-8, -4);
//   %wire_56 = &"GND" @WIRE(mode="straight") {#"M22":4 %p36};
//   %p37 = (8, -9);
//   %wire_57 = &"GND" @WIRE(mode="straight") {%p37 #"I22":2};
//   %p38 = (57, 14);
//   %wire_58 = &"GND" @WIRE(mode="straight") {%p38 #"M7":3};
//   %p39 = (78, -7);
//   %wire_59 = &"GND" @WIRE(mode="straight") {#"M0":4 %p39};
//   %p40 = (68, -16);
//   %wire_60 = &"GND" @WIRE(mode="straight") {#"M6":3 %p40};
//   %p41 = (68, -14);
//   %wire_61 = &"GND" @WIRE(mode="straight") {%p40 %p41};
//   %wire_62 = &"GND" @WIRE(mode="straight") {#"M6":4 %p41};
//   %p42 = (66, -19);
//   %p43 = (76, -19);
//   %wire_63 = &"GND" @WIRE(mode="straight") {%p42 %p43};
//   %p44 = (78, -9);
//   %wire_64 = &"GND" @WIRE(mode="straight") {#"M0":3 %p44};
//   %wire_65 = &"GND" @WIRE(mode="straight") {%p42 #"M6":3};
//   %p45 = (13, 14);
//   %p46 = (27, 14);
//   %wire_66 = &"GND" @WIRE(mode="straight") {%p45 %p46};
//   %p47 = (59, 15);
//   %p48 = (59, 17);
//   %wire_67 = &"GND" @WIRE(mode="straight") {%p47 %p48};
//   %wire_68 = &"GND" @WIRE(mode="straight") {%p45 #"I20":5};
//   %p49 = (-12, 12);
//   %wire_69 = &"GND" @WIRE(mode="straight") {%p49 #"I21":6};
//   %p50 = (52, -7);
//   %wire_70 = &"GND" @WIRE(mode="straight") {#"M3":4 %p50};
//   %wire_71 = &"GND" @WIRE(mode="straight") {%p43 #"M0":3};
//   %wire_72 = &"GND" @WIRE(mode="straight") {%p46 %p38};
//   %p51 = (47, 24);
//   %wire_73 = &"GND" @WIRE(mode="straight") {#"M5":4 %p51};
//   %wire_74 = &"GND" @WIRE(mode="straight") {#"M7":4 %p48};
//   %wire_75 = &"GND" @WIRE(mode="straight") {%p46 #"I23":4};
//   %p52 = (66, 14);
//   %wire_76 = &"GND" @WIRE(mode="straight") {%p52 #"I15":4};
//   %wire_77 = &"GND" @WIRE(mode="straight") {%p44 %p39};
//   %wire_78 = &"GND" @WIRE(mode="straight") {%p38 %p52};
//   %wire_79 = &"GND" @WIRE(mode="straight") {#"M7":3 %p47};
//   %wire_63 @TEXT("GND", size=1, halign="middle", valign="top") => @PLACE(71, -17);
//   %wire_66 @TEXT("GND", size=1, halign="middle", valign="top") => @PLACE(20, 16);
//   %wire_70 @TEXT("GND", size=1, halign="middle", valign="top", rotate=90) => @PLACE(52.7, -5);
//   %wire_69 @TEXT("GND", size=1, halign="middle", valign="baseline", rotate=90) => @PLACE(-12.7, 14);
//   %wire_73 @TEXT("GND", size=1, halign="middle", valign="top", rotate=90) => @PLACE(47.7, 26);
//   %wire_56 @TEXT("GND", size=1, halign="middle", valign="baseline") => @PLACE(-10, -3.3);
//   %wire_57 @TEXT("GND", size=1, halign="middle", valign="baseline", rotate=90) => @PLACE(7.3, -7);
//   $JUNCTION @ATTACH %p0;
//   $JUNCTION @ATTACH %p1;
//   $JUNCTION @ATTACH %p3;
//   $JUNCTION @ATTACH %p7;
//   $JUNCTION @ATTACH %p8;
//   $JUNCTION @ATTACH %p13;
//   $JUNCTION @ATTACH %p14;
//   $JUNCTION @ATTACH %p22;
//   $JUNCTION @ATTACH %p24;
//   $JUNCTION @ATTACH %p25;
//   $JUNCTION @ATTACH %p30;
//   $JUNCTION @ATTACH %p38;
//   $JUNCTION @ATTACH %p46
// }
// @RNL(author="gemini-4-argon") {
//   @USE-PACKAGE(name="risca-semantics", version="0.3", path="risca_semantics.rnl");
//   /* LB_crossbar_cell: 1-Bit SPI-Programmed Dynamic Crossbar Switch Cell for 16x24 Clock Matrix */
//   #"I21"(cfg_dff) {#"M2" #"M3" #"M6" #"M0"}(active_pulldown_path) {#"I20" #"I23" #"M4" #"M5" #"M7" #"I15" #"M1"}(precharge_pullup_path) #"M22"(rep_eval_nmos) @AS(role="1bit_SPI_dynamic_crossbar_switch_cell") $SPI_CROSSBAR_CELL;
//   #"M2"(pmos_pass) #"M3"(nmos_pass) @AS(role="active_col_to_row_pulldown_trangate", width="300nm") $CMOS_TRANGATE;
//   #"M4"(pmos_pass) #"M5"(nmos_pass) @AS(role="precharge_col_to_row_pullup_trangate", width="300nm") $CMOS_TRANGATE;
//   #"I22"(caps) @AS(role="local_cell_supply_decap", substrate_tap="DCAP4_stdcell") $MOM_DECAP;
//   {#"M2" #"M3" #"M4" #"M5"}(members) @AS $MATCHED;
//   {#"I21" #"M3" #"M0"}(path) @AS(direction="left-to-right") $FLOW;
//   {#"M5" #"M4"}(members) @AS $BRANCH;
//   {#"M7" #"M3" #"M2"}(members) @AS $BRANCH;
//   {#"M1" #"M0"}(members) @AS $BRANCH;
//   /* Note Box & Author Header (Placed in Empty Region Above Schematic) */
//   (-56, 111.07) @TEXT("Comment by Gemini-4-Argon", size=2.8) => @SET-STYLE $risca_author_style;
//   @RECTANGLE {(-56, 77.03) (159.88, 108.23)} => @SET-STYLE $risca_note_box;
//   (-52, 101.25) @TEXT("LB_crossbar_cell: 1-Bit SPI-Configured Dynamic Crossbar Switch Cell (384 Instantiated per Channel in L3_clk_mux_V1)", size=3) => @SET-STYLE $risca_title_style;
//   (-52, 96.25) @TEXT("1. SPI Shift Bit (I21 DFD1): Stores programming bit SDO (and complement SDB) shifted along SDI->SDO on SCK.", size=2.5) => @SET-STYLE $risca_digital_style;
//   (-52, 91.25) @TEXT("2. Active Path (SDO=1, SDB=0): TG (M2+M3) passes COL to net1, enabling NMOS M0 to pull ROW low when COL=1.", size=2.5) => @SET-STYLE $risca_digital_style;
//   (-52, 86.25) @TEXT("3. Precharge Path (SDO=0, SDB=1, PRE=1): I20+I23 enable TG (M4+M5), passing COL through I15 (INVD0) to PMOS M1 to pull ROW high.", size=2.5) => @SET-STYLE $risca_digital_style;
//   (-52, 81.25) @TEXT("4. Repetition Bus Evaluation (M22): Pulls BUS toward SDO when gated by repetition strobe REP.", size=2.5) => @SET-STYLE $risca_digital_style
// }
ends LB_crossbar_cell
