// RNL cell RISCA_JL/LB_vcmbooster
// @RNL(type="header") {
//   @VERSION("0.3");
//   @USE-PACKAGE(name="eda-symbol", version="0.1", path="eda-symbol.rnl");
//   @USE-PACKAGE(name="eda-style", version="0.1", path="eda-style.rnl")
// }
subckt LB_vcmbooster AVDD AVSS CLK SAM TUNE_3 TUNE_2 TUNE_1 TUNE_0 VBTSTP
    C0 (net3 net2) cfmom_2t nr=96 lr=3u w=50n s=50n stm=2 spm=7 multi=1
    M20 (net7 net9 net12 AVDD) pch_mac l=30n w=250.0n multi=1 nf=1 sd=100n \
        ad=1.875e-14 as=1.875e-14 pd=650.0n ps=650.0n nrd=0.777777 \
        nrs=0.777777 sa=75.0n sb=75.0n sa1=75.0n sa2=75.0n sa3=75.0n \
        sa4=75.0n sb1=75.0n sb2=75.0n sb3=75.0n spa=100n spa1=100n \
        spa2=100n spa3=100n sap=91.9776n sapb=114.444n spba=115.715n \
        spba1=117.043n dfm_flag=0 spmt=1.11111e+15 spomt=0 \
        spomt1=1.11111e+60 spmb=1.11111e+15 spomb=0 spomb1=1.11111e+60
    M19 (net12 net9 net13 AVDD) pch_mac l=30n w=250.0n multi=1 nf=1 \
        sd=100n ad=1.875e-14 as=1.875e-14 pd=650.0n ps=650.0n nrd=0.777777 \
        nrs=0.777777 sa=75.0n sb=75.0n sa1=75.0n sa2=75.0n sa3=75.0n \
        sa4=75.0n sb1=75.0n sb2=75.0n sb3=75.0n spa=100n spa1=100n \
        spa2=100n spa3=100n sap=91.9776n sapb=114.444n spba=115.715n \
        spba1=117.043n dfm_flag=0 spmt=1.11111e+15 spomt=0 \
        spomt1=1.11111e+60 spmb=1.11111e+15 spomb=0 spomb1=1.11111e+60
    M18 (net11 net9 AVDD AVDD) pch_mac l=30n w=250.0n multi=1 nf=1 sd=100n \
        ad=1.875e-14 as=1.875e-14 pd=650.0n ps=650.0n nrd=0.777777 \
        nrs=0.777777 sa=75.0n sb=75.0n sa1=75.0n sa2=75.0n sa3=75.0n \
        sa4=75.0n sb1=75.0n sb2=75.0n sb3=75.0n spa=100n spa1=100n \
        spa2=100n spa3=100n sap=91.9776n sapb=114.444n spba=115.715n \
        spba1=117.043n dfm_flag=0 spmt=1.11111e+15 spomt=0 \
        spomt1=1.11111e+60 spmb=1.11111e+15 spomb=0 spomb1=1.11111e+60
    M17 (net13 net9 net11 AVDD) pch_mac l=30n w=250.0n multi=1 nf=1 \
        sd=100n ad=1.875e-14 as=1.875e-14 pd=650.0n ps=650.0n nrd=0.777777 \
        nrs=0.777777 sa=75.0n sb=75.0n sa1=75.0n sa2=75.0n sa3=75.0n \
        sa4=75.0n sb1=75.0n sb2=75.0n sb3=75.0n spa=100n spa1=100n \
        spa2=100n spa3=100n sap=91.9776n sapb=114.444n spba=115.715n \
        spba1=117.043n dfm_flag=0 spmt=1.11111e+15 spomt=0 \
        spomt1=1.11111e+60 spmb=1.11111e+15 spomb=0 spomb1=1.11111e+60
    M16 (net7 net8 net5 AVDD) pch_mac l=30n w=250.0n multi=1 nf=1 sd=100n \
        ad=1.875e-14 as=1.875e-14 pd=650.0n ps=650.0n nrd=0.777777 \
        nrs=0.777777 sa=75.0n sb=75.0n sa1=75.0n sa2=75.0n sa3=75.0n \
        sa4=75.0n sb1=75.0n sb2=75.0n sb3=75.0n spa=100n spa1=100n \
        spa2=100n spa3=100n sap=91.9776n sapb=114.444n spba=115.715n \
        spba1=117.043n dfm_flag=0 spmt=1.11111e+15 spomt=0 \
        spomt1=1.11111e+60 spmb=1.11111e+15 spomb=0 spomb1=1.11111e+60
    M15 (net5 net8 AVDD AVDD) pch_mac l=30n w=250.0n multi=1 nf=1 sd=100n \
        ad=1.875e-14 as=1.875e-14 pd=650.0n ps=650.0n nrd=0.777777 \
        nrs=0.777777 sa=75.0n sb=75.0n sa1=75.0n sa2=75.0n sa3=75.0n \
        sa4=75.0n sb1=75.0n sb2=75.0n sb3=75.0n spa=100n spa1=100n \
        spa2=100n spa3=100n sap=91.9776n sapb=114.444n spba=115.715n \
        spba1=117.043n dfm_flag=0 spmt=1.11111e+15 spomt=0 \
        spomt1=1.11111e+60 spmb=1.11111e+15 spomb=0 spomb1=1.11111e+60
    M14 (net7 net10 AVDD AVDD) pch_mac l=30n w=250.0n multi=1 nf=1 sd=100n \
        ad=1.875e-14 as=1.875e-14 pd=650.0n ps=650.0n nrd=0.777777 \
        nrs=0.777777 sa=75.0n sb=75.0n sa1=75.0n sa2=75.0n sa3=75.0n \
        sa4=75.0n sb1=75.0n sb2=75.0n sb3=75.0n spa=100n spa1=100n \
        spa2=100n spa3=100n sap=91.9776n sapb=114.444n spba=115.715n \
        spba1=117.043n dfm_flag=0 spmt=1.11111e+15 spomt=0 \
        spomt1=1.11111e+60 spmb=1.11111e+15 spomb=0 spomb1=1.11111e+60
    M9 (net7 AVSS AVDD AVDD) pch_mac l=30n w=500n multi=1 nf=1 sd=100n \
        ad=3.75e-14 as=3.75e-14 pd=1.15u ps=1.15u nrd=0.383209 \
        nrs=0.383209 sa=75.0n sb=75.0n sa1=75.0n sa2=75.0n sa3=75.0n \
        sa4=75.0n sb1=75.0n sb2=75.0n sb3=75.0n spa=100n spa1=100n \
        spa2=100n spa3=100n sap=91.9776n sapb=114.444n spba=115.715n \
        spba1=117.043n dfm_flag=0 spmt=1.11111e+15 spomt=0 \
        spomt1=1.11111e+60 spmb=1.11111e+15 spomb=0 spomb1=1.11111e+60
    M8 (net1 CLK net7 AVDD) pch_mac l=30n w=1u multi=1 nf=2 sd=100n \
        ad=5e-14 as=7.5e-14 pd=1.2u ps=2.3u nrd=0.212518 nrs=0.212518 \
        sa=112.742n sb=112.742n sa1=93.6047n sa2=112.078n sa3=163.715n \
        sa4=110.059n sb1=93.6047n sb2=112.078n sb3=163.715n spa=100n \
        spa1=100n spa2=100n spa3=100n sap=104.359n sapb=125.813n \
        spba=115.715n spba1=117.043n dfm_flag=0 spmt=1.11111e+15 spomt=0 \
        spomt1=1.11111e+60 spmb=1.11111e+15 spomb=0 spomb1=1.11111e+60
    M10 (net7 net6 AVDD AVDD) pch_mac l=30n w=500n multi=1 nf=1 sd=100n \
        ad=3.75e-14 as=3.75e-14 pd=1.15u ps=1.15u nrd=0.383209 \
        nrs=0.383209 sa=75.0n sb=75.0n sa1=75.0n sa2=75.0n sa3=75.0n \
        sa4=75.0n sb1=75.0n sb2=75.0n sb3=75.0n spa=100n spa1=100n \
        spa2=100n spa3=100n sap=91.9776n sapb=114.444n spba=115.715n \
        spba1=117.043n dfm_flag=0 spmt=1.11111e+15 spomt=0 \
        spomt1=1.11111e+60 spmb=1.11111e+15 spomb=0 spomb1=1.11111e+60
    M21 (net7 AVDD AVDD AVDD) pch_mac l=30n w=250.0n multi=1 nf=1 sd=100n \
        ad=1.875e-14 as=1.875e-14 pd=650.0n ps=650.0n nrd=0.777777 \
        nrs=0.777777 sa=75.0n sb=75.0n sa1=75.0n sa2=75.0n sa3=75.0n \
        sa4=75.0n sb1=75.0n sb2=75.0n sb3=75.0n spa=100n spa1=100n \
        spa2=100n spa3=100n sap=91.9776n sapb=114.444n spba=115.715n \
        spba1=117.043n dfm_flag=0 spmt=1.11111e+15 spomt=0 \
        spomt1=1.11111e+60 spmb=1.11111e+15 spomb=0 spomb1=1.11111e+60
    M5 (net1 SAM AVDD AVDD) pch_mac l=30n w=500n multi=1 nf=1 sd=100n \
        ad=3.75e-14 as=3.75e-14 pd=1.15u ps=1.15u nrd=0.383209 \
        nrs=0.383209 sa=75.0n sb=75.0n sa1=75.0n sa2=75.0n sa3=75.0n \
        sa4=75.0n sb1=75.0n sb2=75.0n sb3=75.0n spa=100n spa1=100n \
        spa2=100n spa3=100n sap=91.9776n sapb=114.444n spba=115.715n \
        spba1=117.043n dfm_flag=0 spmt=1.11111e+15 spomt=0 \
        spomt1=1.11111e+60 spmb=1.11111e+15 spomb=0 spomb1=1.11111e+60
    M4 (VBTSTP AVDD net3 net3) pch_ulvt_mac l=30n w=2u multi=1 nf=4 \
        sd=100n ad=1e-13 as=1.25e-13 pd=2.4u ps=3.5u nrd=0.112393 \
        nrs=0.112393 sa=179.203n sb=179.203n sa1=118.069n sa2=174.76n \
        sa3=310.76n sa4=171.966n sb1=118.069n sb2=174.76n sb3=310.76n \
        spa=100n spa1=100n spa2=100n spa3=100n sap=120.952n sapb=140.537n \
        spba=115.715n spba1=117.043n dfm_flag=0 spmt=1.11111e+15 spomt=0 \
        spomt1=1.11111e+60 spmb=1.11111e+15 spomb=0 spomb1=1.11111e+60
    M7 (AVDD VBTSTP net3 net3) pch_ehvt_mac l=30n w=1u multi=1 nf=2 \
        sd=100n ad=5e-14 as=7.5e-14 pd=1.2u ps=2.3u nrd=0.212518 \
        nrs=0.212518 sa=112.742n sb=112.742n sa1=93.6047n sa2=112.078n \
        sa3=163.715n sa4=110.059n sb1=93.6047n sb2=112.078n sb3=163.715n \
        spa=100n spa1=100n spa2=100n spa3=100n sap=104.359n sapb=125.813n \
        spba=115.715n spba1=117.043n dfm_flag=0 spmt=1.11111e+15 spomt=0 \
        spomt1=1.11111e+60 spmb=1.11111e+15 spomb=0 spomb1=1.11111e+60
    M0 (net2 net1 AVDD AVDD) pch_ehvt_mac l=30n w=2u multi=1 nf=4 sd=100n \
        ad=1e-13 as=1.25e-13 pd=2.4u ps=3.5u nrd=0.112393 nrs=0.112393 \
        sa=179.203n sb=179.203n sa1=118.069n sa2=174.76n sa3=310.76n \
        sa4=171.966n sb1=118.069n sb2=174.76n sb3=310.76n spa=100n \
        spa1=100n spa2=100n spa3=100n sap=120.952n sapb=140.537n \
        spba=115.715n spba1=117.043n dfm_flag=0 spmt=1.11111e+15 spomt=0 \
        spomt1=1.11111e+60 spmb=1.11111e+15 spomb=0 spomb1=1.11111e+60
    M2 (net1 CLK net4 AVSS) nch_mac l=30n w=500n multi=1 nf=1 sd=100n \
        ad=3.75e-14 as=3.75e-14 pd=1.15u ps=1.15u nrd=0.662935 \
        nrs=0.662935 sa=75.0n sb=75.0n sa1=75.0n sa2=75.0n sa3=75.0n \
        sa4=75.0n sb1=75.0n sb2=75.0n sb3=75.0n spa=100n spa1=100n \
        spa2=100n spa3=100n sap=91.9776n sapb=114.444n spba=115.715n \
        spba1=117.043n dfm_flag=0 spmt=1.11111e+15 spomt=0 \
        spomt1=1.11111e+60 spmb=1.11111e+15 spomb=0 spomb1=1.11111e+60
    M1 (net2 net1 AVSS AVSS) nch_mac l=30n w=4u multi=1 nf=8 sd=100n \
        ad=2e-13 as=2.25e-13 pd=4.8u ps=5.9u nrd=0.135370 nrs=0.135370 \
        sa=295.835n sb=295.835n sa1=149.315n sa2=274.565n sa3=507.343n \
        sa4=281.096n sb1=149.315n sb2=274.565n sb3=507.343n spa=100n \
        spa1=100n spa2=100n spa3=100n sap=142.36n sapb=158.808n \
        spba=115.715n spba1=117.043n dfm_flag=0 spmt=1.11111e+15 spomt=0 \
        spomt1=1.11111e+60 spmb=1.11111e+15 spomb=0 spomb1=1.11111e+60
    M11 (VBTSTP AVDD net2 AVSS) nch_mac l=30n w=4u multi=1 nf=8 sd=100n \
        ad=2e-13 as=2.25e-13 pd=4.8u ps=5.9u nrd=0.135370 nrs=0.135370 \
        sa=295.835n sb=295.835n sa1=149.315n sa2=274.565n sa3=507.343n \
        sa4=281.096n sb1=149.315n sb2=274.565n sb3=507.343n spa=100n \
        spa1=100n spa2=100n spa3=100n sap=142.36n sapb=158.808n \
        spba=115.715n spba1=117.043n dfm_flag=0 spmt=1.11111e+15 spomt=0 \
        spomt1=1.11111e+60 spmb=1.11111e+15 spomb=0 spomb1=1.11111e+60
    M3 (net4 SAM AVSS AVSS) nch_mac l=30n w=1u multi=1 nf=2 sd=100n \
        ad=5e-14 as=7.5e-14 pd=1.2u ps=2.3u nrd=0.425847 nrs=0.425847 \
        sa=112.742n sb=112.742n sa1=93.6047n sa2=112.078n sa3=163.715n \
        sa4=110.059n sb1=93.6047n sb2=112.078n sb3=163.715n spa=100n \
        spa1=100n spa2=100n spa3=100n sap=104.359n sapb=125.813n \
        spba=115.715n spba1=117.043n dfm_flag=0 spmt=1.11111e+15 spomt=0 \
        spomt1=1.11111e+60 spmb=1.11111e+15 spomb=0 spomb1=1.11111e+60
    I3 (TUNE_3 net9 AVDD AVSS) INVD2BWP12T30P140
    I2 (TUNE_2 net8 AVDD AVSS) INVD2BWP12T30P140
    I1 (TUNE_1 net10 AVDD AVSS) INVD2BWP12T30P140
    I0 (TUNE_0 net6 AVDD AVSS) INVD2BWP12T30P140
// @RNL(author="rnl-virtuoso") {
//   %block_symbol = @DEFINE-SYMBOL(box=[6, -10, 26, -2]) {
//     @LINE {(16.5, -5) (16.5, -7)};
//     @LINE {(15.5, -5) (15.5, -7)};
//     @LINE {(13, -6) (15.5, -6)};
//     @LINE {(6, -8) (12, -8)};
//     @LINE {(6, -4) (12, -4)};
//     @LINE {(26, -6) (20, -6)};
//     @LINE {(26, -4) (20, -4)};
//     @LINE {(26, -8) (20, -8)};
//     @LINE {(6, -6) (12, -6)};
//     @LINE {(18, -4.5) (17.5, -4.5)};
//     @LINE {(17, -4.5) (17.5, -4.5)};
//     @LINE {(16.5, -6) (19, -6)};
//     @LINE {(17.5, -4) (17.5, -5)};
//     @LINE {(14, -4.5) (15, -4.5)};
//     @LINE {(12, -2) (20, -2) (20, -10) (12, -10) (12, -2)};
//     ? @TEXT("${name}", size=1, halign="start", valign="middle", key="name") => @PLACE(22, -1);
//     ? @TEXT("${model}", size=1, halign="start", valign="middle", key="model") => @PLACE(11, -11);
//     (6, -6) @PIN(terminal="SAM");
//     (7.1, -5) @TEXT("SAM", size=1, halign="start", valign="middle");
//     (6, -4) @PIN(terminal="CLK");
//     (7.1, -3) @TEXT("CLK", size=1, halign="start", valign="middle");
//     (26, -8) @PIN(terminal="AVSS");
//     (25.4, -7) @TEXT("AVSS", size=1, halign="end", valign="middle");
//     (26, -4) @PIN(terminal="AVDD");
//     (25.4, -3) @TEXT("AVDD", size=1, halign="end", valign="middle");
//     (26, -6) @PIN(terminal="VBTSTP");
//     (25.4, -5) @TEXT("VBTSTP", size=1, halign="end", valign="middle");
//     (6, -8) @PIN(terminal=["TUNE_3", "TUNE_2", "TUNE_1", "TUNE_0"]);
//     (7.1, -7) @TEXT("TUNE<3:0>", size=1, halign="start", valign="middle")
//   };
//   # @SET-SYMBOL %block_symbol;
//   %symbol_0 = @DEFINE-SYMBOL(box=[-0.1, -2.8, 3.8, 2.8]) {
//     @LINE {(2, 1.5) (4, 1.5) (4, 3)};
//     @LINE {(2, -1.5) (2, 1.5)};
//     @LINE {(3, -1) (4, -1.5) (3, -2)};
//     @LINE {(0, 0) (1.5, 0)};
//     @LINE {(1.5, 1.5) (1.5, -1.5)};
//     @LINE {(2, -1.5) (4, -1.5) (4, -3)};
//     ? @TEXT("${name}", size=0.8, halign="start", valign="baseline", key="name") => @PLACE(5, 3.5);
//     ? @TEXT("${model}", size=0.8, halign="end", valign="baseline", key="model") => @PLACE(3.2, 3.2);
//     (4, -1) @PIN(terminal=4);
//     (4, -3) @PIN(terminal=3);
//     (4, 3) @PIN(terminal=1);
//     (0, 0) @PIN(terminal=2)
//   };
//   #"M1" @SET-SYMBOL %symbol_0;
//   #"M1" @PLACE(-4, -8) => @ORIENT("R0");
//   #"M3" @SET-SYMBOL %symbol_0;
//   #"M3" @PLACE(-22, -15) => @ORIENT("R0");
//   %symbol_1 = @DEFINE-SYMBOL(box=[-0.1, -2.8, 3.8, 2.8]) {
//     @LINE {(0, 0) (0.7, 0)};
//     @LINE {(1.5, 1.5) (1.5, -1.5)};
//     @LINE {(2, -1.5) (4, -1.5) (4, -3)};
//     @LINE {(2, 1.5) (4, 1.5) (4, 3)};
//     (1.1, 0) @CIRCLE(radius=0.4);
//     @LINE {(3.7, 2) (2.7, 1.5) (3.7, 1)};
//     @LINE {(2, -1.5) (2, 1.5)};
//     ? @TEXT("${name}", size=0.8, halign="start", valign="baseline", key="name") => @PLACE(4.9, 3.4);
//     ? @TEXT("${model}", size=0.8, halign="end", valign="baseline", key="model") => @PLACE(3.3, 3.2);
//     (4, 3) @PIN(terminal=3);
//     (4, 1) @PIN(terminal=4);
//     (0, 0) @PIN(terminal=2);
//     (4, -3) @PIN(terminal=1)
//   };
//   #"M21" @SET-SYMBOL %symbol_1;
//   #"M21" @PLACE(0, 27) => @ORIENT("MX");
//   #"M16" @SET-SYMBOL %symbol_1;
//   #"M16" @PLACE(8, 41) => @ORIENT("R0");
//   #"M10" @SET-SYMBOL %symbol_1;
//   #"M10" @PLACE(-12, 50) => @ORIENT("R0");
//   %symbol_2 = @DEFINE-SYMBOL(box=[-8, -8, -1, -2]) {
//     @LINE {(-6, -3) (-6, -7)};
//     @LINE {(-8, -5) (-6, -5)};
//     @LINE {(-6, -3) (-3, -5)};
//     @LINE {(-6, -7) (-3, -5)};
//     @LINE {(-2, -5) (-1, -5)};
//     @LINE {(-5, -2) (-5, -3.7)};
//     @LINE {(-5, -8) (-5, -6.4)};
//     (-2.5, -5) @CIRCLE(radius=0.5);
//     ? @TEXT("${model}", size=0.4, halign="end", valign="baseline", key="model") => @PLACE(-1, -8);
//     ? @TEXT("${name}", size=0.4, halign="end", valign="top", key="name") => @PLACE(-1, -2);
//     (-5, -8) @PIN(terminal=4);
//     (-4.1, -8) @TEXT("VSS", size=0.4, halign="start", valign="middle");
//     (-5, -2) @PIN(terminal=3);
//     (-4.1, -2) @TEXT("VDD", size=0.4, halign="start", valign="middle");
//     (-1, -5) @PIN(terminal=2);
//     (-3.4, -5) @TEXT("ZN", size=0.4, halign="end", valign="middle");
//     (-8, -5) @PIN(terminal=1);
//     (-5.8, -5) @TEXT("I", size=0.4, halign="start", valign="middle")
//   };
//   #"I3" @SET-SYMBOL %symbol_2;
//   #"I3" @PLACE(-15, 98) => @ORIENT("R0");
//   %symbol_3 = @DEFINE-SYMBOL(box=[-2, -6, 2, 0]) {
//     @LINE {(1, -2.2) (-1, -2.2)};
//     @LINE {(0, 0) (0, -2.2)};
//     @LINE {(0, -2.8) (0, -6)};
//     @ARC {(1, -3.2) (0, -2.8) (-1, -3.2)};
//     ? @TEXT("${name}", size=0.8, halign="start", valign="baseline", key="name") => @PLACE(1.4, 0.1);
//     ? @TEXT("${model}", size=0.8, halign="end", valign="baseline", key="model") => @PLACE(-1.1, 0.3);
//     (0, 0) @PIN(terminal=1);
//     (0, -6) @PIN(terminal=2)
//   };
//   #"C0" @SET-SYMBOL %symbol_3;
//   #"C0" @PLACE(43, 19) => @ORIENT("R0");
//   %symbol_4 = @DEFINE-SYMBOL(box=[-0.1, -2.8, 3.8, 2.8]) {
//     @LINE {(0, 0) (0.7, 0)};
//     @LINE {(1.5, 1.5) (1.5, -1.5)};
//     @LINE {(2, -1.5) (4, -1.5) (4, -3)};
//     @LINE {(2, 1.5) (4, 1.5) (4, 3)};
//     (1.1, 0) @CIRCLE(radius=0.4);
//     @LINE {(3.7, 2) (2.7, 1.5) (3.7, 1)};
//     @LINE {(2, -1.5) (2, 1.5)};
//     ? @TEXT("${name}", size=0.8, halign="start", valign="baseline", key="name") => @PLACE(4.9, 3.4);
//     ? @TEXT("${model}", size=0.8, halign="end", valign="baseline", key="model") => @PLACE(3.3, 3.2);
//     (4, 3) @PIN(terminal=3);
//     (4, 1) @PIN(terminal=4);
//     (0, 0) @PIN(terminal=2);
//     (4, -3) @PIN(terminal=1)
//   };
//   #"M0" @SET-SYMBOL %symbol_4;
//   #"M0" @PLACE(-4, 8) => @ORIENT("R0");
//   #"M2" @SET-SYMBOL %symbol_0;
//   #"M2" @PLACE(-22, -7) => @ORIENT("R0");
//   %symbol_5 = @DEFINE-SYMBOL(box=[-0.1, -2.8, 3.8, 2.8]) {
//     @LINE {(0, 0) (0.7, 0)};
//     @LINE {(1.5, 1.5) (1.5, -1.5)};
//     @LINE {(2, -1.5) (4, -1.5) (4, -3)};
//     @LINE {(2, 1.5) (4, 1.5) (4, 3)};
//     (1.1, 0) @CIRCLE(radius=0.4);
//     @LINE {(3.7, 2) (2.7, 1.5) (3.7, 1)};
//     @LINE {(2, -1.5) (2, 1.5)};
//     ? @TEXT("${name}", size=0.8, halign="start", valign="baseline", key="name") => @PLACE(4.9, 3.4);
//     ? @TEXT("${model}", size=0.8, halign="end", valign="baseline", key="model") => @PLACE(3.3, 3.2);
//     (4, 3) @PIN(terminal=3);
//     (4, 1) @PIN(terminal=4);
//     (0, 0) @PIN(terminal=2);
//     (4, -3) @PIN(terminal=1)
//   };
//   #"M4" @SET-SYMBOL %symbol_5;
//   #"M4" @PLACE(59, 28) => @ORIENT("R90");
//   #"M9" @SET-SYMBOL %symbol_1;
//   #"M9" @PLACE(-22, 50) => @ORIENT("R0");
//   #"M19" @SET-SYMBOL %symbol_1;
//   #"M19" @PLACE(18, 32) => @ORIENT("R0");
//   #"M18" @SET-SYMBOL %symbol_1;
//   #"M18" @PLACE(18, 50) => @ORIENT("R0");
//   #"M7" @SET-SYMBOL %symbol_4;
//   #"M7" @PLACE(47, 40) => @ORIENT("R180");
//   #"I0" @SET-SYMBOL %symbol_2;
//   #"I0" @PLACE(-15, 68) => @ORIENT("R0");
//   #"I1" @SET-SYMBOL %symbol_2;
//   #"I1" @PLACE(-15, 78) => @ORIENT("R0");
//   #"M11" @SET-SYMBOL %symbol_0;
//   #"M11" @PLACE(59, 4) => @ORIENT("R270");
//   #"M17" @SET-SYMBOL %symbol_1;
//   #"M17" @PLACE(18, 41) => @ORIENT("R0");
//   #"M8" @SET-SYMBOL %symbol_1;
//   #"M8" @PLACE(-16, 8) => @ORIENT("R0");
//   #"I2" @SET-SYMBOL %symbol_2;
//   #"I2" @PLACE(-15, 88) => @ORIENT("R0");
//   #"M5" @SET-SYMBOL %symbol_1;
//   #"M5" @PLACE(-28, 8) => @ORIENT("R0");
//   #"M14" @SET-SYMBOL %symbol_1;
//   #"M14" @PLACE(-2, 50) => @ORIENT("R0");
//   #"M15" @SET-SYMBOL %symbol_1;
//   #"M15" @PLACE(8, 50) => @ORIENT("R0");
//   #"M20" @SET-SYMBOL %symbol_1;
//   #"M20" @PLACE(18, 23) => @ORIENT("R0");
//   %port_0 = $IO_PORT @ATTACH &"AVDD" => @PLACE(-38, 60) => @ORIENT("R0");
//   %input_port_symbol = @DEFINE-SYMBOL(box=[-2, -1, 0, 1]) {
//       @LINE(fill="linecolor", linestyle="none") {(-2, -0.9) (-2, 0.9) (-0.9, 0.9) (0, 0) (-0.9, -0.9) (-2, -0.9)};
//       (0, 0) @PIN(terminal=1, direction="right");
//       ? @TEXT("${name}", key="name", halign="middle") => @PLACE(-1, 1.6)
//     };
//   %port_1 = $IO_PORT @ATTACH &"SAM" => @PLACE(-38, -15) => @ORIENT("R0");
//   %port_1 @SET-SYMBOL %input_port_symbol;
//   %port_1 @TEXT("SAM", key="name");
//   %port_2 = $IO_PORT @ATTACH &"CLK" => @PLACE(-38, -7) => @ORIENT("R0");
//   %port_2 @SET-SYMBOL %input_port_symbol;
//   %port_2 @TEXT("CLK", key="name");
//   %port_3 = $IO_PORT @ATTACH &"AVSS" => @PLACE(-38, 56) => @ORIENT("R0");
//   %output_port_symbol = @DEFINE-SYMBOL(box=[0, -1, 2, 1]) {
//       @LINE(fill="linecolor", linestyle="none") {(0, -0.9) (0, 0.9) (1.1, 0.9) (2, 0) (1.1, -0.9) (0, -0.9)};
//       (0, 0) @PIN(terminal=1, direction="left");
//       ? @TEXT("${name}", key="name", halign="middle") => @PLACE(1, 1.6)
//     };
//   %port_4 = $IO_PORT @ATTACH &"VBTSTP" => @PLACE(75, 16) => @ORIENT("R0");
//   %port_4 @SET-SYMBOL %output_port_symbol;
//   %port_4 @TEXT("VBTSTP", key="name");
//   %bus_port_type_5 = @DEFINE(roles=[["p", "net"], ["p1", "net"], ["p2", "net"], ["p3", "net"]]) {};
//   %bus_port_type_5_symbol = @DEFINE-SYMBOL {(0, 0) @PIN(terminal=[1, 2, 3, 4])};
//   {&"TUNE_3" &"TUNE_2" &"TUNE_1" &"TUNE_0"} @REMOVE-FROM $PORT_FILL_SET;
//   %port_5 = %bus_port_type_5 @ATTACH &"TUNE_3" &"TUNE_2" &"TUNE_1" &"TUNE_0" => @PLACE(-38, 52) => @ORIENT("R0");
//   %port_5 @SET-SYMBOL %bus_port_type_5_symbol;
//   %port_5_marker = $IO_PORT @ATTACH &"TUNE_3" => @PLACE(-38, 52) => @ORIENT("R0");
//   %port_5_marker @SET-SYMBOL %input_port_symbol;
//   %port_5_marker @TEXT("TUNE<3:0>", key="name");
//   %wire_0 = &"net12" @WIRE(mode="straight") {#"M20":3 #"M19":1};
//   %wire_1 = &"net11" @WIRE(mode="straight") {#"M17":3 #"M18":1};
//   %wire_2 = &"net5" @WIRE(mode="straight") {#"M16":3 #"M15":1};
//   %wire_3 = &"net13" @WIRE(mode="straight") {#"M19":3 #"M17":1};
//   %p0 = (-2, 73);
//   %wire_4 = &"net10" @WIRE(mode="straight") {#"M14":2 %p0};
//   %wire_5 = &"net10" @WIRE(mode="straight") {#"I1":2 %p0};
//   %wire_6 = &"net9" @WIRE(mode="straight") {#"M19":2 #"M17":2};
//   %wire_7 = &"net9" @WIRE(mode="straight") {#"M20":2 #"M19":2};
//   %wire_8 = &"net9" @WIRE(mode="straight") {#"M17":2 #"M18":2};
//   %p1 = (18, 93);
//   %wire_9 = &"net9" @WIRE(mode="straight") {#"M18":2 %p1};
//   %wire_10 = &"net9" @WIRE(mode="straight") {#"I3":2 %p1};
//   %p2 = (8, 83);
//   %wire_11 = &"net8" @WIRE(mode="straight") {#"M15":2 %p2};
//   %wire_12 = &"net8" @WIRE(mode="straight") {#"M16":2 #"M15":2};
//   %wire_13 = &"net8" @WIRE(mode="straight") {#"I2":2 %p2};
//   %p3 = (-30, 63);
//   %wire_14 = &"TUNE_0" @WIRE(mode="straight") {%p3 #"I0":1};
//   %wire_14 @TEXT("TUNE\_0", size=1, halign="middle", valign="baseline") => @PLACE(-27, 63.7);
//   %p4 = (-30, 73);
//   %wire_15 = &"TUNE_1" @WIRE(mode="straight") {%p4 #"I1":1};
//   %wire_15 @TEXT("TUNE\_1", size=1, halign="middle", valign="baseline") => @PLACE(-27, 73.7);
//   %wire_16 = &"net4" @WIRE(mode="straight") {#"M3":1 #"M2":3};
//   %p5 = (-18, 0);
//   %wire_17 = &"net1" @WIRE(mode="straight") {#"M2":1 %p5};
//   %p6 = (-12, 0);
//   %wire_18 = &"net1" @WIRE(mode="straight") {%p5 %p6};
//   %wire_19 = &"net1" @WIRE(mode="straight") {%p6 #"M8":1};
//   %p7 = (-24, 0);
//   %wire_20 = &"net1" @WIRE(mode="straight") {%p7 %p5};
//   %p8 = (-6, 0);
//   %p9 = (-6, 8);
//   %wire_21 = &"net1" @WIRE(mode="straight") {%p8 %p9};
//   %p10 = (-6, -8);
//   %wire_22 = &"net1" @WIRE(mode="straight") {%p10 %p8};
//   %wire_23 = &"net1" @WIRE(mode="straight") {%p10 #"M1":2};
//   %wire_24 = &"net1" @WIRE(mode="straight") {%p9 #"M0":2};
//   %wire_25 = &"net1" @WIRE(mode="straight") {%p7 #"M5":1};
//   %wire_26 = &"net1" @WIRE(mode="straight") {%p6 %p8};
//   %p11 = (-30, -7);
//   %wire_27 = &"CLK" @WIRE(mode="straight") {%port_2:p %p11};
//   %p12 = (-30, 3);
//   %wire_28 = &"CLK" @WIRE(mode="straight") {%p11 %p12};
//   %p13 = (-16, 3);
//   %wire_29 = &"CLK" @WIRE(mode="straight") {%p12 %p13};
//   %wire_30 = &"CLK" @WIRE(mode="straight") {%p13 #"M8":2};
//   %wire_31 = &"CLK" @WIRE(mode="straight") {%p11 #"M2":2};
//   %p14 = (-12, 63);
//   %wire_32 = &"net6" @WIRE(mode="straight") {#"M10":2 %p14};
//   %wire_33 = &"net6" @WIRE(mode="straight") {#"I0":2 %p14};
//   %p15 = (22, 17);
//   %wire_34 = &"net7" @WIRE(mode="straight") {%p15 #"M20":1};
//   %p16 = (12, 17);
//   %wire_35 = &"net7" @WIRE(mode="straight") {%p16 %p15};
//   %p17 = (12, 35);
//   %wire_36 = &"net7" @WIRE(mode="straight") {%p16 %p17};
//   %wire_37 = &"net7" @WIRE(mode="straight") {%p17 #"M16":1};
//   %p18 = (-12, 47);
//   %wire_38 = &"net7" @WIRE(mode="straight") {#"M9":1 %p18};
//   %wire_39 = &"net7" @WIRE(mode="straight") {%p18 #"M10":1};
//   %p19 = (4, 35);
//   %wire_40 = &"net7" @WIRE(mode="straight") {%p19 %p17};
//   %p20 = (4, 47);
//   %wire_41 = &"net7" @WIRE(mode="straight") {#"M14":1 %p20};
//   %wire_42 = &"net7" @WIRE(mode="straight") {%p19 %p20};
//   %wire_43 = &"net7" @WIRE(mode="straight") {#"M8":3 %p18};
//   %wire_44 = &"net7" @WIRE(mode="straight") {#"M10":1 #"M14":1};
//   %wire_45 = &"net7" @WIRE(mode="straight") {#"M21":1 %p19};
//   %p21 = (67, 16);
//   %wire_46 = &"VBTSTP" @WIRE(mode="straight") {%p21 %port_4:p};
//   %p22 = (67, 0);
//   %wire_47 = &"VBTSTP" @WIRE(mode="straight") {%p22 %p21};
//   %p23 = (67, 32);
//   %wire_48 = &"VBTSTP" @WIRE(mode="straight") {%p21 %p23};
//   %wire_49 = &"VBTSTP" @WIRE(mode="straight") {#"M4":1 %p23};
//   %p24 = (67, 40);
//   %wire_50 = &"VBTSTP" @WIRE(mode="straight") {#"M7":2 %p24};
//   %wire_51 = &"VBTSTP" @WIRE(mode="straight") {#"M11":1 %p22};
//   %wire_52 = &"VBTSTP" @WIRE(mode="straight") {%p23 %p24};
//   %p25 = (56, 33);
//   %p26 = (58, 33);
//   %wire_53 = &"net3" @WIRE(mode="straight") {%p25 %p26};
//   %p27 = (42, 37);
//   %p28 = (42, 39);
//   %wire_54 = &"net3" @WIRE(mode="straight") {%p27 %p28};
//   %wire_55 = &"net3" @WIRE(mode="straight") {%p27 #"M7":3};
//   %wire_56 = &"net3" @WIRE(mode="straight") {%p28 #"M7":4};
//   %wire_57 = &"net3" @WIRE(mode="straight") {#"M4":3 %p25};
//   %wire_58 = &"net3" @WIRE(mode="straight") {#"M4":4 %p26};
//   %p29 = (43, 32);
//   %wire_59 = &"net3" @WIRE(mode="straight") {%p29 #"M4":3};
//   %wire_60 = &"net3" @WIRE(mode="straight") {#"C0":1 %p29};
//   %wire_61 = &"net3" @WIRE(mode="straight") {%p29 #"M7":3};
//   %p30 = (0, 0);
//   %wire_62 = &"net2" @WIRE(mode="straight") {%p30 #"M0":1};
//   %p31 = (43, 0);
//   %wire_63 = &"net2" @WIRE(mode="straight") {%p31 #"C0":2};
//   %wire_64 = &"net2" @WIRE(mode="straight") {%p31 #"M11":3};
//   %wire_65 = &"net2" @WIRE(mode="straight") {#"M1":1 %p30};
//   %wire_66 = &"net2" @WIRE(mode="straight") {%p30 %p31};
//   %p32 = (-34, -15);
//   %wire_67 = &"SAM" @WIRE(mode="straight") {%port_1:p %p32};
//   %p33 = (-34, 8);
//   %wire_68 = &"SAM" @WIRE(mode="straight") {%p32 %p33};
//   %wire_69 = &"SAM" @WIRE(mode="straight") {%p33 #"M5":2};
//   %wire_70 = &"SAM" @WIRE(mode="straight") {%p32 #"M3":2};
//   %p34 = (-30, 83);
//   %wire_71 = &"TUNE_2" @WIRE(mode="straight") {%p34 #"I2":1};
//   %wire_71 @TEXT("TUNE\_2", size=1, halign="middle", valign="baseline") => @PLACE(-27, 83.7);
//   %p35 = (-23, 90);
//   %wire_72 = &"AVSS" @WIRE(mode="straight") {%p35 #"I3":4};
//   %p36 = (-23, 80);
//   %wire_73 = &"AVSS" @WIRE(mode="straight") {%p36 #"I2":4};
//   %p37 = (-23, 70);
//   %wire_74 = &"AVSS" @WIRE(mode="straight") {%p37 #"I1":4};
//   %p38 = (-23, 60);
//   %wire_75 = &"AVSS" @WIRE(mode="straight") {%p38 #"I0":4};
//   %p39 = (-27, 50);
//   %wire_76 = &"AVSS" @WIRE(mode="straight") {%p39 #"M9":2};
//   %p40 = (1, -11);
//   %wire_77 = &"AVSS" @WIRE(mode="straight") {#"M1":3 %p40};
//   %p41 = (-16, -18);
//   %p42 = (-16, -16);
//   %wire_78 = &"AVSS" @WIRE(mode="straight") {%p41 %p42};
//   %p43 = (-16, -8);
//   %wire_79 = &"AVSS" @WIRE(mode="straight") {#"M2":4 %p43};
//   %p44 = (1, -9);
//   %wire_80 = &"AVSS" @WIRE(mode="straight") {#"M1":4 %p44};
//   %wire_81 = &"AVSS" @WIRE(mode="straight") {#"M3":3 %p41};
//   %p45 = (58, -5);
//   %wire_82 = &"AVSS" @WIRE(mode="straight") {%p45 #"M11":4};
//   %wire_83 = &"AVSS" @WIRE(mode="straight") {%p42 %p43};
//   %wire_84 = &"AVSS" @WIRE(mode="straight") {%p40 %p44};
//   %p46 = (-18, -23);
//   %wire_85 = &"AVSS" @WIRE(mode="straight") {%p46 #"M3":3};
//   %p47 = (0, -16);
//   %wire_86 = &"AVSS" @WIRE(mode="straight") {%p47 #"M1":3};
//   %wire_87 = &"AVSS" @WIRE(mode="straight") {#"M3":4 %p42};
//   %wire_85 @TEXT("AVSS", size=1, halign="middle", valign="baseline", rotate=90) => @PLACE(-18.7, -21);
//   %wire_82 @TEXT("AVSS", size=1, halign="middle", valign="baseline", rotate=90) => @PLACE(57.3, -3);
//   %wire_86 @TEXT("AVSS", size=1, halign="middle", valign="baseline", rotate=90) => @PLACE(-0.7, -14);
//   %wire_76 @TEXT("AVSS", size=1, halign="middle", valign="baseline") => @PLACE(-24, 50.7);
//   %wire_75 @TEXT("AVSS", size=1, halign="middle", valign="baseline") => @PLACE(-22, 58.7);
//   %wire_74 @TEXT("AVSS", size=1, halign="middle", valign="baseline") => @PLACE(-22, 68.7);
//   %wire_73 @TEXT("AVSS", size=1, halign="middle", valign="baseline") => @PLACE(-22, 78.7);
//   %wire_72 @TEXT("AVSS", size=1, halign="middle", valign="baseline") => @PLACE(-22, 88.7);
//   %p48 = (-30, 93);
//   %wire_88 = &"TUNE_3" @WIRE(mode="straight") {%p48 #"I3":1};
//   %wire_88 @TEXT("TUNE\_3", size=1, halign="middle", valign="baseline") => @PLACE(-27, 93.7);
//   %p49 = (24, 33);
//   %p50 = (24, 42);
//   %wire_89 = &"AVDD" @WIRE(mode="straight") {%p49 %p50};
//   %p51 = (24, 24);
//   %wire_90 = &"AVDD" @WIRE(mode="straight") {#"M20":4 %p51};
//   %wire_91 = &"AVDD" @WIRE(mode="straight") {#"M19":4 %p49};
//   %wire_92 = &"AVDD" @WIRE(mode="straight") {%p51 %p49};
//   %p52 = (14, 53);
//   %wire_93 = &"AVDD" @WIRE(mode="straight") {%p52 #"M18":3};
//   %p53 = (24, 51);
//   %p54 = (24, 53);
//   %wire_94 = &"AVDD" @WIRE(mode="straight") {%p53 %p54};
//   %wire_95 = &"AVDD" @WIRE(mode="straight") {%p50 %p53};
//   %wire_96 = &"AVDD" @WIRE(mode="straight") {#"M18":3 %p54};
//   %wire_97 = &"AVDD" @WIRE(mode="straight") {#"M18":4 %p53};
//   %wire_98 = &"AVDD" @WIRE(mode="straight") {#"M17":4 %p50};
//   %p55 = (-23, 96);
//   %wire_99 = &"AVDD" @WIRE(mode="straight") {%p55 #"I3":3};
//   %p56 = (-23, 86);
//   %wire_100 = &"AVDD" @WIRE(mode="straight") {%p56 #"I2":3};
//   %p57 = (-23, 76);
//   %wire_101 = &"AVDD" @WIRE(mode="straight") {%p57 #"I1":3};
//   %p58 = (-23, 66);
//   %wire_102 = &"AVDD" @WIRE(mode="straight") {%p58 #"I0":3};
//   %p59 = (4, 53);
//   %wire_103 = &"AVDD" @WIRE(mode="straight") {%p59 #"M15":3};
//   %p60 = (4, 51);
//   %wire_104 = &"AVDD" @WIRE(mode="straight") {%p60 %p59};
//   %p61 = (14, 51);
//   %wire_105 = &"AVDD" @WIRE(mode="straight") {%p61 %p52};
//   %wire_106 = &"AVDD" @WIRE(mode="straight") {#"M14":3 %p59};
//   %p62 = (14, 42);
//   %wire_107 = &"AVDD" @WIRE(mode="straight") {#"M16":4 %p62};
//   %wire_108 = &"AVDD" @WIRE(mode="straight") {%p62 %p61};
//   %wire_109 = &"AVDD" @WIRE(mode="straight") {#"M15":4 %p61};
//   %p63 = (-6, 53);
//   %wire_110 = &"AVDD" @WIRE(mode="straight") {%p63 #"M14":3};
//   %wire_111 = &"AVDD" @WIRE(mode="straight") {#"M14":4 %p60};
//   %wire_112 = &"AVDD" @WIRE(mode="straight") {#"M15":3 %p52};
//   %p64 = (-6, 51);
//   %wire_113 = &"AVDD" @WIRE(mode="straight") {#"M10":4 %p64};
//   %wire_114 = &"AVDD" @WIRE(mode="straight") {#"M10":3 %p63};
//   %p65 = (-16, 53);
//   %wire_115 = &"AVDD" @WIRE(mode="straight") {%p65 #"M10":3};
//   %p66 = (-10, 9);
//   %p67 = (-10, 16);
//   %wire_116 = &"AVDD" @WIRE(mode="straight") {%p66 %p67};
//   %p68 = (-22, 9);
//   %p69 = (-22, 11);
//   %wire_117 = &"AVDD" @WIRE(mode="straight") {%p68 %p69};
//   %wire_118 = &"AVDD" @WIRE(mode="straight") {%p64 %p63};
//   %p70 = (0, 22);
//   %p71 = (4, 22);
//   %wire_119 = &"AVDD" @WIRE(mode="straight") {%p70 %p71};
//   %wire_120 = &"AVDD" @WIRE(mode="straight") {#"M9":3 %p65};
//   %p72 = (-16, 51);
//   %wire_121 = &"AVDD" @WIRE(mode="straight") {#"M9":4 %p72};
//   %p73 = (1, 11);
//   %wire_122 = &"AVDD" @WIRE(mode="straight") {#"M0":3 %p73};
//   %p74 = (1, 9);
//   %wire_123 = &"AVDD" @WIRE(mode="straight") {%p74 %p73};
//   %wire_124 = &"AVDD" @WIRE(mode="straight") {#"M0":4 %p74};
//   %p75 = (-5, 22);
//   %wire_125 = &"AVDD" @WIRE(mode="straight") {%p75 %p70};
//   %wire_126 = &"AVDD" @WIRE(mode="straight") {%p71 #"M21":3};
//   %p76 = (0, 16);
//   %wire_127 = &"AVDD" @WIRE(mode="straight") {#"M0":3 %p76};
//   %wire_128 = &"AVDD" @WIRE(mode="straight") {%p72 %p65};
//   %wire_129 = &"AVDD" @WIRE(mode="straight") {%p70 #"M21":2};
//   %wire_130 = &"AVDD" @WIRE(mode="straight") {#"M5":4 %p68};
//   %p77 = (6, 22);
//   %p78 = (6, 26);
//   %wire_131 = &"AVDD" @WIRE(mode="straight") {%p77 %p78};
//   %wire_132 = &"AVDD" @WIRE(mode="straight") {%p71 %p77};
//   %p79 = (-24, 16);
//   %wire_133 = &"AVDD" @WIRE(mode="straight") {#"M5":3 %p79};
//   %wire_134 = &"AVDD" @WIRE(mode="straight") {#"M21":4 %p78};
//   %wire_135 = &"AVDD" @WIRE(mode="straight") {#"M8":4 %p66};
//   %p80 = (59, 24);
//   %wire_136 = &"AVDD" @WIRE(mode="straight") {%p80 #"M4":2};
//   %p81 = (43, 48);
//   %wire_137 = &"AVDD" @WIRE(mode="straight") {#"M7":1 %p81};
//   %p82 = (59, 8);
//   %wire_138 = &"AVDD" @WIRE(mode="straight") {%p82 #"M11":2};
//   %wire_139 = &"AVDD" @WIRE(mode="straight") {#"M5":3 %p69};
//   %wire_138 @TEXT("AVDD", size=1, halign="middle", valign="baseline", rotate=90) => @PLACE(58.3, 6);
//   %wire_137 @TEXT("AVDD", size=1, halign="middle", valign="baseline", rotate=90) => @PLACE(42.3, 47);
//   %wire_125 @TEXT("AVDD", size=1, halign="middle", valign="baseline") => @PLACE(-3, 22.7);
//   %wire_127 @TEXT("AVDD", size=1, halign="middle", valign="baseline", rotate=90) => @PLACE(-0.7, 14);
//   %wire_136 @TEXT("AVDD", size=1, halign="middle", valign="baseline", rotate=90) => @PLACE(58.3, 25);
//   %wire_133 @TEXT("AVDD", size=1, halign="middle", valign="baseline", rotate=90) => @PLACE(-24.7, 14);
//   %wire_120 @TEXT("AVDD", size=1, halign="middle", valign="baseline") => @PLACE(-17, 53.7);
//   %wire_116 @TEXT("AVDD", size=1, halign="middle", valign="baseline", rotate=90) => @PLACE(-10.7, 14);
//   %wire_102 @TEXT("AVDD", size=1, halign="middle", valign="baseline") => @PLACE(-22, 66.7);
//   %wire_101 @TEXT("AVDD", size=1, halign="middle", valign="baseline") => @PLACE(-22, 76.7);
//   %wire_100 @TEXT("AVDD", size=1, halign="middle", valign="baseline") => @PLACE(-22, 86.7);
//   %wire_99 @TEXT("AVDD", size=1, halign="middle", valign="baseline") => @PLACE(-22, 96.7);
//   $JUNCTION @ATTACH %p5;
//   $JUNCTION @ATTACH %p6;
//   $JUNCTION @ATTACH %p8;
//   $JUNCTION @ATTACH %p11;
//   $JUNCTION @ATTACH %p17;
//   $JUNCTION @ATTACH %p18;
//   $JUNCTION @ATTACH %p19;
//   $JUNCTION @ATTACH %p21;
//   $JUNCTION @ATTACH %p23;
//   $JUNCTION @ATTACH %p29;
//   $JUNCTION @ATTACH %p30;
//   $JUNCTION @ATTACH %p31;
//   $JUNCTION @ATTACH %p32;
//   $JUNCTION @ATTACH %p42;
//   $JUNCTION @ATTACH %p49;
//   $JUNCTION @ATTACH %p50;
//   $JUNCTION @ATTACH %p52;
//   $JUNCTION @ATTACH %p53;
//   $JUNCTION @ATTACH %p59;
//   $JUNCTION @ATTACH %p61;
//   $JUNCTION @ATTACH %p63;
//   $JUNCTION @ATTACH %p65;
//   $JUNCTION @ATTACH %p70;
//   $JUNCTION @ATTACH %p71
// }
// @RNL(author="gemini-4-argon") {
//   @USE-PACKAGE(name="risca-semantics", version="0.3", path="risca_semantics.rnl");
//   /* LB_vcmbooster: 4-Bit Skew-Tunable Gated Clock Voltage Doubler for Top-Plate Sampling Switch (SAM_GATE) */
//   {#"I0" #"I1" #"I2" #"I3"}(tune_inverters) {#"M5" #"M8" #"M2" #"M3"}(gated_predriver) {#"M9" #"M10" #"M14" #"M15" #"M16" #"M18" #"M17" #"M19" #"M20" #"M21"}(programmable_pmos_header) {#"M0" #"M1" #"C0" #"M7" #"M4" #"M11"}(doubler_core) @AS(role="skew_tunable_sampling_clock_booster", tuning_bits=4) $TUNABLE_GATED_BOOSTER;
//   {#"M0" #"M1"}(driver_inverter) #"C0"(flying_cap) #"M7"(precharge_switch) #"M4"(boost_pass_switch) #"M11"(discharge_switch) @AS(role="capacitive_clock_voltage_doubler", boost_level="2x_AVDD_when_SAM_and_CLK_high") $CLK_VOLTAGE_DOUBLER;
//   {#"I0" #"I1" #"I2" #"I3"}(members) @AS $MATCHED;
//   {#"M9" #"M10" #"M14" #"M15" #"M16" #"M18" #"M17" #"M19" #"M20"}(members) @AS $MATCHED;
//   {#"M8" #"M2" #"M3"}(members) @AS $BRANCH;
//   {#"M0" #"M1"}(members) @AS $BRANCH;
//   {%port_2 #"M8" #"M0" #"C0" #"M4" %port_5}(path) @AS(direction="left-to-right") $FLOW;
//   {#"M15" #"M16"}(members) @AS $BRANCH;
//   {#"M18" #"M17" #"M19" #"M20"}(members) @AS $BRANCH;
//   {#"M4" #"M11"}(members) @AS $BRANCH;
//   /* Note Box & Author Header (Placed in Empty Region Above Schematic) */
//   (-68, 177.07) @TEXT("Comment by Gemini-4-Argon", size=2.8) => @SET-STYLE $risca_author_style;
//   @RECTANGLE {(-68, 143.03) (140.34, 174.23)} => @SET-STYLE $risca_note_box;
//   (-64, 167.25) @TEXT("LB_vcmbooster: 4-Bit Aperture-Skew-Tunable Gated Clock Voltage Booster for Top-Plate VCM Sampling (SAM_GATE)", size=3) => @SET-STYLE $risca_title_style;
//   (-64, 162.25) @TEXT("1. Gating Logic: Only when SAM=1 and CLK=1 does M2+M3 pull net1=AVSS, driving net2=AVDD and boosting VBTSTP to ~2*AVDD.", size=2.5) => @SET-STYLE $risca_swcap_style;
//   (-64, 157.25) @TEXT("2. Aperture Skew Calibration (TUNE_3:0): Controls PMOS header array (M9 fixed + M10 1x + M14 0.5x + M15:M16 0.25x + M18..M20 0.125x)", size=2.5) => @SET-STYLE $risca_swcap_style;
//   (-64, 152.25) @TEXT("   supplying net7. When CLK falls (sampling instant!), M8 pulls net1 high through net7, turning off VBTSTP with sub-ps tunable delay.", size=2.5) => @SET-STYLE $risca_swcap_style;
//   (-64, 147.25) @TEXT("3. Layout Dummy: M21 (gate=source=AVDD) is an always-off dummy PMOS attached to net7 for diffusion matching.", size=2.5) => @SET-STYLE $risca_bias_style
// }
ends LB_vcmbooster
