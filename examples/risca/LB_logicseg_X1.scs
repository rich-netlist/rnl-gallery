// RNL cell RISCA_JL/LB_logicseg_X1
// @RNL(type="header") {
//   @VERSION("0.3");
//   @USE-PACKAGE(name="eda-symbol", version="0.1", path="eda-symbol.rnl");
//   @USE-PACKAGE(name="eda-style", version="0.1", path="eda-style.rnl")
// }
subckt LB_logicseg_X1 CMPN CMPO CMPP DON DOP ENB GND NEXTB RST VDD RDY
    I6 (CMPP net1 net14 DOP VDD GND) AOI21D1BWP12T30P140
    I30 (CMPN net1 net9 DON VDD GND) AOI21D1BWP12T30P140
    I7 (DOP RST net14 VDD GND) NR2D0BWP12T30P140
    I36 (DON RST net9 VDD GND) NR2D0BWP12T30P140
    I4 (net2 RDY NEXTB VDD GND) ND2D1BWP12T30P140
    I3 (CMPO NEXTB net2 VDD GND) ND2D0BWP12T30P140
    I2 (DOP DON RDY VDD GND) ND2D0BWP12T30P140
    I8 (RDY ENB net1 VDD GND) NR2D1BWP12T30P140
// @RNL(author="rnl-virtuoso") {
//   %block_symbol = @DEFINE-SYMBOL(box=[0, -23, 22, 9]) {
//     @LINE {(22, -12) (17, -12)};
//     @LINE {(22, -8) (17, -8)};
//     @LINE {(22, 4) (17, 4)};
//     @LINE {(22, -4) (17, -4)};
//     @LINE {(22, 0) (17, 0)};
//     @LINE {(0, -8) (6, -8)};
//     @LINE {(12, 9) (12, 5)};
//     @LINE {(12, -23) (12, -19)};
//     @LINE {(22, -16) (17, -16)};
//     @LINE {(22, -18) (17, -18)};
//     @RECTANGLE {(6, -19) (17, 5)};
//     @LINE {(6, -23) (6, -17)};
//     ? @TEXT("${name}", size=1, halign="start", valign="middle", key="name") => @PLACE(19, 8);
//     ? @TEXT("${model}", size=1, halign="middle", valign="middle", rotate=90, key="model") => @PLACE(11, -7);
//     (22, -12) @PIN(terminal="RST");
//     (21.4, -11) @TEXT("RST", size=1, halign="end", valign="middle");
//     (22, -8) @PIN(terminal="ENB");
//     (21.4, -7) @TEXT("ENB", size=1, halign="end", valign="middle");
//     (22, 4) @PIN(terminal="CMPP");
//     (21.4, 5) @TEXT("CMPP", size=1, halign="end", valign="middle");
//     (22, -4) @PIN(terminal="CMPO");
//     (21.4, -3) @TEXT("CMPO", size=1, halign="end", valign="middle");
//     (22, 0) @PIN(terminal="CMPN");
//     (21.4, 1) @TEXT("CMPN", size=1, halign="end", valign="middle");
//     (0, -8) @PIN(terminal="NEXTB");
//     (0.6, -7) @TEXT("NEXTB", size=1, halign="start", valign="middle");
//     (12, 9) @PIN(terminal="DOP");
//     (11, 8.4) @TEXT("DOP", size=1, halign="end", valign="middle", rotate=90);
//     (12, -23) @PIN(terminal="DON");
//     (11, -22.4) @TEXT("DON", size=1, halign="start", valign="middle", rotate=90);
//     (22, -16) @PIN(terminal="VDD");
//     (21.4, -15) @TEXT("VDD", size=1, halign="end", valign="middle");
//     (22, -18) @PIN(terminal="GND");
//     (21.4, -17) @TEXT("GND", size=1, halign="end", valign="middle");
//     (6, -23) @PIN(terminal="RDY");
//     (5, -22.4) @TEXT("RDY", size=1, halign="start", valign="middle", rotate=90)
//   };
//   # @SET-SYMBOL %block_symbol;
//   %symbol_0 = @DEFINE-SYMBOL(box=[8, -3, 17, 5]) {
//     (15.5, 1) @CIRCLE(radius=0.5);
//     @LINE {(12, 5) (12, 3)};
//     @LINE {(16, 1) (17, 1)};
//     @LINE {(12, -3) (12, -1)};
//     @LINE {(9, 3) (12, 3)};
//     @LINE {(9, -1) (12, -1)};
//     @ARC {(9, -1) (11, 1) (9, 3)};
//     @LINE {(8, 2) (10.7, 2)};
//     @LINE {(8, 0) (10.7, 0)};
//     @ARC {(14.9, 0.9) (13.8, 2.4) (12, 2.9)};
//     @ARC {(12, -1) (13.8, -0.5) (15, 1)};
//     ? @TEXT("${name}", size=0.4, halign="end", valign="top", key="name") => @PLACE(17, 5);
//     ? @TEXT("${model}", size=0.4, halign="end", valign="baseline", key="model") => @PLACE(17, -3);
//     (12, -3) @PIN(terminal=5);
//     (12.9, -3) @TEXT("VSS", size=0.4, halign="start", valign="middle");
//     (17, 1) @PIN(terminal=3);
//     (14.6, 1) @TEXT("ZN", size=0.4, halign="end", valign="middle");
//     (12, 5) @PIN(terminal=4);
//     (12.9, 5) @TEXT("VDD", size=0.4, halign="start", valign="middle");
//     (8, 2) @PIN(terminal=1);
//     (11.4, 2) @TEXT("A1", size=0.4, halign="start", valign="middle");
//     (8, 0) @PIN(terminal=2);
//     (11.4, 0) @TEXT("A2", size=0.4, halign="start", valign="middle")
//   };
//   #"I36" @SET-SYMBOL %symbol_0;
//   #"I36" @PLACE(-3, -32) => @ORIENT("R180");
//   #"I7" @SET-SYMBOL %symbol_0;
//   #"I7" @PLACE(-3, 37) => @ORIENT("MY");
//   %symbol_1 = @DEFINE-SYMBOL(box=[15, -3, 29, 5]) {
//     @LINE {(28, 0) (29, 0)};
//     @LINE {(22, 5) (22, 2)};
//     @LINE {(28, 0) (29, 0)};
//     @LINE {(22, -3) (22, -2)};
//     @LINE {(21, 2) (24, 2)};
//     @LINE {(21, -2) (24, -2)};
//     @ARC {(21, -2) (23, 0) (21, 2)};
//     (27.5, 0) @CIRCLE(radius=0.5);
//     @LINE {(15, -1) (22.7, -1)};
//     @ARC {(26.9, -0.1) (25.8, 1.4) (24, 1.9)};
//     @ARC {(24, -2) (25.8, -1.5) (27, 0)};
//     @LINE {(17, 4) (17, 0)};
//     @LINE {(17, 4) (19, 4)};
//     @LINE {(17, 0) (19, 0)};
//     @ARC {(19, 0) (21, 2) (19, 4)};
//     @LINE {(15, 3) (17, 3)};
//     @LINE {(15, 1) (17, 1)};
//     ? @TEXT("${model}", size=0.4, halign="end", valign="baseline", key="model") => @PLACE(29, -3);
//     ? @TEXT("${name}", size=0.4, halign="end", valign="top", key="name") => @PLACE(29, 5);
//     (22, -3) @PIN(terminal=6);
//     (22.9, -3) @TEXT("VSS", size=0.4, halign="start", valign="middle");
//     (29, 0) @PIN(terminal=4);
//     (26.6, 0) @TEXT("ZN", size=0.4, halign="end", valign="middle");
//     (22, 5) @PIN(terminal=5);
//     (22.9, 5) @TEXT("VDD", size=0.4, halign="start", valign="middle");
//     (15, 3) @PIN(terminal=1);
//     (17.4, 3) @TEXT("A1", size=0.4, halign="start", valign="middle");
//     (15, 1) @PIN(terminal=2);
//     (17.4, 1) @TEXT("A2", size=0.4, halign="start", valign="middle");
//     (15, -1) @PIN(terminal=3);
//     (17.4, -0.6) @TEXT("B", size=0.4, halign="start", valign="middle")
//   };
//   #"I6" @SET-SYMBOL %symbol_1;
//   #"I6" @PLACE(7, 55) => @ORIENT("MY");
//   %symbol_2 = @DEFINE-SYMBOL(box=[-9, -3, 0, 5]) {
//     @LINE {(-6, 5) (-6, 3)};
//     @LINE {(-2, 1) (-1, 1)};
//     @LINE {(-6, -3) (-6, -1)};
//     @LINE {(-7, 3) (-7, -1)};
//     @LINE {(-7, 3) (-5, 3)};
//     @LINE {(-7, -1) (-5, -1)};
//     @ARC {(-5, -1) (-3, 1) (-5, 3)};
//     @LINE {(-9, 2) (-7, 2)};
//     @LINE {(-9, 0) (-7, 0)};
//     @LINE {(-1, 1) (0, 1)};
//     (-2.5, 1) @CIRCLE(radius=0.5);
//     ? @TEXT("${name}", size=0.4, halign="end", valign="top", key="name") => @PLACE(0, 5);
//     ? @TEXT("${model}", size=0.4, halign="end", valign="baseline", key="model") => @PLACE(0, -3);
//     (0, 1) @PIN(terminal=3);
//     (-3.4, 1) @TEXT("ZN", size=0.4, halign="end", valign="middle");
//     (-6, -3) @PIN(terminal=5);
//     (-5.1, -3) @TEXT("VSS", size=0.4, halign="start", valign="middle");
//     (-6, 5) @PIN(terminal=4);
//     (-5.1, 5) @TEXT("VDD", size=0.4, halign="start", valign="middle");
//     (-9, 2) @PIN(terminal=1);
//     (-6.6, 2) @TEXT("A1", size=0.4, halign="start", valign="middle");
//     (-9, 0) @PIN(terminal=2);
//     (-6.6, 0) @TEXT("A2", size=0.4, halign="start", valign="middle")
//   };
//   #"I3" @SET-SYMBOL %symbol_2;
//   #"I3" @PLACE(-21, 17) => @ORIENT("MY");
//   %symbol_3 = @DEFINE-SYMBOL(box=[8, -3, 17, 5]) {
//     (15.5, 1) @CIRCLE(radius=0.5);
//     @LINE {(12, 5) (12, 3)};
//     @LINE {(16, 1) (17, 1)};
//     @LINE {(12, -3) (12, -1)};
//     @LINE {(9, 3) (12, 3)};
//     @LINE {(9, -1) (12, -1)};
//     @ARC {(9, -1) (11, 1) (9, 3)};
//     @LINE {(8, 2) (10.7, 2)};
//     @LINE {(8, 0) (10.7, 0)};
//     @ARC {(14.9, 0.9) (13.8, 2.4) (12, 2.9)};
//     @ARC {(12, -1) (13.8, -0.5) (15, 1)};
//     ? @TEXT("${name}", size=0.4, halign="end", valign="top", key="name") => @PLACE(17, 5);
//     ? @TEXT("${model}", size=0.4, halign="end", valign="baseline", key="model") => @PLACE(17, -3);
//     (12, -3) @PIN(terminal=5);
//     (12.9, -3) @TEXT("VSS", size=0.4, halign="start", valign="middle");
//     (17, 1) @PIN(terminal=3);
//     (14.6, 1) @TEXT("ZN", size=0.4, halign="end", valign="middle");
//     (12, 5) @PIN(terminal=4);
//     (12.9, 5) @TEXT("VDD", size=0.4, halign="start", valign="middle");
//     (8, 2) @PIN(terminal=1);
//     (11.4, 2) @TEXT("A1", size=0.4, halign="start", valign="middle");
//     (8, 0) @PIN(terminal=2);
//     (11.4, 0) @TEXT("A2", size=0.4, halign="start", valign="middle")
//   };
//   #"I8" @SET-SYMBOL %symbol_3;
//   #"I8" @PLACE(-12, -10) => @ORIENT("MX");
//   #"I30" @SET-SYMBOL %symbol_1;
//   #"I30" @PLACE(7, -50) => @ORIENT("R180");
//   #"I2" @SET-SYMBOL %symbol_2;
//   #"I2" @PLACE(-21, -13) => @ORIENT("R0");
//   %symbol_4 = @DEFINE-SYMBOL(box=[-9, -3, 0, 5]) {
//     @LINE {(-6, 5) (-6, 3)};
//     @LINE {(-2, 1) (-1, 1)};
//     @LINE {(-6, -3) (-6, -1)};
//     @LINE {(-7, 3) (-7, -1)};
//     @LINE {(-7, 3) (-5, 3)};
//     @LINE {(-7, -1) (-5, -1)};
//     @ARC {(-5, -1) (-3, 1) (-5, 3)};
//     @LINE {(-9, 2) (-7, 2)};
//     @LINE {(-9, 0) (-7, 0)};
//     @LINE {(-1, 1) (0, 1)};
//     (-2.5, 1) @CIRCLE(radius=0.5);
//     ? @TEXT("${name}", size=0.4, halign="end", valign="top", key="name") => @PLACE(0, 5);
//     ? @TEXT("${model}", size=0.4, halign="end", valign="baseline", key="model") => @PLACE(0, -3);
//     (0, 1) @PIN(terminal=3);
//     (-3.4, 1) @TEXT("ZN", size=0.4, halign="end", valign="middle");
//     (-6, -3) @PIN(terminal=5);
//     (-5.1, -3) @TEXT("VSS", size=0.4, halign="start", valign="middle");
//     (-6, 5) @PIN(terminal=4);
//     (-5.1, 5) @TEXT("VDD", size=0.4, halign="start", valign="middle");
//     (-9, 2) @PIN(terminal=1);
//     (-6.6, 2) @TEXT("A1", size=0.4, halign="start", valign="middle");
//     (-9, 0) @PIN(terminal=2);
//     (-6.6, 0) @TEXT("A2", size=0.4, halign="start", valign="middle")
//   };
//   #"I4" @SET-SYMBOL %symbol_4;
//   #"I4" @PLACE(-21, -2) => @ORIENT("MY");
//   %port_0 = $IO_PORT @ATTACH &"VDD" => @PLACE(-65, 48) => @ORIENT("R0");
//   %port_1 = $IO_PORT @ATTACH &"GND" => @PLACE(-65, 44) => @ORIENT("R0");
//   %input_port_symbol = @DEFINE-SYMBOL(box=[-2, -1, 0, 1]) {
//       @LINE(fill="linecolor", linestyle="none") {(-2, -0.9) (-2, 0.9) (-0.9, 0.9) (0, 0) (-0.9, -0.9) (-2, -0.9)};
//       (0, 0) @PIN(terminal=1, direction="right");
//       ? @TEXT("${name}", key="name", halign="middle") => @PLACE(-1, 1.6)
//     };
//   %port_2 = $IO_PORT @ATTACH &"CMPP" => @PLACE(-64, 40) => @ORIENT("R0");
//   %port_2 @SET-SYMBOL %input_port_symbol;
//   %port_2 @TEXT("CMPP", key="name");
//   %port_3 = $IO_PORT @ATTACH &"CMPN" => @PLACE(-64, 36) => @ORIENT("R0");
//   %port_3 @SET-SYMBOL %input_port_symbol;
//   %port_3 @TEXT("CMPN", key="name");
//   %port_4 = $IO_PORT @ATTACH &"RST" => @PLACE(-64, 28) => @ORIENT("R0");
//   %port_4 @SET-SYMBOL %input_port_symbol;
//   %port_4 @TEXT("RST", key="name");
//   %output_port_symbol = @DEFINE-SYMBOL(box=[0, -1, 2, 1]) {
//       @LINE(fill="linecolor", linestyle="none") {(0, -0.9) (0, 0.9) (1.1, 0.9) (2, 0) (1.1, -0.9) (0, -0.9)};
//       (0, 0) @PIN(terminal=1, direction="left");
//       ? @TEXT("${name}", key="name", halign="middle") => @PLACE(1, 1.6)
//     };
//   %port_5 = $IO_PORT @ATTACH &"DOP" => @PLACE(-66, 20) => @ORIENT("R0");
//   %port_5 @SET-SYMBOL %output_port_symbol;
//   %port_5 @TEXT("DOP", key="name");
//   %port_6 = $IO_PORT @ATTACH &"DON" => @PLACE(-66, 16) => @ORIENT("R0");
//   %port_6 @SET-SYMBOL %output_port_symbol;
//   %port_6 @TEXT("DON", key="name");
//   %port_7 = $IO_PORT @ATTACH &"NEXTB" => @PLACE(-66, 12) => @ORIENT("R0");
//   %port_7 @SET-SYMBOL %output_port_symbol;
//   %port_7 @TEXT("NEXTB", key="name");
//   %port_8 = $IO_PORT @ATTACH &"ENB" => @PLACE(-64, 24) => @ORIENT("R0");
//   %port_8 @SET-SYMBOL %input_port_symbol;
//   %port_8 @TEXT("ENB", key="name");
//   %port_9 = $IO_PORT @ATTACH &"CMPO" => @PLACE(-64, 32) => @ORIENT("R0");
//   %port_9 @SET-SYMBOL %input_port_symbol;
//   %port_9 @TEXT("CMPO", key="name");
//   %port_10 = $IO_PORT @ATTACH &"RDY" => @PLACE(-66, 8) => @ORIENT("R0");
//   %port_10 @SET-SYMBOL %output_port_symbol;
//   %port_10 @TEXT("RDY", key="name");
//   %p0 = (1, 48);
//   %p1 = (1, 54);
//   %wire_0 = &"net14" @WIRE(mode="straight") {%p0 %p1};
//   %wire_1 = &"net14" @WIRE(mode="straight") {%p1 #"I6":3};
//   %p2 = (-23, 44);
//   %wire_2 = &"net14" @WIRE(mode="straight") {%p2 %p0};
//   %p3 = (-23, 38);
//   %wire_3 = &"net14" @WIRE(mode="straight") {#"I7":3 %p3};
//   %wire_4 = &"net14" @WIRE(mode="straight") {%p3 %p2};
//   %p4 = (14, 19);
//   %wire_5 = &"CMPO" @WIRE(mode="straight") {#"I3":1 %p4};
//   %wire_5 @TEXT("CMPO", size=1, halign="middle", valign="baseline") => @PLACE(12, 19.7);
//   %p5 = (7, -11);
//   %wire_6 = &"net1" @WIRE(mode="straight") {#"I8":3 %p5};
//   %p6 = (7, -51);
//   %wire_7 = &"net1" @WIRE(mode="straight") {#"I30":2 %p6};
//   %p7 = (7, 56);
//   %wire_8 = &"net1" @WIRE(mode="straight") {#"I6":2 %p7};
//   %wire_9 = &"net1" @WIRE(mode="straight") {%p6 %p5};
//   %wire_10 = &"net1" @WIRE(mode="straight") {%p5 %p7};
//   %p8 = (-6, -1);
//   %p9 = (14, -1);
//   %wire_11 = &"ENB" @WIRE(mode="straight") {%p8 %p9};
//   %p10 = (-6, -10);
//   %wire_12 = &"ENB" @WIRE(mode="straight") {%p10 #"I8":2};
//   %wire_13 = &"ENB" @WIRE(mode="straight") {%p10 %p8};
//   %wire_11 @TEXT("ENB", size=1, halign="middle", valign="baseline") => @PLACE(11.7, -0.3);
//   %p11 = (1, -43);
//   %p12 = (1, -49);
//   %wire_14 = &"net9" @WIRE(mode="straight") {%p11 %p12};
//   %wire_15 = &"net9" @WIRE(mode="straight") {%p12 #"I30":3};
//   %p13 = (-23, -39);
//   %wire_16 = &"net9" @WIRE(mode="straight") {%p13 %p11};
//   %p14 = (-23, -33);
//   %wire_17 = &"net9" @WIRE(mode="straight") {#"I36":3 %p14};
//   %wire_18 = &"net9" @WIRE(mode="straight") {%p14 %p13};
//   %p15 = (14, -53);
//   %wire_19 = &"CMPN" @WIRE(mode="straight") {#"I30":1 %p15};
//   %wire_19 @TEXT("CMPN", size=1, halign="middle", valign="baseline") => @PLACE(12, -52.3);
//   %p16 = (14, 58);
//   %wire_20 = &"CMPP" @WIRE(mode="straight") {#"I6":1 %p16};
//   %wire_20 @TEXT("CMPP", size=1, halign="middle", valign="baseline") => @PLACE(11, 58.7);
//   %p17 = (-3, -7);
//   %wire_21 = &"GND" @WIRE(mode="straight") {%p17 #"I8":5};
//   %p18 = (-12, -5);
//   %wire_22 = &"GND" @WIRE(mode="straight") {%p18 #"I4":5};
//   %p19 = (-12, 14);
//   %wire_23 = &"GND" @WIRE(mode="straight") {%p19 #"I3":5};
//   %p20 = (-11, 52);
//   %wire_24 = &"GND" @WIRE(mode="straight") {#"I6":6 %p20};
//   %p21 = (-11, -29);
//   %wire_25 = &"GND" @WIRE(mode="straight") {#"I36":5 %p21};
//   %p22 = (-11, 34);
//   %wire_26 = &"GND" @WIRE(mode="straight") {#"I7":5 %p22};
//   %p23 = (-30, -16);
//   %wire_27 = &"GND" @WIRE(mode="straight") {%p23 #"I2":5};
//   %p24 = (-11, -47);
//   %wire_28 = &"GND" @WIRE(mode="straight") {#"I30":6 %p24};
//   %wire_28 @TEXT("GND", size=1, halign="middle", valign="baseline") => @PLACE(-13, -46.3);
//   %wire_27 @TEXT("GND", size=1, halign="middle", valign="top") => @PLACE(-28, -16.7);
//   %wire_26 @TEXT("GND", size=1, halign="middle", valign="top") => @PLACE(-13, 33.3);
//   %wire_25 @TEXT("GND", size=1, halign="middle", valign="baseline") => @PLACE(-13, -28.3);
//   %wire_24 @TEXT("GND", size=1, halign="middle", valign="top") => @PLACE(-13, 51.3);
//   %wire_23 @TEXT("GND", size=1, halign="middle", valign="top") => @PLACE(-14, 13.3);
//   %wire_22 @TEXT("GND", size=1, halign="middle", valign="top") => @PLACE(-14, -5.7);
//   %wire_21 @TEXT("GND", size=1, halign="middle", valign="baseline") => @PLACE(-1, -6.3);
//   %p25 = (-3, -15);
//   %wire_29 = &"VDD" @WIRE(mode="straight") {%p25 #"I8":4};
//   %p26 = (-12, 3);
//   %wire_30 = &"VDD" @WIRE(mode="straight") {%p26 #"I4":4};
//   %p27 = (-12, 22);
//   %wire_31 = &"VDD" @WIRE(mode="straight") {%p27 #"I3":4};
//   %p28 = (-11, 60);
//   %wire_32 = &"VDD" @WIRE(mode="straight") {%p28 #"I6":5};
//   %p29 = (-11, 42);
//   %wire_33 = &"VDD" @WIRE(mode="straight") {%p29 #"I7":4};
//   %p30 = (-30, -8);
//   %wire_34 = &"VDD" @WIRE(mode="straight") {%p30 #"I2":4};
//   %p31 = (-11, -37);
//   %wire_35 = &"VDD" @WIRE(mode="straight") {%p31 #"I36":4};
//   %p32 = (-11, -55);
//   %wire_36 = &"VDD" @WIRE(mode="straight") {%p32 #"I30":5};
//   %wire_36 @TEXT("VDD", size=1, halign="middle", valign="top") => @PLACE(-13, -55.7);
//   %wire_35 @TEXT("VDD", size=1, halign="middle", valign="top") => @PLACE(-13, -37.7);
//   %wire_34 @TEXT("VDD", size=1, halign="middle", valign="baseline") => @PLACE(-28, -7.3);
//   %wire_33 @TEXT("VDD", size=1, halign="middle", valign="baseline") => @PLACE(-13, 42.7);
//   %wire_32 @TEXT("VDD", size=1, halign="middle", valign="baseline") => @PLACE(-13, 60.7);
//   %wire_31 @TEXT("VDD", size=1, halign="middle", valign="baseline") => @PLACE(-14, 22.7);
//   %wire_30 @TEXT("VDD", size=1, halign="middle", valign="baseline") => @PLACE(-14, 3.7);
//   %wire_29 @TEXT("VDD", size=1, halign="middle", valign="top") => @PLACE(-1, -15.7);
//   %p33 = (-33, -13);
//   %wire_37 = &"DON" @WIRE(mode="straight") {%p33 #"I2":2};
//   %p34 = (-33, -50);
//   %p35 = (-23, -50);
//   %wire_38 = &"DON" @WIRE(mode="straight") {%p34 %p35};
//   %p36 = (-33, -59);
//   %wire_39 = &"DON" @WIRE(mode="straight") {%p36 %p34};
//   %wire_40 = &"DON" @WIRE(mode="straight") {%p34 %p33};
//   %p37 = (1, -34);
//   %p38 = (1, -39);
//   %wire_41 = &"DON" @WIRE(mode="straight") {%p37 %p38};
//   %wire_42 = &"DON" @WIRE(mode="straight") {%p37 #"I36":1};
//   %p39 = (-23, -43);
//   %wire_43 = &"DON" @WIRE(mode="straight") {%p39 %p38};
//   %wire_44 = &"DON" @WIRE(mode="straight") {#"I30":4 %p35};
//   %wire_45 = &"DON" @WIRE(mode="straight") {%p39 %p35};
//   %wire_39 @TEXT("DON", size=1, halign="middle", valign="baseline", rotate=90) => @PLACE(-33.7, -55);
//   %p40 = (-43, -1);
//   %wire_46 = &"NEXTB" @WIRE(mode="straight") {%p40 #"I4":3};
//   %p41 = (-8, 17);
//   %wire_47 = &"NEXTB" @WIRE(mode="straight") {%p41 #"I3":2};
//   %p42 = (-8, 11);
//   %wire_48 = &"NEXTB" @WIRE(mode="straight") {%p42 %p41};
//   %p43 = (-21, 6);
//   %wire_49 = &"NEXTB" @WIRE(mode="straight") {%p43 %p42};
//   %wire_50 = &"NEXTB" @WIRE(mode="straight") {#"I4":3 %p43};
//   %wire_46 @TEXT("NEXTB", size=1, halign="middle", valign="baseline") => @PLACE(-40, -0.3);
//   %p44 = (14, 37);
//   %wire_51 = &"RST" @WIRE(mode="straight") {#"I7":2 %p44};
//   %p45 = (14, -32);
//   %wire_52 = &"RST" @WIRE(mode="straight") {#"I36":2 %p45};
//   %wire_51 @TEXT("RST", size=1, halign="middle", valign="baseline") => @PLACE(12, 37.7);
//   %wire_52 @TEXT("RST", size=1, halign="middle", valign="baseline") => @PLACE(12, -31.3);
//   %p46 = (1, 39);
//   %p47 = (1, 44);
//   %wire_53 = &"DOP" @WIRE(mode="straight") {%p46 %p47};
//   %wire_54 = &"DOP" @WIRE(mode="straight") {%p46 #"I7":1};
//   %p48 = (-23, 48);
//   %wire_55 = &"DOP" @WIRE(mode="straight") {%p48 %p47};
//   %p49 = (-23, 55);
//   %wire_56 = &"DOP" @WIRE(mode="straight") {%p49 #"I6":4};
//   %wire_57 = &"DOP" @WIRE(mode="straight") {%p48 %p49};
//   %p50 = (-33, 55);
//   %wire_58 = &"DOP" @WIRE(mode="straight") {%p50 %p49};
//   %p51 = (-33, 62);
//   %wire_59 = &"DOP" @WIRE(mode="straight") {%p50 %p51};
//   %p52 = (-33, -11);
//   %wire_60 = &"DOP" @WIRE(mode="straight") {%p52 #"I2":1};
//   %wire_61 = &"DOP" @WIRE(mode="straight") {%p52 %p50};
//   %wire_59 @TEXT("DOP", size=1, halign="middle", valign="baseline", rotate=90) => @PLACE(-33.7, 59);
//   %p53 = (-43, -22);
//   %p54 = (-15, -22);
//   %wire_62 = &"RDY" @WIRE(mode="straight") {%p53 %p54};
//   %p55 = (-15, -12);
//   %wire_63 = &"RDY" @WIRE(mode="straight") {%p54 %p55};
//   %p56 = (-8, -12);
//   %wire_64 = &"RDY" @WIRE(mode="straight") {%p56 #"I8":1};
//   %wire_65 = &"RDY" @WIRE(mode="straight") {%p55 %p56};
//   %wire_66 = &"RDY" @WIRE(mode="straight") {#"I2":3 %p55};
//   %p57 = (-8, -2);
//   %wire_67 = &"RDY" @WIRE(mode="straight") {#"I4":2 %p57};
//   %wire_68 = &"RDY" @WIRE(mode="straight") {%p56 %p57};
//   %wire_62 @TEXT("RDY", size=1, halign="middle", valign="baseline") => @PLACE(-40, -21.3);
//   %p58 = (-8, 0);
//   %p59 = (-8, 6);
//   %wire_69 = &"net2" @WIRE(mode="straight") {%p58 %p59};
//   %wire_70 = &"net2" @WIRE(mode="straight") {%p58 #"I4":1};
//   %p60 = (-21, 11);
//   %wire_71 = &"net2" @WIRE(mode="straight") {%p60 %p59};
//   %wire_72 = &"net2" @WIRE(mode="straight") {%p60 #"I3":3};
//   $JUNCTION @ATTACH %p5;
//   $JUNCTION @ATTACH %p34;
//   $JUNCTION @ATTACH %p35;
//   $JUNCTION @ATTACH %p49;
//   $JUNCTION @ATTACH %p50;
//   $JUNCTION @ATTACH %p55;
//   $JUNCTION @ATTACH %p56;
//   (71, 28) @TEXT("CMPP", size=3.2, halign="middle", valign="baseline");
//   (154, -29) @TEXT("=ENB'+RDY'", size=3.2, halign="middle", valign="baseline");
//   (170, -39) @TEXT("=RST at (RDY+CMPO')", size=3.2, halign="middle", valign="baseline");
//   (72, -13) @TEXT("RDY", size=3.2, halign="middle", valign="baseline");
//   (72, 8) @TEXT("CMPO", size=3.2, halign="middle", valign="baseline");
//   (167, 8) @TEXT("=CMPP+CMPN+CMPCK", size=3.2, halign="middle", valign="baseline");
//   (71, 18) @TEXT("CMPN", size=3.2, halign="middle", valign="baseline");
//   (70, -30) @TEXT("EN\_SELF", size=3.2, halign="middle", valign="baseline");
//   (72, -39) @TEXT("NEXTB", size=3.2, halign="middle", valign="baseline");
//   (72, -3) @TEXT("DOP", size=3.2, halign="middle", valign="baseline");
//   (72, -22) @TEXT("ENB", size=3.2, halign="middle", valign="baseline");
//   @LINE {(83, 17) (123, 17)};
//   @LINE {(83, -13) (96, -13) (96, -8) (137, -8)};
//   @LINE {(83, 7) (88, 7) (88, 13) (113, 13) (113, 7) (120, 7) (120, 13) (137, 13)};
//   @LINE {(123, 17) (123, 23) (137, 23)};
//   @LINE {(83, 26) (91, 26) (91, 32) (108, 32)};
//   @LINE {(108, 32) (108, 26) (123, 26) (123, 26) (137, 26)};
//   @LINE {(83, -26) (98, -26) (98, -31) (137, -31)};
//   @LINE {(83, -35) (114, -35) (114, -40) (126, -40)};
//   @LINE {(83, 1) (94, 1) (94, -5) (137, -5)};
//   @LINE {(126, -40) (130, -40) (130, -40) (137, -40)};
//   @LINE {(83, -23) (98, -23) (98, -17) (137, -17)};
//   @LINE(linestyle="dashed") {(91, 25) (94, 2)};
//   @LINE(linestyle="dashed") {(94, -6) (95, -10)};
//   @LINE(linestyle="dashed") {(96, -14) (97, -25)};
//   @LINE(linestyle="dashed") {(112, 6) (114, -33)}
// }
// @RNL(author="gemini-4-argon") {
//   @USE-PACKAGE(name="risca-semantics", version="0.3", path="risca_semantics.rnl");
//   /* LB_logicseg_X1: Standard-Drive (X1) Asynchronous SAR Bit Register & Token-Passing Slice */
//   #"I8"(window_enable_gate) {#"I6" #"I7"}(dop_sr_latch) {#"I30" #"I36"}(don_sr_latch) {#"I2" #"I3" #"I4"}(completion_and_token_logic) @AS(role="asynchronous_SAR_bit_slice", drive_strength="X1_AOI21D1") $ASYNC_SAR_BIT_SLICE;
//   {#"I6" #"I30"}(members) @AS $MATCHED;
//   {#"I7" #"I36"}(members) @AS $MATCHED;
//   {#"I8" #"I6" #"I2" #"I4"}(path) @AS(direction="left-to-right") $FLOW;
//   {#"I8" #"I30" #"I2" #"I4"}(path) @AS(direction="left-to-right") $FLOW;
//   {#"I3" #"I4" #"I2"}(members) @AS $BRANCH;
//   {#"I7" #"I36"}(members) @AS $BRANCH;
//   {#"I6" #"I30"}(members) @AS $BRANCH;
//   /* Note Box & Author Header (Placed in Empty Region Above Schematic) */
//   (-99, 138.07) @TEXT("Comment by Gemini-4-Argon", size=2.8) => @SET-STYLE $risca_author_style;
//   @RECTANGLE {(-99, 109.03) (95.79, 135.23)} => @SET-STYLE $risca_note_box;
//   (-95, 128.25) @TEXT("LB_logicseg_X1: Asynchronous SAR Bit Slice (1x Drive AOI21D1, With External RDY Port)", size=3) => @SET-STYLE $risca_title_style;
//   (-95, 123.25) @TEXT("1. Window Gate I8 (NR2D1): Asserts active capture window net1=1 when ENB=0 (token arrived) and RDY=0 (not yet resolved).", size=2.5) => @SET-STYLE $risca_digital_style;
//   (-95, 118.25) @TEXT("2. Complementary SR Bit Latches: I6+I7 latch DOP=1 on CMPP=1; I30+I36 latch DON=1 on CMPN=1; RST=1 resets DOP=DON=0.", size=2.5) => @SET-STYLE $risca_digital_style;
//   (-95, 113.25) @TEXT("3. Completion & Token Handshake: I2 (ND2D0) pulls RDY=0 once DOP|DON=1; I3+I4 latch NEXTB=0 when CMPO=1 to trigger next bit.", size=2.5) => @SET-STYLE $risca_digital_style
// }
ends LB_logicseg_X1
