// RNL cell decap/V1_decap
// @RNL(type="header") {
//   @VERSION("0.3");
//   @USE-PACKAGE(name="eda-symbol", version="0.1", path="../eda-symbol.rnl");
//   @USE-PACKAGE(name="eda-style", version="0.1", path="../eda-style.rnl")
// }
subckt V1_decap GND VDD
    C0 (VDD GND) cfmom_2t nr=28 lr=1.67u w=70n s=70n stm=2 spm=7 multi=2
// @RNL(author="rnl-virtuoso") {
//   %block_symbol = @DEFINE-SYMBOL(box=[-1.1, -3, 1.1, 0]) {
//     @LINE {(0, 0) (0, -1)};
//     @LINE {(-1, -1) (1, -1)};
//     @LINE {(0, -3) (0, -2)};
//     @LINE {(-1, -2) (1, -2)};
//     @LINE {(1.2, -2.8) (1.6, -2.8)};
//     @LINE {(1, -2.2) (1.4, -2.2) (1.4, -2.8)};
//     @LINE {(1.2, -2.8) (1, -3)};
//     @LINE {(1.4, -2.8) (1.2, -3)};
//     @LINE {(1.6, -2.8) (1.4, -3)};
//     ? @TEXT("${name}", size=0.3, halign="start", valign="middle", key="name") => @PLACE(1, 0);
//     (0, 0) @PIN(terminal="VDD");
//     (0, -3) @PIN(terminal="GND")
//   };
//   # @SET-SYMBOL %block_symbol;
//   %symbol_0 = @DEFINE-SYMBOL(box=[-2, -6, 2, 0]) {
//     @LINE {(1, -2.2) (-1, -2.2)};
//     @LINE {(0, 0) (0, -2.2)};
//     @LINE {(0, -2.8) (0, -6)};
//     @ARC {(1, -3.2) (0, -2.8) (-1, -3.2)};
//     ? @TEXT("${name}", size=0.8, halign="start", valign="baseline", key="name") => @PLACE(1.4, 0.1);
//     ? @TEXT("${model}", size=0.8, halign="end", valign="baseline", key="model") => @PLACE(-1.1, 0.3);
//     (0, 0) @PIN(terminal=1);
//     (0, -6) @PIN(terminal=2)
//   };
//   #"C0" @SET-SYMBOL %symbol_0;
//   #"C0" @PLACE(-16, 14) => @ORIENT("R0");
//   %port_0 = $IO_PORT @ATTACH &"VDD" => @PLACE(-30, 14) => @ORIENT("R0");
//   %port_1 = $IO_PORT @ATTACH &"GND" => @PLACE(-30, 8) => @ORIENT("R0");
//   %p0 = (-16, 6);
//   %p1 = (-6, 6);
//   %wire_0 = &"GND" @WIRE(mode="straight") {%p0 %p1};
//   %wire_1 = &"GND" @WIRE(mode="straight") {%p0 #"C0":2};
//   %wire_0 @TEXT("GND", size=1, halign="middle", valign="baseline") => @PLACE(-12, 6.7);
//   %p2 = (-16, 16);
//   %p3 = (-6, 16);
//   %wire_2 = &"VDD" @WIRE(mode="straight") {%p2 %p3};
//   %wire_3 = &"VDD" @WIRE(mode="straight") {#"C0":1 %p2};
//   %wire_2 @TEXT("VDD", size=1, halign="middle", valign="baseline") => @PLACE(-12, 16.7)
// }
// @RNL(author="gemini-4-argon") {
//   @USE-PACKAGE(name="risca-semantics", version="0.3", path="../risca_semantics.rnl");
//   /* V1_decap: MOM Supply Decoupling Capacitor Cell with Substrate Tap (stm=2, spm=7, multi=2) */
//   #"C0"(caps) @AS(role="MOM_supply_decoupling_capacitor", substrate_tap="with_substrate_tap_stm2") $MOM_DECAP;
//   #"C0":1(pin) @AS $SUPPLY_HIGH;
//   #"C0":2(pin) @AS $SUPPLY_LOW;
//   #"C0"(members) @AS $BRANCH;
//   /* Note Box & Author Header (Placed in Empty Region Above Schematic) */
//   (-40, 42.96) @TEXT("Comment by Gemini-4-Argon", size=1.5) => @SET-STYLE $risca_author_style;
//   @RECTANGLE {(-40, 33.01) (94.24, 41.51)} => @SET-STYLE $risca_note_box;
//   (-38, 37.8) @TEXT("V1_decap: 28nm Finger MOM Decoupling Capacitor (cfmom_2t, nr=28, lr=1.67u, w=70n, s=70n, stm=2..7, multi=2) with Substrate Tap", size=1.65) => @SET-STYLE $risca_title_style;
//   (-38, 35.2) @TEXT("Note: Zero static DC current; provides local high-frequency charge reservoir between VDD and GND.", size=1.35) => @SET-STYLE $risca_bias_style
// }
ends V1_decap
