// RNL cell RISCA_JL/LB_inv_trim
// @RNL(type="header") {
//   @VERSION("0.3");
//   @USE-PACKAGE(name="eda-symbol", version="0.1", path="eda-symbol.rnl");
//   @USE-PACKAGE(name="eda-style", version="0.1", path="eda-style.rnl")
// }
subckt LB_inv_trim A GND SN_1 SN_0 SP_1 SP_0 VDD Y
    M6 (net2 GND net4 VDD) pch_mac l=30n w=520.0n multi=1 nf=1 sd=100n \
        ad=3.9e-14 as=3.9e-14 pd=1.19u ps=1.19u nrd=0.386982 nrs=0.386982 \
        sa=75.0n sb=75.0n sa1=75.0n sa2=75.0n sa3=75.0n sa4=75.0n \
        sb1=75.0n sb2=75.0n sb3=75.0n spa=100n spa1=100n spa2=100n \
        spa3=100n sap=91.9776n sapb=114.444n spba=115.715n spba1=117.043n \
        dfm_flag=0 spmt=1.11111e+15 spomt=0 spomt1=1.11111e+60 \
        spmb=1.11111e+15 spomb=0 spomb1=1.11111e+60
    M1 (Y A net2 VDD) pch_mac l=30n w=1.04u multi=1 nf=2 sd=100n \
        ad=5.2e-14 as=7.8e-14 pd=1.24u ps=2.38u nrd=0.214709 nrs=0.214709 \
        sa=112.742n sb=112.742n sa1=93.6047n sa2=112.078n sa3=163.715n \
        sa4=110.059n sb1=93.6047n sb2=112.078n sb3=163.715n spa=100n \
        spa1=100n spa2=100n spa3=100n sap=104.359n sapb=125.813n \
        spba=115.715n spba1=117.043n dfm_flag=0 spmt=1.11111e+15 spomt=0 \
        spomt1=1.11111e+60 spmb=1.11111e+15 spomb=0 spomb1=1.11111e+60
    M3 (net4 GND VDD VDD) pch_mac l=30n w=520.0n multi=1 nf=1 sd=100n \
        ad=3.9e-14 as=3.9e-14 pd=1.19u ps=1.19u nrd=0.386982 nrs=0.386982 \
        sa=75.0n sb=75.0n sa1=75.0n sa2=75.0n sa3=75.0n sa4=75.0n \
        sb1=75.0n sb2=75.0n sb3=75.0n spa=100n spa1=100n spa2=100n \
        spa3=100n sap=91.9776n sapb=114.444n spba=115.715n spba1=117.043n \
        dfm_flag=0 spmt=1.11111e+15 spomt=0 spomt1=1.11111e+60 \
        spmb=1.11111e+15 spomb=0 spomb1=1.11111e+60
    M4 (net2 SP_0 VDD VDD) pch_mac l=30n w=520.0n multi=1 nf=1 sd=100n \
        ad=3.9e-14 as=3.9e-14 pd=1.19u ps=1.19u nrd=0.386982 nrs=0.386982 \
        sa=75.0n sb=75.0n sa1=75.0n sa2=75.0n sa3=75.0n sa4=75.0n \
        sb1=75.0n sb2=75.0n sb3=75.0n spa=100n spa1=100n spa2=100n \
        spa3=100n sap=91.9776n sapb=114.444n spba=115.715n spba1=117.043n \
        dfm_flag=0 spmt=1.11111e+15 spomt=0 spomt1=1.11111e+60 \
        spmb=1.11111e+15 spomb=0 spomb1=1.11111e+60
    M5 (net2 SP_1 VDD VDD) pch_mac l=30n w=2.08u multi=1 nf=4 sd=100n \
        ad=1.04e-13 as=1.3e-13 pd=2.48u ps=3.62u nrd=0.113583 nrs=0.113583 \
        sa=179.203n sb=179.203n sa1=118.069n sa2=174.76n sa3=310.76n \
        sa4=171.966n sb1=118.069n sb2=174.76n sb3=310.76n spa=100n \
        spa1=100n spa2=100n spa3=100n sap=120.952n sapb=140.537n \
        spba=115.715n spba1=117.043n dfm_flag=0 spmt=1.11111e+15 spomt=0 \
        spomt1=1.11111e+60 spmb=1.11111e+15 spomb=0 spomb1=1.11111e+60
    M9 (net5 SN_1 GND GND) nch_mac l=30n w=1.6u multi=1 nf=4 sd=100n \
        ad=8e-14 as=1e-13 pd=2u ps=2.9u nrd=0.336264 nrs=0.336264 \
        sa=179.203n sb=179.203n sa1=118.069n sa2=174.76n sa3=310.76n \
        sa4=171.966n sb1=118.069n sb2=174.76n sb3=310.76n spa=100n \
        spa1=100n spa2=100n spa3=100n sap=120.952n sapb=140.537n \
        spba=115.715n spba1=117.043n dfm_flag=0 spmt=1.11111e+15 spomt=0 \
        spomt1=1.11111e+60 spmb=1.11111e+15 spomb=0 spomb1=1.11111e+60
    M8 (net5 SN_0 GND GND) nch_mac l=30n w=400n multi=1 nf=1 sd=100n \
        ad=3e-14 as=3e-14 pd=950.0n ps=950.0n nrd=0.896976 nrs=0.896976 \
        sa=75.0n sb=75.0n sa1=75.0n sa2=75.0n sa3=75.0n sa4=75.0n \
        sb1=75.0n sb2=75.0n sb3=75.0n spa=100n spa1=100n spa2=100n \
        spa3=100n sap=91.9776n sapb=114.444n spba=115.715n spba1=117.043n \
        dfm_flag=0 spmt=1.11111e+15 spomt=0 spomt1=1.11111e+60 \
        spmb=1.11111e+15 spomb=0 spomb1=1.11111e+60
    M7 (net5 VDD net6 GND) nch_mac l=30n w=400n multi=1 nf=1 sd=100n \
        ad=3e-14 as=3e-14 pd=950.0n ps=950.0n nrd=0.896976 nrs=0.896976 \
        sa=75.0n sb=75.0n sa1=75.0n sa2=75.0n sa3=75.0n sa4=75.0n \
        sb1=75.0n sb2=75.0n sb3=75.0n spa=100n spa1=100n spa2=100n \
        spa3=100n sap=91.9776n sapb=114.444n spba=115.715n spba1=117.043n \
        dfm_flag=0 spmt=1.11111e+15 spomt=0 spomt1=1.11111e+60 \
        spmb=1.11111e+15 spomb=0 spomb1=1.11111e+60
    M0 (Y A net5 GND) nch_mac l=30n w=800n multi=1 nf=2 sd=100n ad=4e-14 \
        as=6e-14 pd=1u ps=1.9u nrd=0.576527 nrs=0.576527 sa=112.742n \
        sb=112.742n sa1=93.6047n sa2=112.078n sa3=163.715n sa4=110.059n \
        sb1=93.6047n sb2=112.078n sb3=163.715n spa=100n spa1=100n \
        spa2=100n spa3=100n sap=104.359n sapb=125.813n spba=115.715n \
        spba1=117.043n dfm_flag=0 spmt=1.11111e+15 spomt=0 \
        spomt1=1.11111e+60 spmb=1.11111e+15 spomb=0 spomb1=1.11111e+60
    M2 (net6 VDD GND GND) nch_mac l=30n w=400n multi=1 nf=1 sd=100n \
        ad=3e-14 as=3e-14 pd=950.0n ps=950.0n nrd=0.896976 nrs=0.896976 \
        sa=75.0n sb=75.0n sa1=75.0n sa2=75.0n sa3=75.0n sa4=75.0n \
        sb1=75.0n sb2=75.0n sb3=75.0n spa=100n spa1=100n spa2=100n \
        spa3=100n sap=91.9776n sapb=114.444n spba=115.715n spba1=117.043n \
        dfm_flag=0 spmt=1.11111e+15 spomt=0 spomt1=1.11111e+60 \
        spmb=1.11111e+15 spomb=0 spomb1=1.11111e+60
// @RNL(author="rnl-virtuoso") {
//   %block_symbol = @DEFINE-SYMBOL(box=[0, -2, 7, 4]) {
//     @LINE {(0, 3) (2, 3)};
//     @LINE {(0, -1) (2, -1)};
//     @LINE {(0, 1) (2, 1)};
//     @LINE {(2, 3) (2, -1)};
//     @LINE {(3, 4) (3, 2.3)};
//     @LINE {(3, -2) (3, -0.4)};
//     @LINE {(2, -1) (5, 1)};
//     @LINE {(2, 3) (5, 1)};
//     (5.5, 1) @CIRCLE(radius=0.5);
//     @LINE {(6, 1) (7, 1)};
//     ? @TEXT("${name}", size=0.4, halign="end", valign="top", key="name") => @PLACE(10, 4);
//     ? @TEXT("${model}", size=0.4, halign="end", valign="baseline", key="model") => @PLACE(8, -2);
//     (0, 3) @PIN(terminal=["SP_1", "SP_0"]);
//     (-1.4, 4) @TEXT("SP<1:0>", size=0.5, halign="start", valign="middle");
//     (0, -1) @PIN(terminal=["SN_1", "SN_0"]);
//     (-1.4, -2) @TEXT("SN<1:0>", size=0.5, halign="start", valign="middle");
//     (0, 1) @PIN(terminal="A");
//     (7, 1) @PIN(terminal="Y");
//     (3, 4) @PIN(terminal="VDD");
//     (3.6, 3) @TEXT("VDD", size=0.5, halign="start", valign="middle");
//     (3, -2) @PIN(terminal="GND");
//     (3.6, -1) @TEXT("GND", size=0.5, halign="start", valign="middle")
//   };
//   # @SET-SYMBOL %block_symbol;
//   %symbol_0 = @DEFINE-SYMBOL(box=[-0.1, -2.8, 3.8, 2.8]) {
//     @LINE {(0, 0) (0.7, 0)};
//     @LINE {(1.5, 1.5) (1.5, -1.5)};
//     @LINE {(2, -1.5) (4, -1.5) (4, -3)};
//     @LINE {(2, 1.5) (4, 1.5) (4, 3)};
//     (1.1, 0) @CIRCLE(radius=0.4);
//     @LINE {(3.7, 2) (2.7, 1.5) (3.7, 1)};
//     @LINE {(2, -1.5) (2, 1.5)};
//     ? @TEXT("${name}", size=0.8, halign="start", valign="baseline", key="name") => @PLACE(4.9, 3.4);
//     ? @TEXT("${model}", size=0.8, halign="end", valign="baseline", key="model") => @PLACE(3.3, 3.2);
//     (4, 3) @PIN(terminal=3);
//     (4, 1) @PIN(terminal=4);
//     (0, 0) @PIN(terminal=2);
//     (4, -3) @PIN(terminal=1)
//   };
//   #"M1" @SET-SYMBOL %symbol_0;
//   #"M1" @PLACE(1, 4) => @ORIENT("R0");
//   #"M3" @SET-SYMBOL %symbol_0;
//   #"M3" @PLACE(1, 20) => @ORIENT("R0");
//   %symbol_1 = @DEFINE-SYMBOL(box=[-0.1, -2.8, 3.8, 2.8]) {
//     @LINE {(2, 1.5) (4, 1.5) (4, 3)};
//     @LINE {(2, -1.5) (2, 1.5)};
//     @LINE {(3, -1) (4, -1.5) (3, -2)};
//     @LINE {(0, 0) (1.5, 0)};
//     @LINE {(1.5, 1.5) (1.5, -1.5)};
//     @LINE {(2, -1.5) (4, -1.5) (4, -3)};
//     ? @TEXT("${name}", size=0.8, halign="start", valign="baseline", key="name") => @PLACE(5, 3.5);
//     ? @TEXT("${model}", size=0.8, halign="end", valign="baseline", key="model") => @PLACE(3.2, 3.2);
//     (4, -1) @PIN(terminal=4);
//     (4, -3) @PIN(terminal=3);
//     (4, 3) @PIN(terminal=1);
//     (0, 0) @PIN(terminal=2)
//   };
//   #"M0" @SET-SYMBOL %symbol_1;
//   #"M0" @PLACE(1, -6) => @ORIENT("R0");
//   #"M2" @SET-SYMBOL %symbol_1;
//   #"M2" @PLACE(1, -23) => @ORIENT("R0");
//   #"M9" @SET-SYMBOL %symbol_1;
//   #"M9" @PLACE(-22, -23) => @ORIENT("R0");
//   #"M4" @SET-SYMBOL %symbol_0;
//   #"M4" @PLACE(-10, 20) => @ORIENT("R0");
//   #"M7" @SET-SYMBOL %symbol_1;
//   #"M7" @PLACE(1, -14) => @ORIENT("R0");
//   #"M8" @SET-SYMBOL %symbol_1;
//   #"M8" @PLACE(-10, -23) => @ORIENT("R0");
//   #"M5" @SET-SYMBOL %symbol_0;
//   #"M5" @PLACE(-21, 20) => @ORIENT("R0");
//   #"M6" @SET-SYMBOL %symbol_0;
//   #"M6" @PLACE(1, 12) => @ORIENT("R0");
//   %port_0 = $IO_PORT @ATTACH &"GND" => @PLACE(-51, 22) => @ORIENT("R0");
//   %port_1 = $IO_PORT @ATTACH &"VDD" => @PLACE(-51, 18) => @ORIENT("R0");
//   %input_port_symbol = @DEFINE-SYMBOL(box=[-2, -1, 0, 1]) {
//       @LINE(fill="linecolor", linestyle="none") {(-2, -0.9) (-2, 0.9) (-0.9, 0.9) (0, 0) (-0.9, -0.9) (-2, -0.9)};
//       (0, 0) @PIN(terminal=1, direction="right");
//       ? @TEXT("${name}", key="name", halign="middle") => @PLACE(-1, 1.6)
//     };
//   %port_2 = $IO_PORT @ATTACH &"A" => @PLACE(-50, 13) => @ORIENT("R0");
//   %port_2 @SET-SYMBOL %input_port_symbol;
//   %port_2 @TEXT("A", key="name");
//   %output_port_symbol = @DEFINE-SYMBOL(box=[0, -1, 2, 1]) {
//       @LINE(fill="linecolor", linestyle="none") {(0, -0.9) (0, 0.9) (1.1, 0.9) (2, 0) (1.1, -0.9) (0, -0.9)};
//       (0, 0) @PIN(terminal=1, direction="left");
//       ? @TEXT("${name}", key="name", halign="middle") => @PLACE(1, 1.6)
//     };
//   %port_3 = $IO_PORT @ATTACH &"Y" => @PLACE(-52, 8) => @ORIENT("R0");
//   %port_3 @SET-SYMBOL %output_port_symbol;
//   %port_3 @TEXT("Y", key="name");
//   %bus_port_type_4 = @DEFINE(roles=[["p", "net"], ["p1", "net"]]) {};
//   %bus_port_type_4_symbol = @DEFINE-SYMBOL {(0, 0) @PIN(terminal=[1, 2])};
//   {&"SN_1" &"SN_0"} @REMOVE-FROM $PORT_FILL_SET;
//   %port_4 = %bus_port_type_4 @ATTACH &"SN_1" &"SN_0" => @PLACE(-50, 3) => @ORIENT("R0");
//   %port_4 @SET-SYMBOL %bus_port_type_4_symbol;
//   %port_4_marker = $IO_PORT @ATTACH &"SN_1" => @PLACE(-50, 3) => @ORIENT("R0");
//   %port_4_marker @SET-SYMBOL %input_port_symbol;
//   %port_4_marker @TEXT("SN<1:0>", key="name");
//   %bus_port_type_5 = @DEFINE(roles=[["p", "net"], ["p1", "net"]]) {};
//   %bus_port_type_5_symbol = @DEFINE-SYMBOL {(0, 0) @PIN(terminal=[1, 2])};
//   {&"SP_1" &"SP_0"} @REMOVE-FROM $PORT_FILL_SET;
//   %port_5 = %bus_port_type_5 @ATTACH &"SP_1" &"SP_0" => @PLACE(-50, -2) => @ORIENT("R0");
//   %port_5 @SET-SYMBOL %bus_port_type_5_symbol;
//   %port_5_marker = $IO_PORT @ATTACH &"SP_1" => @PLACE(-50, -2) => @ORIENT("R0");
//   %port_5_marker @SET-SYMBOL %input_port_symbol;
//   %port_5_marker @TEXT("SP<1:0>", key="name");
//   %wire_0 = &"net6" @WIRE(mode="straight") {#"M2":1 #"M7":3};
//   %p0 = (-21, 30);
//   %wire_1 = &"SP_1" @WIRE(mode="straight") {#"M5":2 %p0};
//   %wire_1 @TEXT("SP\_1", size=1, halign="middle", valign="baseline", rotate=90) => @PLACE(-21.7, 28);
//   %p1 = (-10, 30);
//   %wire_2 = &"SP_0" @WIRE(mode="straight") {#"M4":2 %p1};
//   %wire_2 @TEXT("SP\_0", size=1, halign="middle", valign="baseline", rotate=90) => @PLACE(-10.7, 28);
//   %p2 = (-22, -34);
//   %wire_3 = &"SN_1" @WIRE(mode="straight") {%p2 #"M9":2};
//   %wire_3 @TEXT("SN\_1", size=1, halign="middle", valign="baseline", rotate=90) => @PLACE(-22.7, -32);
//   %p3 = (-10, -34);
//   %wire_4 = &"SN_0" @WIRE(mode="straight") {%p3 #"M8":2};
//   %wire_4 @TEXT("SN\_0", size=1, halign="middle", valign="baseline", rotate=90) => @PLACE(-10.7, -32);
//   %p4 = (-28, -1);
//   %p5 = (1, -1);
//   %wire_5 = &"A" @WIRE(mode="straight") {%p4 %p5};
//   %wire_6 = &"A" @WIRE(mode="straight") {%p5 #"M1":2};
//   %wire_7 = &"A" @WIRE(mode="straight") {#"M0":2 %p5};
//   %wire_5 @TEXT("A", size=1, halign="middle", valign="baseline") => @PLACE(-26, -0.3);
//   %p6 = (5, -1);
//   %p7 = (15, -1);
//   %wire_8 = &"Y" @WIRE(mode="straight") {%p6 %p7};
//   %wire_9 = &"Y" @WIRE(mode="straight") {#"M0":1 %p6};
//   %wire_10 = &"Y" @WIRE(mode="straight") {%p6 #"M1":1};
//   %wire_8 @TEXT("Y", size=1, halign="middle", valign="baseline") => @PLACE(14, -0.3);
//   %p8 = (-6, -10);
//   %p9 = (5, -10);
//   %wire_11 = &"net5" @WIRE(mode="straight") {%p8 %p9};
//   %wire_12 = &"net5" @WIRE(mode="straight") {#"M8":1 %p8};
//   %wire_13 = &"net5" @WIRE(mode="straight") {%p9 #"M0":3};
//   %wire_14 = &"net5" @WIRE(mode="straight") {#"M9":1 #"M8":1};
//   %wire_15 = &"net5" @WIRE(mode="straight") {#"M7":1 %p9};
//   %wire_16 = &"net4" @WIRE(mode="straight") {#"M6":3 #"M3":1};
//   %p10 = (-6, 8);
//   %wire_17 = &"net2" @WIRE(mode="straight") {%p10 #"M4":1};
//   %p11 = (5, 8);
//   %wire_18 = &"net2" @WIRE(mode="straight") {#"M1":3 %p11};
//   %wire_19 = &"net2" @WIRE(mode="straight") {%p10 %p11};
//   %wire_20 = &"net2" @WIRE(mode="straight") {%p11 #"M6":1};
//   %wire_21 = &"net2" @WIRE(mode="straight") {#"M5":1 #"M4":1};
//   %p12 = (-3, -14);
//   %wire_22 = &"VDD" @WIRE(mode="straight") {%p12 #"M7":2};
//   %p13 = (7, 13);
//   %wire_23 = &"VDD" @WIRE(mode="straight") {#"M6":4 %p13};
//   %p14 = (-4, 23);
//   %wire_24 = &"VDD" @WIRE(mode="straight") {%p14 #"M3":3};
//   %p15 = (7, 21);
//   %wire_25 = &"VDD" @WIRE(mode="straight") {%p13 %p15};
//   %p16 = (-4, 21);
//   %wire_26 = &"VDD" @WIRE(mode="straight") {%p16 %p14};
//   %wire_27 = &"VDD" @WIRE(mode="straight") {#"M4":4 %p16};
//   %p17 = (-15, 21);
//   %p18 = (-15, 23);
//   %wire_28 = &"VDD" @WIRE(mode="straight") {%p17 %p18};
//   %wire_29 = &"VDD" @WIRE(mode="straight") {%p18 #"M4":3};
//   %wire_30 = &"VDD" @WIRE(mode="straight") {#"M5":3 %p18};
//   %p19 = (7, 23);
//   %wire_31 = &"VDD" @WIRE(mode="straight") {#"M3":3 %p19};
//   %wire_32 = &"VDD" @WIRE(mode="straight") {%p15 %p19};
//   %wire_33 = &"VDD" @WIRE(mode="straight") {#"M3":4 %p15};
//   %p20 = (7, 5);
//   %wire_34 = &"VDD" @WIRE(mode="straight") {%p20 %p13};
//   %wire_35 = &"VDD" @WIRE(mode="straight") {#"M1":4 %p20};
//   %wire_36 = &"VDD" @WIRE(mode="straight") {#"M5":4 %p17};
//   %p21 = (-3, -23);
//   %wire_37 = &"VDD" @WIRE(mode="straight") {%p21 #"M2":2};
//   %wire_38 = &"VDD" @WIRE(mode="straight") {#"M4":3 %p14};
//   %wire_37 @TEXT("VDD", size=1, halign="middle", valign="baseline") => @PLACE(-1, -22.3);
//   %wire_31 @TEXT("VDD", size=1, halign="middle", valign="baseline") => @PLACE(6, 23.7);
//   %wire_22 @TEXT("VDD", size=1, halign="middle", valign="baseline") => @PLACE(-1, -13.3);
//   %p22 = (-4, -26);
//   %wire_39 = &"GND" @WIRE(mode="straight") {%p22 #"M2":3};
//   %p23 = (-16, -24);
//   %wire_40 = &"GND" @WIRE(mode="straight") {#"M9":4 %p23};
//   %p24 = (-16, -26);
//   %wire_41 = &"GND" @WIRE(mode="straight") {%p24 %p23};
//   %wire_42 = &"GND" @WIRE(mode="straight") {#"M8":3 %p22};
//   %wire_43 = &"GND" @WIRE(mode="straight") {#"M9":3 %p24};
//   %p25 = (-4, -24);
//   %wire_44 = &"GND" @WIRE(mode="straight") {%p22 %p25};
//   %wire_45 = &"GND" @WIRE(mode="straight") {#"M8":4 %p25};
//   %wire_46 = &"GND" @WIRE(mode="straight") {%p24 #"M8":3};
//   %p26 = (7, -15);
//   %wire_47 = &"GND" @WIRE(mode="straight") {#"M7":4 %p26};
//   %p27 = (7, -7);
//   %wire_48 = &"GND" @WIRE(mode="straight") {%p26 %p27};
//   %p28 = (-1, 12);
//   %wire_49 = &"GND" @WIRE(mode="straight") {#"M6":2 %p28};
//   %p29 = (7, -24);
//   %wire_50 = &"GND" @WIRE(mode="straight") {%p29 %p26};
//   %p30 = (7, -26);
//   %wire_51 = &"GND" @WIRE(mode="straight") {#"M2":3 %p30};
//   %wire_52 = &"GND" @WIRE(mode="straight") {%p30 %p29};
//   %wire_53 = &"GND" @WIRE(mode="straight") {#"M2":4 %p29};
//   %p31 = (-1, 20);
//   %wire_54 = &"GND" @WIRE(mode="straight") {#"M3":2 %p31};
//   %wire_55 = &"GND" @WIRE(mode="straight") {#"M0":4 %p27};
//   %wire_51 @TEXT("GND", size=1, halign="middle", valign="baseline") => @PLACE(6, -27.3);
//   %wire_54 @TEXT("GND", size=1, halign="middle", valign="top") => @PLACE(0, 21.3);
//   %wire_49 @TEXT("GND", size=1, halign="middle", valign="top") => @PLACE(0, 13.3);
//   $JUNCTION @ATTACH %p5;
//   $JUNCTION @ATTACH %p6;
//   $JUNCTION @ATTACH %p9;
//   $JUNCTION @ATTACH %p11;
//   $JUNCTION @ATTACH %p13;
//   $JUNCTION @ATTACH %p14;
//   $JUNCTION @ATTACH %p15;
//   $JUNCTION @ATTACH %p18;
//   $JUNCTION @ATTACH %p22;
//   $JUNCTION @ATTACH %p24;
//   $JUNCTION @ATTACH %p26;
//   $JUNCTION @ATTACH %p29
// }
// @RNL(author="gemini-4-argon") {
//   @USE-PACKAGE(name="risca-semantics", version="0.3", path="risca_semantics.rnl");
//   /* LB_inv_trim: 4-Bit Digitally Current-Starved Delay-Trimmed Inverter for Async SAR Loop Timing */
//   {#"M1" #"M0"}(core_inverter) {#"M3" #"M6" #"M4" #"M5"}(pmos_header_bank) {#"M7" #"M2" #"M8" #"M9"}(nmos_footer_bank) @AS(role="current_starved_delay_trimmed_inverter", tuning_bits="2b_SP_plus_2b_SN") $STARVED_DELAY_INV;
//   {#"M3" #"M6" #"M4" #"M5"}(members) @AS $MATCHED;
//   {#"M7" #"M2" #"M8" #"M9"}(members) @AS $MATCHED;
//   {#"M3" #"M6" #"M1" #"M0" #"M7" #"M2"}(members) @AS $BRANCH;
//   {%p4 #"M1" %p7}(path) @AS(direction="left-to-right") $FLOW;
//   {%p4 #"M0" %p7}(path) @AS(direction="left-to-right") $FLOW;
//   #"M3":3(pin) @AS $SUPPLY_HIGH;
//   #"M4":3(pin) @AS $SUPPLY_HIGH;
//   #"M5":3(pin) @AS $SUPPLY_HIGH;
//   #"M2":3(pin) @AS $SUPPLY_LOW;
//   #"M8":3(pin) @AS $SUPPLY_LOW;
//   #"M9":3(pin) @AS $SUPPLY_LOW;
//   {#"M4" #"M8"}(members) @AS $BRANCH;
//   {#"M5" #"M9"}(members) @AS $BRANCH;
//   /* Note Box & Author Header (Placed in Empty Region Above Schematic) */
//   (-63, 66.29) @TEXT("Comment by Gemini-4-Argon", size=2) => @SET-STYLE $risca_author_style;
//   @RECTANGLE {(-63, 49.02) (74.23, 64.29)} => @SET-STYLE $risca_note_box;
//   (-60, 59.24) @TEXT("LB_inv_trim: 4-Bit Current-Starved Delay-Tuned CMOS Inverter (Async SAR Loop Delay Element)", size=2.2) => @SET-STYLE $risca_title_style;
//   (-60, 55.64) @TEXT("PMOS Header (VDD->net2): Always-on 0.5x series path (M3+M6, w=520n, gate=GND) + SP_0 (M4, 1x=520n) + SP_1 (M5, 4x=2.08u).", size=1.8) => @SET-STYLE $risca_digital_style;
//   (-60, 52.04) @TEXT("NMOS Footer (net5->GND): Always-on 0.5x series path (M7+M2, w=400n, gate=VDD) + SN_0 (M8, 1x=400n) + SN_1 (M9, 4x=1.6u).", size=1.8) => @SET-STYLE $risca_digital_style
// }
ends LB_inv_trim
