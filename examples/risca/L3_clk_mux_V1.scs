// RNL cell RISCA_JL/L3_clk_mux_V1
// @RNL(type="header") { @USE-PACKAGE(name="rnl-std-all", version="0.4"); @USE-PACKAGE(name="rnl-std-semantics", version="0.4");
//   @VERSION("0.4");
//   @USE-PACKAGE(name="eda-symbol", version="0.2", path="eda-symbol.rnl");
//   @USE-PACKAGE(name="eda-style", version="0.2", path="eda-style.rnl")
// }
// @RNL { # @SELECT-PIN(recursive=true) => @REMOVE-FROM $LABEL_FILL_SET; $SUPPLY_NET_SET @REMOVE-FROM $PORT_FILL_SET; $GROUND_NET_SET @REMOVE-FROM $PORT_FILL_SET }
subckt L3_clk_mux_V1 FRAME_15 FRAME_14 FRAME_13 FRAME_12 FRAME_11 FRAME_10 \
        FRAME_9 FRAME_8 FRAME_7 FRAME_6 FRAME_5 FRAME_4 FRAME_3 FRAME_2 \
        FRAME_1 FRAME_0 GND OUT_23 OUT_22 OUT_21 OUT_20 OUT_19 OUT_18 \
        OUT_17 OUT_16 OUT_15 OUT_14 OUT_13 OUT_12 OUT_11 OUT_10 OUT_9 \
        OUT_8 OUT_7 OUT_6 OUT_5 OUT_4 OUT_3 OUT_2 OUT_1 OUT_0 REPET_17 \
        REPET_16 REPET_15 REPET_14 REPET_13 REPET_12 REPET_11 REPET_10 \
        REPET_9 REPET_8 REPET_7 REPET_6 REPET_5 REPET_4 REPET_3 REPET_2 \
        REPET_1 RST SCKI SCKO SDI SDO VDD
    I1224 (net116 net352 VDD GND) INVD4BWP12T30P140
    I1602 (net352 net460 VDD GND) INVD4BWP12T30P140
    I1596 (net352 net508 VDD GND) INVD4BWP12T30P140
    I1182 (net352 net89 VDD GND) INVD4BWP12T30P140
    I1271 (net352 net79 VDD GND) INVD4BWP12T30P140
    I942 (net352 net258 VDD GND) INVD4BWP12T30P140
    I1142 (net352 net217 VDD GND) INVD4BWP12T30P140
    I1288 (net352 net110 VDD GND) INVD4BWP12T30P140
    I1062 (net352 net240 VDD GND) INVD4BWP12T30P140
    I1407 (net352 net198 VDD GND) INVD4BWP12T30P140
    I982 (net352 net191 VDD GND) INVD4BWP12T30P140
    I782 (net352 net21 VDD GND) INVD4BWP12T30P140
    I768 (net352 net9 VDD GND) INVD4BWP12T30P140
    I822 (net352 net445 VDD GND) INVD4BWP12T30P140
    I1424 (net352 net408 VDD GND) INVD4BWP12T30P140
    I1356 (net352 net154 VDD GND) INVD4BWP12T30P140
    I902 (net352 net32 VDD GND) INVD4BWP12T30P140
    I862 (net352 net364 VDD GND) INVD4BWP12T30P140
    I1373 (net352 net186 VDD GND) INVD4BWP12T30P140
    I1022 (net352 net178 VDD GND) INVD4BWP12T30P140
    I1390 (net352 net135 VDD GND) INVD4BWP12T30P140
    I1339 (net352 net62 VDD GND) INVD4BWP12T30P140
    I1305 (net352 net42 VDD GND) INVD4BWP12T30P140
    I1102 (net352 net164 VDD GND) INVD4BWP12T30P140
    I1221 (REPET_4 net571 VDD GND) INVD4BWP12T30P140
    I1637 (RST net2 VDD GND) INVD4BWP12T30P140
    I1322 (net352 net243 VDD GND) INVD4BWP12T30P140
    I1456 (REPET_9 net550 VDD GND) INVD4BWP12T30P140
    I1454 (net571 net573 VDD GND) INVD4BWP12T30P140
    I1455 (net550 net552 VDD GND) INVD4BWP12T30P140
    M44 (net14 net573 net15 GND) nch_mac l=30n w=900n multi=1 nf=3 sd=100n \
        ad=5.25e-14 as=5.25e-14 pd=1.55u ps=1.55u nrd=0.671741 \
        nrs=0.671741 sa=147.042n sb=147.042n sa1=107.158n sa2=144.915n \
        sa3=241.797n sa4=141.98n sb1=107.158n sb2=144.915n sb3=241.797n \
        spa=100n spa1=100n spa2=100n spa3=100n sap=113.519n sapb=134.009n \
        spba=115.715n spba1=117.043n dfm_flag=0 spmt=1.11111e+15 spomt=0 \
        spomt1=1.11111e+60 spmb=1.11111e+15 spomb=0 spomb1=1.11111e+60
    M165 (net257 net552 net254 GND) nch_mac l=30n w=900n multi=1 nf=3 \
        sd=100n ad=5.25e-14 as=5.25e-14 pd=1.55u ps=1.55u nrd=0.671741 \
        nrs=0.671741 sa=147.042n sb=147.042n sa1=107.158n sa2=144.915n \
        sa3=241.797n sa4=141.98n sb1=107.158n sb2=144.915n sb3=241.797n \
        spa=100n spa1=100n spa2=100n spa3=100n sap=113.519n sapb=134.009n \
        spba=115.715n spba1=117.043n dfm_flag=0 spmt=1.11111e+15 spomt=0 \
        spomt1=1.11111e+60 spmb=1.11111e+15 spomb=0 spomb1=1.11111e+60
    M176 (net546 net573 net561 GND) nch_mac l=30n w=900n multi=1 nf=3 \
        sd=100n ad=5.25e-14 as=5.25e-14 pd=1.55u ps=1.55u nrd=0.671741 \
        nrs=0.671741 sa=147.042n sb=147.042n sa1=107.158n sa2=144.915n \
        sa3=241.797n sa4=141.98n sb1=107.158n sb2=144.915n sb3=241.797n \
        spa=100n spa1=100n spa2=100n spa3=100n sap=113.519n sapb=134.009n \
        spba=115.715n spba1=117.043n dfm_flag=0 spmt=1.11111e+15 spomt=0 \
        spomt1=1.11111e+60 spmb=1.11111e+15 spomb=0 spomb1=1.11111e+60
    M175 (net511 net552 net546 GND) nch_mac l=30n w=900n multi=1 nf=3 \
        sd=100n ad=5.25e-14 as=5.25e-14 pd=1.55u ps=1.55u nrd=0.671741 \
        nrs=0.671741 sa=147.042n sb=147.042n sa1=107.158n sa2=144.915n \
        sa3=241.797n sa4=141.98n sb1=107.158n sb2=144.915n sb3=241.797n \
        spa=100n spa1=100n spa2=100n spa3=100n sap=113.519n sapb=134.009n \
        spba=115.715n spba1=117.043n dfm_flag=0 spmt=1.11111e+15 spomt=0 \
        spomt1=1.11111e+60 spmb=1.11111e+15 spomb=0 spomb1=1.11111e+60
    M139 (net347 net573 net319 GND) nch_mac l=30n w=900n multi=1 nf=3 \
        sd=100n ad=5.25e-14 as=5.25e-14 pd=1.55u ps=1.55u nrd=0.671741 \
        nrs=0.671741 sa=147.042n sb=147.042n sa1=107.158n sa2=144.915n \
        sa3=241.797n sa4=141.98n sb1=107.158n sb2=144.915n sb3=241.797n \
        spa=100n spa1=100n spa2=100n spa3=100n sap=113.519n sapb=134.009n \
        spba=115.715n spba1=117.043n dfm_flag=0 spmt=1.11111e+15 spomt=0 \
        spomt1=1.11111e+60 spmb=1.11111e+15 spomb=0 spomb1=1.11111e+60
    M133 (net361 net573 net489 GND) nch_mac l=30n w=900n multi=1 nf=3 \
        sd=100n ad=5.25e-14 as=5.25e-14 pd=1.55u ps=1.55u nrd=0.671741 \
        nrs=0.671741 sa=147.042n sb=147.042n sa1=107.158n sa2=144.915n \
        sa3=241.797n sa4=141.98n sb1=107.158n sb2=144.915n sb3=241.797n \
        spa=100n spa1=100n spa2=100n spa3=100n sap=113.519n sapb=134.009n \
        spba=115.715n spba1=117.043n dfm_flag=0 spmt=1.11111e+15 spomt=0 \
        spomt1=1.11111e+60 spmb=1.11111e+15 spomb=0 spomb1=1.11111e+60
    M154 (net216 net552 net223 GND) nch_mac l=30n w=900n multi=1 nf=3 \
        sd=100n ad=5.25e-14 as=5.25e-14 pd=1.55u ps=1.55u nrd=0.671741 \
        nrs=0.671741 sa=147.042n sb=147.042n sa1=107.158n sa2=144.915n \
        sa3=241.797n sa4=141.98n sb1=107.158n sb2=144.915n sb3=241.797n \
        spa=100n spa1=100n spa2=100n spa3=100n sap=113.519n sapb=134.009n \
        spba=115.715n spba1=117.043n dfm_flag=0 spmt=1.11111e+15 spomt=0 \
        spomt1=1.11111e+60 spmb=1.11111e+15 spomb=0 spomb1=1.11111e+60
    M157 (net163 net552 net419 GND) nch_mac l=30n w=900n multi=1 nf=3 \
        sd=100n ad=5.25e-14 as=5.25e-14 pd=1.55u ps=1.55u nrd=0.671741 \
        nrs=0.671741 sa=147.042n sb=147.042n sa1=107.158n sa2=144.915n \
        sa3=241.797n sa4=141.98n sb1=107.158n sb2=144.915n sb3=241.797n \
        spa=100n spa1=100n spa2=100n spa3=100n sap=113.519n sapb=134.009n \
        spba=115.715n spba1=117.043n dfm_flag=0 spmt=1.11111e+15 spomt=0 \
        spomt1=1.11111e+60 spmb=1.11111e+15 spomb=0 spomb1=1.11111e+60
    M153 (net335 net552 net345 GND) nch_mac l=30n w=900n multi=1 nf=3 \
        sd=100n ad=5.25e-14 as=5.25e-14 pd=1.55u ps=1.55u nrd=0.671741 \
        nrs=0.671741 sa=147.042n sb=147.042n sa1=107.158n sa2=144.915n \
        sa3=241.797n sa4=141.98n sb1=107.158n sb2=144.915n sb3=241.797n \
        spa=100n spa1=100n spa2=100n spa3=100n sap=113.519n sapb=134.009n \
        spba=115.715n spba1=117.043n dfm_flag=0 spmt=1.11111e+15 spomt=0 \
        spomt1=1.11111e+60 spmb=1.11111e+15 spomb=0 spomb1=1.11111e+60
    M138 (net265 net573 net195 GND) nch_mac l=30n w=900n multi=1 nf=3 \
        sd=100n ad=5.25e-14 as=5.25e-14 pd=1.55u ps=1.55u nrd=0.671741 \
        nrs=0.671741 sa=147.042n sb=147.042n sa1=107.158n sa2=144.915n \
        sa3=241.797n sa4=141.98n sb1=107.158n sb2=144.915n sb3=241.797n \
        spa=100n spa1=100n spa2=100n spa3=100n sap=113.519n sapb=134.009n \
        spba=115.715n spba1=117.043n dfm_flag=0 spmt=1.11111e+15 spomt=0 \
        spomt1=1.11111e+60 spmb=1.11111e+15 spomb=0 spomb1=1.11111e+60
    M158 (net183 net552 net225 GND) nch_mac l=30n w=900n multi=1 nf=3 \
        sd=100n ad=5.25e-14 as=5.25e-14 pd=1.55u ps=1.55u nrd=0.671741 \
        nrs=0.671741 sa=147.042n sb=147.042n sa1=107.158n sa2=144.915n \
        sa3=241.797n sa4=141.98n sb1=107.158n sb2=144.915n sb3=241.797n \
        spa=100n spa1=100n spa2=100n spa3=100n sap=113.519n sapb=134.009n \
        spba=115.715n spba1=117.043n dfm_flag=0 spmt=1.11111e+15 spomt=0 \
        spomt1=1.11111e+60 spmb=1.11111e+15 spomb=0 spomb1=1.11111e+60
    M137 (net254 net573 net214 GND) nch_mac l=30n w=900n multi=1 nf=3 \
        sd=100n ad=5.25e-14 as=5.25e-14 pd=1.55u ps=1.55u nrd=0.671741 \
        nrs=0.671741 sa=147.042n sb=147.042n sa1=107.158n sa2=144.915n \
        sa3=241.797n sa4=141.98n sb1=107.158n sb2=144.915n sb3=241.797n \
        spa=100n spa1=100n spa2=100n spa3=100n sap=113.519n sapb=134.009n \
        spba=115.715n spba1=117.043n dfm_flag=0 spmt=1.11111e+15 spomt=0 \
        spomt1=1.11111e+60 spmb=1.11111e+15 spomb=0 spomb1=1.11111e+60
    M152 (net119 net552 net123 GND) nch_mac l=30n w=900n multi=1 nf=3 \
        sd=100n ad=5.25e-14 as=5.25e-14 pd=1.55u ps=1.55u nrd=0.671741 \
        nrs=0.671741 sa=147.042n sb=147.042n sa1=107.158n sa2=144.915n \
        sa3=241.797n sa4=141.98n sb1=107.158n sb2=144.915n sb3=241.797n \
        spa=100n spa1=100n spa2=100n spa3=100n sap=113.519n sapb=134.009n \
        spba=115.715n spba1=117.043n dfm_flag=0 spmt=1.11111e+15 spomt=0 \
        spomt1=1.11111e+60 spmb=1.11111e+15 spomb=0 spomb1=1.11111e+60
    M159 (net293 net552 net239 GND) nch_mac l=30n w=900n multi=1 nf=3 \
        sd=100n ad=5.25e-14 as=5.25e-14 pd=1.55u ps=1.55u nrd=0.671741 \
        nrs=0.671741 sa=147.042n sb=147.042n sa1=107.158n sa2=144.915n \
        sa3=241.797n sa4=141.98n sb1=107.158n sb2=144.915n sb3=241.797n \
        spa=100n spa1=100n spa2=100n spa3=100n sap=113.519n sapb=134.009n \
        spba=115.715n spba1=117.043n dfm_flag=0 spmt=1.11111e+15 spomt=0 \
        spomt1=1.11111e+60 spmb=1.11111e+15 spomb=0 spomb1=1.11111e+60
    M156 (net132 net552 net211 GND) nch_mac l=30n w=900n multi=1 nf=3 \
        sd=100n ad=5.25e-14 as=5.25e-14 pd=1.55u ps=1.55u nrd=0.671741 \
        nrs=0.671741 sa=147.042n sb=147.042n sa1=107.158n sa2=144.915n \
        sa3=241.797n sa4=141.98n sb1=107.158n sb2=144.915n sb3=241.797n \
        spa=100n spa1=100n spa2=100n spa3=100n sap=113.519n sapb=134.009n \
        spba=115.715n spba1=117.043n dfm_flag=0 spmt=1.11111e+15 spomt=0 \
        spomt1=1.11111e+60 spmb=1.11111e+15 spomb=0 spomb1=1.11111e+60
    M140 (net169 net573 net298 GND) nch_mac l=30n w=900n multi=1 nf=3 \
        sd=100n ad=5.25e-14 as=5.25e-14 pd=1.55u ps=1.55u nrd=0.671741 \
        nrs=0.671741 sa=147.042n sb=147.042n sa1=107.158n sa2=144.915n \
        sa3=241.797n sa4=141.98n sb1=107.158n sb2=144.915n sb3=241.797n \
        spa=100n spa1=100n spa2=100n spa3=100n sap=113.519n sapb=134.009n \
        spba=115.715n spba1=117.043n dfm_flag=0 spmt=1.11111e+15 spomt=0 \
        spomt1=1.11111e+60 spmb=1.11111e+15 spomb=0 spomb1=1.11111e+60
    M160 (net310 net552 net367 GND) nch_mac l=30n w=900n multi=1 nf=3 \
        sd=100n ad=5.25e-14 as=5.25e-14 pd=1.55u ps=1.55u nrd=0.671741 \
        nrs=0.671741 sa=147.042n sb=147.042n sa1=107.158n sa2=144.915n \
        sa3=241.797n sa4=141.98n sb1=107.158n sb2=144.915n sb3=241.797n \
        spa=100n spa1=100n spa2=100n spa3=100n sap=113.519n sapb=134.009n \
        spba=115.715n spba1=117.043n dfm_flag=0 spmt=1.11111e+15 spomt=0 \
        spomt1=1.11111e+60 spmb=1.11111e+15 spomb=0 spomb1=1.11111e+60
    M131 (net516 net573 net464 GND) nch_mac l=30n w=900n multi=1 nf=3 \
        sd=100n ad=5.25e-14 as=5.25e-14 pd=1.55u ps=1.55u nrd=0.671741 \
        nrs=0.671741 sa=147.042n sb=147.042n sa1=107.158n sa2=144.915n \
        sa3=241.797n sa4=141.98n sb1=107.158n sb2=144.915n sb3=241.797n \
        spa=100n spa1=100n spa2=100n spa3=100n sap=113.519n sapb=134.009n \
        spba=115.715n spba1=117.043n dfm_flag=0 spmt=1.11111e+15 spomt=0 \
        spomt1=1.11111e+60 spmb=1.11111e+15 spomb=0 spomb1=1.11111e+60
    M161 (net177 net552 net172 GND) nch_mac l=30n w=900n multi=1 nf=3 \
        sd=100n ad=5.25e-14 as=5.25e-14 pd=1.55u ps=1.55u nrd=0.671741 \
        nrs=0.671741 sa=147.042n sb=147.042n sa1=107.158n sa2=144.915n \
        sa3=241.797n sa4=141.98n sb1=107.158n sb2=144.915n sb3=241.797n \
        spa=100n spa1=100n spa2=100n spa3=100n sap=113.519n sapb=134.009n \
        spba=115.715n spba1=117.043n dfm_flag=0 spmt=1.11111e+15 spomt=0 \
        spomt1=1.11111e+60 spmb=1.11111e+15 spomb=0 spomb1=1.11111e+60
    M132 (net77 net573 net452 GND) nch_mac l=30n w=900n multi=1 nf=3 \
        sd=100n ad=5.25e-14 as=5.25e-14 pd=1.55u ps=1.55u nrd=0.671741 \
        nrs=0.671741 sa=147.042n sb=147.042n sa1=107.158n sa2=144.915n \
        sa3=241.797n sa4=141.98n sb1=107.158n sb2=144.915n sb3=241.797n \
        spa=100n spa1=100n spa2=100n spa3=100n sap=113.519n sapb=134.009n \
        spba=115.715n spba1=117.043n dfm_flag=0 spmt=1.11111e+15 spomt=0 \
        spomt1=1.11111e+60 spmb=1.11111e+15 spomb=0 spomb1=1.11111e+60
    M155 (net61 net552 net169 GND) nch_mac l=30n w=900n multi=1 nf=3 \
        sd=100n ad=5.25e-14 as=5.25e-14 pd=1.55u ps=1.55u nrd=0.671741 \
        nrs=0.671741 sa=147.042n sb=147.042n sa1=107.158n sa2=144.915n \
        sa3=241.797n sa4=141.98n sb1=107.158n sb2=144.915n sb3=241.797n \
        spa=100n spa1=100n spa2=100n spa3=100n sap=113.519n sapb=134.009n \
        spba=115.715n spba1=117.043n dfm_flag=0 spmt=1.11111e+15 spomt=0 \
        spomt1=1.11111e+60 spmb=1.11111e+15 spomb=0 spomb1=1.11111e+60
    M134 (net148 net573 net368 GND) nch_mac l=30n w=900n multi=1 nf=3 \
        sd=100n ad=5.25e-14 as=5.25e-14 pd=1.55u ps=1.55u nrd=0.671741 \
        nrs=0.671741 sa=147.042n sb=147.042n sa1=107.158n sa2=144.915n \
        sa3=241.797n sa4=141.98n sb1=107.158n sb2=144.915n sb3=241.797n \
        spa=100n spa1=100n spa2=100n spa3=100n sap=113.519n sapb=134.009n \
        spba=115.715n spba1=117.043n dfm_flag=0 spmt=1.11111e+15 spomt=0 \
        spomt1=1.11111e+60 spmb=1.11111e+15 spomb=0 spomb1=1.11111e+60
    M135 (net206 net573 net22 GND) nch_mac l=30n w=900n multi=1 nf=3 \
        sd=100n ad=5.25e-14 as=5.25e-14 pd=1.55u ps=1.55u nrd=0.671741 \
        nrs=0.671741 sa=147.042n sb=147.042n sa1=107.158n sa2=144.915n \
        sa3=241.797n sa4=141.98n sb1=107.158n sb2=144.915n sb3=241.797n \
        spa=100n spa1=100n spa2=100n spa3=100n sap=113.519n sapb=134.009n \
        spba=115.715n spba1=117.043n dfm_flag=0 spmt=1.11111e+15 spomt=0 \
        spomt1=1.11111e+60 spmb=1.11111e+15 spomb=0 spomb1=1.11111e+60
    M151 (net420 net552 net431 GND) nch_mac l=30n w=900n multi=1 nf=3 \
        sd=100n ad=5.25e-14 as=5.25e-14 pd=1.55u ps=1.55u nrd=0.671741 \
        nrs=0.671741 sa=147.042n sb=147.042n sa1=107.158n sa2=144.915n \
        sa3=241.797n sa4=141.98n sb1=107.158n sb2=144.915n sb3=241.797n \
        spa=100n spa1=100n spa2=100n spa3=100n sap=113.519n sapb=134.009n \
        spba=115.715n spba1=117.043n dfm_flag=0 spmt=1.11111e+15 spomt=0 \
        spomt1=1.11111e+60 spmb=1.11111e+15 spomb=0 spomb1=1.11111e+60
    M141 (net172 net573 net173 GND) nch_mac l=30n w=900n multi=1 nf=3 \
        sd=100n ad=5.25e-14 as=5.25e-14 pd=1.55u ps=1.55u nrd=0.671741 \
        nrs=0.671741 sa=147.042n sb=147.042n sa1=107.158n sa2=144.915n \
        sa3=241.797n sa4=141.98n sb1=107.158n sb2=144.915n sb3=241.797n \
        spa=100n spa1=100n spa2=100n spa3=100n sap=113.519n sapb=134.009n \
        spba=115.715n spba1=117.043n dfm_flag=0 spmt=1.11111e+15 spomt=0 \
        spomt1=1.11111e+60 spmb=1.11111e+15 spomb=0 spomb1=1.11111e+60
    M142 (net367 net573 net187 GND) nch_mac l=30n w=900n multi=1 nf=3 \
        sd=100n ad=5.25e-14 as=5.25e-14 pd=1.55u ps=1.55u nrd=0.671741 \
        nrs=0.671741 sa=147.042n sb=147.042n sa1=107.158n sa2=144.915n \
        sa3=241.797n sa4=141.98n sb1=107.158n sb2=144.915n sb3=241.797n \
        spa=100n spa1=100n spa2=100n spa3=100n sap=113.519n sapb=134.009n \
        spba=115.715n spba1=117.043n dfm_flag=0 spmt=1.11111e+15 spomt=0 \
        spomt1=1.11111e+60 spmb=1.11111e+15 spomb=0 spomb1=1.11111e+60
    M146 (net211 net573 net334 GND) nch_mac l=30n w=900n multi=1 nf=3 \
        sd=100n ad=5.25e-14 as=5.25e-14 pd=1.55u ps=1.55u nrd=0.671741 \
        nrs=0.671741 sa=147.042n sb=147.042n sa1=107.158n sa2=144.915n \
        sa3=241.797n sa4=141.98n sb1=107.158n sb2=144.915n sb3=241.797n \
        spa=100n spa1=100n spa2=100n spa3=100n sap=113.519n sapb=134.009n \
        spba=115.715n spba1=117.043n dfm_flag=0 spmt=1.11111e+15 spomt=0 \
        spomt1=1.11111e+60 spmb=1.11111e+15 spomb=0 spomb1=1.11111e+60
    M145 (net419 net573 net373 GND) nch_mac l=30n w=900n multi=1 nf=3 \
        sd=100n ad=5.25e-14 as=5.25e-14 pd=1.55u ps=1.55u nrd=0.671741 \
        nrs=0.671741 sa=147.042n sb=147.042n sa1=107.158n sa2=144.915n \
        sa3=241.797n sa4=141.98n sb1=107.158n sb2=144.915n sb3=241.797n \
        spa=100n spa1=100n spa2=100n spa3=100n sap=113.519n sapb=134.009n \
        spba=115.715n spba1=117.043n dfm_flag=0 spmt=1.11111e+15 spomt=0 \
        spomt1=1.11111e+60 spmb=1.11111e+15 spomb=0 spomb1=1.11111e+60
    M144 (net225 net573 net251 GND) nch_mac l=30n w=900n multi=1 nf=3 \
        sd=100n ad=5.25e-14 as=5.25e-14 pd=1.55u ps=1.55u nrd=0.671741 \
        nrs=0.671741 sa=147.042n sb=147.042n sa1=107.158n sa2=144.915n \
        sa3=241.797n sa4=141.98n sb1=107.158n sb2=144.915n sb3=241.797n \
        spa=100n spa1=100n spa2=100n spa3=100n sap=113.519n sapb=134.009n \
        spba=115.715n spba1=117.043n dfm_flag=0 spmt=1.11111e+15 spomt=0 \
        spomt1=1.11111e+60 spmb=1.11111e+15 spomb=0 spomb1=1.11111e+60
    M143 (net239 net573 net248 GND) nch_mac l=30n w=900n multi=1 nf=3 \
        sd=100n ad=5.25e-14 as=5.25e-14 pd=1.55u ps=1.55u nrd=0.671741 \
        nrs=0.671741 sa=147.042n sb=147.042n sa1=107.158n sa2=144.915n \
        sa3=241.797n sa4=141.98n sb1=107.158n sb2=144.915n sb3=241.797n \
        spa=100n spa1=100n spa2=100n spa3=100n sap=113.519n sapb=134.009n \
        spba=115.715n spba1=117.043n dfm_flag=0 spmt=1.11111e+15 spomt=0 \
        spomt1=1.11111e+60 spmb=1.11111e+15 spomb=0 spomb1=1.11111e+60
    M136 (net321 net573 net153 GND) nch_mac l=30n w=900n multi=1 nf=3 \
        sd=100n ad=5.25e-14 as=5.25e-14 pd=1.55u ps=1.55u nrd=0.671741 \
        nrs=0.671741 sa=147.042n sb=147.042n sa1=107.158n sa2=144.915n \
        sa3=241.797n sa4=141.98n sb1=107.158n sb2=144.915n sb3=241.797n \
        spa=100n spa1=100n spa2=100n spa3=100n sap=113.519n sapb=134.009n \
        spba=115.715n spba1=117.043n dfm_flag=0 spmt=1.11111e+15 spomt=0 \
        spomt1=1.11111e+60 spmb=1.11111e+15 spomb=0 spomb1=1.11111e+60
    M147 (net223 net573 net224 GND) nch_mac l=30n w=900n multi=1 nf=3 \
        sd=100n ad=5.25e-14 as=5.25e-14 pd=1.55u ps=1.55u nrd=0.671741 \
        nrs=0.671741 sa=147.042n sb=147.042n sa1=107.158n sa2=144.915n \
        sa3=241.797n sa4=141.98n sb1=107.158n sb2=144.915n sb3=241.797n \
        spa=100n spa1=100n spa2=100n spa3=100n sap=113.519n sapb=134.009n \
        spba=115.715n spba1=117.043n dfm_flag=0 spmt=1.11111e+15 spomt=0 \
        spomt1=1.11111e+60 spmb=1.11111e+15 spomb=0 spomb1=1.11111e+60
    M148 (net345 net573 net157 GND) nch_mac l=30n w=900n multi=1 nf=3 \
        sd=100n ad=5.25e-14 as=5.25e-14 pd=1.55u ps=1.55u nrd=0.671741 \
        nrs=0.671741 sa=147.042n sb=147.042n sa1=107.158n sa2=144.915n \
        sa3=241.797n sa4=141.98n sb1=107.158n sb2=144.915n sb3=241.797n \
        spa=100n spa1=100n spa2=100n spa3=100n sap=113.519n sapb=134.009n \
        spba=115.715n spba1=117.043n dfm_flag=0 spmt=1.11111e+15 spomt=0 \
        spomt1=1.11111e+60 spmb=1.11111e+15 spomb=0 spomb1=1.11111e+60
    M149 (net123 net573 net87 GND) nch_mac l=30n w=900n multi=1 nf=3 \
        sd=100n ad=5.25e-14 as=5.25e-14 pd=1.55u ps=1.55u nrd=0.671741 \
        nrs=0.671741 sa=147.042n sb=147.042n sa1=107.158n sa2=144.915n \
        sa3=241.797n sa4=141.98n sb1=107.158n sb2=144.915n sb3=241.797n \
        spa=100n spa1=100n spa2=100n spa3=100n sap=113.519n sapb=134.009n \
        spba=115.715n spba1=117.043n dfm_flag=0 spmt=1.11111e+15 spomt=0 \
        spomt1=1.11111e+60 spmb=1.11111e+15 spomb=0 spomb1=1.11111e+60
    M150 (net431 net573 net113 GND) nch_mac l=30n w=900n multi=1 nf=3 \
        sd=100n ad=5.25e-14 as=5.25e-14 pd=1.55u ps=1.55u nrd=0.671741 \
        nrs=0.671741 sa=147.042n sb=147.042n sa1=107.158n sa2=144.915n \
        sa3=241.797n sa4=141.98n sb1=107.158n sb2=144.915n sb3=241.797n \
        spa=100n spa1=100n spa2=100n spa3=100n sap=113.519n sapb=134.009n \
        spba=115.715n spba1=117.043n dfm_flag=0 spmt=1.11111e+15 spomt=0 \
        spomt1=1.11111e+60 spmb=1.11111e+15 spomb=0 spomb1=1.11111e+60
    M164 (net237 net552 net265 GND) nch_mac l=30n w=900n multi=1 nf=3 \
        sd=100n ad=5.25e-14 as=5.25e-14 pd=1.55u ps=1.55u nrd=0.671741 \
        nrs=0.671741 sa=147.042n sb=147.042n sa1=107.158n sa2=144.915n \
        sa3=241.797n sa4=141.98n sb1=107.158n sb2=144.915n sb3=241.797n \
        spa=100n spa1=100n spa2=100n spa3=100n sap=113.519n sapb=134.009n \
        spba=115.715n spba1=117.043n dfm_flag=0 spmt=1.11111e+15 spomt=0 \
        spomt1=1.11111e+60 spmb=1.11111e+15 spomb=0 spomb1=1.11111e+60
    M163 (net190 net552 net347 GND) nch_mac l=30n w=900n multi=1 nf=3 \
        sd=100n ad=5.25e-14 as=5.25e-14 pd=1.55u ps=1.55u nrd=0.671741 \
        nrs=0.671741 sa=147.042n sb=147.042n sa1=107.158n sa2=144.915n \
        sa3=241.797n sa4=141.98n sb1=107.158n sb2=144.915n sb3=241.797n \
        spa=100n spa1=100n spa2=100n spa3=100n sap=113.519n sapb=134.009n \
        spba=115.715n spba1=117.043n dfm_flag=0 spmt=1.11111e+15 spomt=0 \
        spomt1=1.11111e+60 spmb=1.11111e+15 spomb=0 spomb1=1.11111e+60
    M162 (net233 net552 net148 GND) nch_mac l=30n w=900n multi=1 nf=3 \
        sd=100n ad=5.25e-14 as=5.25e-14 pd=1.55u ps=1.55u nrd=0.671741 \
        nrs=0.671741 sa=147.042n sb=147.042n sa1=107.158n sa2=144.915n \
        sa3=241.797n sa4=141.98n sb1=107.158n sb2=144.915n sb3=241.797n \
        spa=100n spa1=100n spa2=100n spa3=100n sap=113.519n sapb=134.009n \
        spba=115.715n spba1=117.043n dfm_flag=0 spmt=1.11111e+15 spomt=0 \
        spomt1=1.11111e+60 spmb=1.11111e+15 spomb=0 spomb1=1.11111e+60
    M130 (net39 net573 net20 GND) nch_mac l=30n w=900n multi=1 nf=3 \
        sd=100n ad=5.25e-14 as=5.25e-14 pd=1.55u ps=1.55u nrd=0.671741 \
        nrs=0.671741 sa=147.042n sb=147.042n sa1=107.158n sa2=144.915n \
        sa3=241.797n sa4=141.98n sb1=107.158n sb2=144.915n sb3=241.797n \
        spa=100n spa1=100n spa2=100n spa3=100n sap=113.519n sapb=134.009n \
        spba=115.715n spba1=117.043n dfm_flag=0 spmt=1.11111e+15 spomt=0 \
        spomt1=1.11111e+60 spmb=1.11111e+15 spomb=0 spomb1=1.11111e+60
    M166 (net40 net552 net321 GND) nch_mac l=30n w=900n multi=1 nf=3 \
        sd=100n ad=5.25e-14 as=5.25e-14 pd=1.55u ps=1.55u nrd=0.671741 \
        nrs=0.671741 sa=147.042n sb=147.042n sa1=107.158n sa2=144.915n \
        sa3=241.797n sa4=141.98n sb1=107.158n sb2=144.915n sb3=241.797n \
        spa=100n spa1=100n spa2=100n spa3=100n sap=113.519n sapb=134.009n \
        spba=115.715n spba1=117.043n dfm_flag=0 spmt=1.11111e+15 spomt=0 \
        spomt1=1.11111e+60 spmb=1.11111e+15 spomb=0 spomb1=1.11111e+60
    M167 (net82 net552 net206 GND) nch_mac l=30n w=900n multi=1 nf=3 \
        sd=100n ad=5.25e-14 as=5.25e-14 pd=1.55u ps=1.55u nrd=0.671741 \
        nrs=0.671741 sa=147.042n sb=147.042n sa1=107.158n sa2=144.915n \
        sa3=241.797n sa4=141.98n sb1=107.158n sb2=144.915n sb3=241.797n \
        spa=100n spa1=100n spa2=100n spa3=100n sap=113.519n sapb=134.009n \
        spba=115.715n spba1=117.043n dfm_flag=0 spmt=1.11111e+15 spomt=0 \
        spomt1=1.11111e+60 spmb=1.11111e+15 spomb=0 spomb1=1.11111e+60
    M168 (net4 net552 net14 GND) nch_mac l=30n w=900n multi=1 nf=3 sd=100n \
        ad=5.25e-14 as=5.25e-14 pd=1.55u ps=1.55u nrd=0.671741 \
        nrs=0.671741 sa=147.042n sb=147.042n sa1=107.158n sa2=144.915n \
        sa3=241.797n sa4=141.98n sb1=107.158n sb2=144.915n sb3=241.797n \
        spa=100n spa1=100n spa2=100n spa3=100n sap=113.519n sapb=134.009n \
        spba=115.715n spba1=117.043n dfm_flag=0 spmt=1.11111e+15 spomt=0 \
        spomt1=1.11111e+60 spmb=1.11111e+15 spomb=0 spomb1=1.11111e+60
    M172 (net31 net552 net39 GND) nch_mac l=30n w=900n multi=1 nf=3 \
        sd=100n ad=5.25e-14 as=5.25e-14 pd=1.55u ps=1.55u nrd=0.671741 \
        nrs=0.671741 sa=147.042n sb=147.042n sa1=107.158n sa2=144.915n \
        sa3=241.797n sa4=141.98n sb1=107.158n sb2=144.915n sb3=241.797n \
        spa=100n spa1=100n spa2=100n spa3=100n sap=113.519n sapb=134.009n \
        spba=115.715n spba1=117.043n dfm_flag=0 spmt=1.11111e+15 spomt=0 \
        spomt1=1.11111e+60 spmb=1.11111e+15 spomb=0 spomb1=1.11111e+60
    M171 (net444 net552 net516 GND) nch_mac l=30n w=900n multi=1 nf=3 \
        sd=100n ad=5.25e-14 as=5.25e-14 pd=1.55u ps=1.55u nrd=0.671741 \
        nrs=0.671741 sa=147.042n sb=147.042n sa1=107.158n sa2=144.915n \
        sa3=241.797n sa4=141.98n sb1=107.158n sb2=144.915n sb3=241.797n \
        spa=100n spa1=100n spa2=100n spa3=100n sap=113.519n sapb=134.009n \
        spba=115.715n spba1=117.043n dfm_flag=0 spmt=1.11111e+15 spomt=0 \
        spomt1=1.11111e+60 spmb=1.11111e+15 spomb=0 spomb1=1.11111e+60
    M170 (net105 net552 net77 GND) nch_mac l=30n w=900n multi=1 nf=3 \
        sd=100n ad=5.25e-14 as=5.25e-14 pd=1.55u ps=1.55u nrd=0.671741 \
        nrs=0.671741 sa=147.042n sb=147.042n sa1=107.158n sa2=144.915n \
        sa3=241.797n sa4=141.98n sb1=107.158n sb2=144.915n sb3=241.797n \
        spa=100n spa1=100n spa2=100n spa3=100n sap=113.519n sapb=134.009n \
        spba=115.715n spba1=117.043n dfm_flag=0 spmt=1.11111e+15 spomt=0 \
        spomt1=1.11111e+60 spmb=1.11111e+15 spomb=0 spomb1=1.11111e+60
    M169 (net360 net552 net361 GND) nch_mac l=30n w=900n multi=1 nf=3 \
        sd=100n ad=5.25e-14 as=5.25e-14 pd=1.55u ps=1.55u nrd=0.671741 \
        nrs=0.671741 sa=147.042n sb=147.042n sa1=107.158n sa2=144.915n \
        sa3=241.797n sa4=141.98n sb1=107.158n sb2=144.915n sb3=241.797n \
        spa=100n spa1=100n spa2=100n spa3=100n sap=113.519n sapb=134.009n \
        spba=115.715n spba1=117.043n dfm_flag=0 spmt=1.11111e+15 spomt=0 \
        spomt1=1.11111e+60 spmb=1.11111e+15 spomb=0 spomb1=1.11111e+60
    M173 (net510 net552 net549 GND) nch_mac l=30n w=900n multi=1 nf=3 \
        sd=100n ad=5.25e-14 as=5.25e-14 pd=1.55u ps=1.55u nrd=0.671741 \
        nrs=0.671741 sa=147.042n sb=147.042n sa1=107.158n sa2=144.915n \
        sa3=241.797n sa4=141.98n sb1=107.158n sb2=144.915n sb3=241.797n \
        spa=100n spa1=100n spa2=100n spa3=100n sap=113.519n sapb=134.009n \
        spba=115.715n spba1=117.043n dfm_flag=0 spmt=1.11111e+15 spomt=0 \
        spomt1=1.11111e+60 spmb=1.11111e+15 spomb=0 spomb1=1.11111e+60
    M174 (net549 net573 net559 GND) nch_mac l=30n w=900n multi=1 nf=3 \
        sd=100n ad=5.25e-14 as=5.25e-14 pd=1.55u ps=1.55u nrd=0.671741 \
        nrs=0.671741 sa=147.042n sb=147.042n sa1=107.158n sa2=144.915n \
        sa3=241.797n sa4=141.98n sb1=107.158n sb2=144.915n sb3=241.797n \
        spa=100n spa1=100n spa2=100n spa3=100n sap=113.519n sapb=134.009n \
        spba=115.715n spba1=117.043n dfm_flag=0 spmt=1.11111e+15 spomt=0 \
        spomt1=1.11111e+60 spmb=1.11111e+15 spomb=0 spomb1=1.11111e+60
    M55 (net61 net550 net169 VDD) pch_mac l=30n w=900n multi=1 nf=3 \
        sd=100n ad=5.25e-14 as=5.25e-14 pd=1.55u ps=1.55u nrd=0.325952 \
        nrs=0.325952 sa=147.042n sb=147.042n sa1=107.158n sa2=144.915n \
        sa3=241.797n sa4=141.98n sb1=107.158n sb2=144.915n sb3=241.797n \
        spa=100n spa1=100n spa2=100n spa3=100n sap=113.519n sapb=134.009n \
        spba=115.715n spba1=117.043n dfm_flag=0 spmt=1.11111e+15 spomt=0 \
        spomt1=1.11111e+60 spmb=1.11111e+15 spomb=0 spomb1=1.11111e+60
    M62 (net360 net550 net361 VDD) pch_mac l=30n w=900n multi=1 nf=3 \
        sd=100n ad=5.25e-14 as=5.25e-14 pd=1.55u ps=1.55u nrd=0.325952 \
        nrs=0.325952 sa=147.042n sb=147.042n sa1=107.158n sa2=144.915n \
        sa3=241.797n sa4=141.98n sb1=107.158n sb2=144.915n sb3=241.797n \
        spa=100n spa1=100n spa2=100n spa3=100n sap=113.519n sapb=134.009n \
        spba=115.715n spba1=117.043n dfm_flag=0 spmt=1.11111e+15 spomt=0 \
        spomt1=1.11111e+60 spmb=1.11111e+15 spomb=0 spomb1=1.11111e+60
    M43 (net431 net571 net113 VDD) pch_mac l=30n w=900n multi=1 nf=3 \
        sd=100n ad=5.25e-14 as=5.25e-14 pd=1.55u ps=1.55u nrd=0.325952 \
        nrs=0.325952 sa=147.042n sb=147.042n sa1=107.158n sa2=144.915n \
        sa3=241.797n sa4=141.98n sb1=107.158n sb2=144.915n sb3=241.797n \
        spa=100n spa1=100n spa2=100n spa3=100n sap=113.519n sapb=134.009n \
        spba=115.715n spba1=117.043n dfm_flag=0 spmt=1.11111e+15 spomt=0 \
        spomt1=1.11111e+60 spmb=1.11111e+15 spomb=0 spomb1=1.11111e+60
    M39 (net211 net571 net334 VDD) pch_mac l=30n w=900n multi=1 nf=3 \
        sd=100n ad=5.25e-14 as=5.25e-14 pd=1.55u ps=1.55u nrd=0.325952 \
        nrs=0.325952 sa=147.042n sb=147.042n sa1=107.158n sa2=144.915n \
        sa3=241.797n sa4=141.98n sb1=107.158n sb2=144.915n sb3=241.797n \
        spa=100n spa1=100n spa2=100n spa3=100n sap=113.519n sapb=134.009n \
        spba=115.715n spba1=117.043n dfm_flag=0 spmt=1.11111e+15 spomt=0 \
        spomt1=1.11111e+60 spmb=1.11111e+15 spomb=0 spomb1=1.11111e+60
    M35 (net367 net571 net187 VDD) pch_mac l=30n w=900n multi=1 nf=3 \
        sd=100n ad=5.25e-14 as=5.25e-14 pd=1.55u ps=1.55u nrd=0.325952 \
        nrs=0.325952 sa=147.042n sb=147.042n sa1=107.158n sa2=144.915n \
        sa3=241.797n sa4=141.98n sb1=107.158n sb2=144.915n sb3=241.797n \
        spa=100n spa1=100n spa2=100n spa3=100n sap=113.519n sapb=134.009n \
        spba=115.715n spba1=117.043n dfm_flag=0 spmt=1.11111e+15 spomt=0 \
        spomt1=1.11111e+60 spmb=1.11111e+15 spomb=0 spomb1=1.11111e+60
    M92 (net511 net550 net546 VDD) pch_mac l=30n w=900n multi=1 nf=3 \
        sd=100n ad=5.25e-14 as=5.25e-14 pd=1.55u ps=1.55u nrd=0.325952 \
        nrs=0.325952 sa=147.042n sb=147.042n sa1=107.158n sa2=144.915n \
        sa3=241.797n sa4=141.98n sb1=107.158n sb2=144.915n sb3=241.797n \
        spa=100n spa1=100n spa2=100n spa3=100n sap=113.519n sapb=134.009n \
        spba=115.715n spba1=117.043n dfm_flag=0 spmt=1.11111e+15 spomt=0 \
        spomt1=1.11111e+60 spmb=1.11111e+15 spomb=0 spomb1=1.11111e+60
    M91 (net546 net571 net561 VDD) pch_mac l=30n w=900n multi=1 nf=3 \
        sd=100n ad=5.25e-14 as=5.25e-14 pd=1.55u ps=1.55u nrd=0.325952 \
        nrs=0.325952 sa=147.042n sb=147.042n sa1=107.158n sa2=144.915n \
        sa3=241.797n sa4=141.98n sb1=107.158n sb2=144.915n sb3=241.797n \
        spa=100n spa1=100n spa2=100n spa3=100n sap=113.519n sapb=134.009n \
        spba=115.715n spba1=117.043n dfm_flag=0 spmt=1.11111e+15 spomt=0 \
        spomt1=1.11111e+60 spmb=1.11111e+15 spomb=0 spomb1=1.11111e+60
    M90 (net549 net571 net559 VDD) pch_mac l=30n w=900n multi=1 nf=3 \
        sd=100n ad=5.25e-14 as=5.25e-14 pd=1.55u ps=1.55u nrd=0.325952 \
        nrs=0.325952 sa=147.042n sb=147.042n sa1=107.158n sa2=144.915n \
        sa3=241.797n sa4=141.98n sb1=107.158n sb2=144.915n sb3=241.797n \
        spa=100n spa1=100n spa2=100n spa3=100n sap=113.519n sapb=134.009n \
        spba=115.715n spba1=117.043n dfm_flag=0 spmt=1.11111e+15 spomt=0 \
        spomt1=1.11111e+60 spmb=1.11111e+15 spomb=0 spomb1=1.11111e+60
    M89 (net510 net550 net549 VDD) pch_mac l=30n w=900n multi=1 nf=3 \
        sd=100n ad=5.25e-14 as=5.25e-14 pd=1.55u ps=1.55u nrd=0.325952 \
        nrs=0.325952 sa=147.042n sb=147.042n sa1=107.158n sa2=144.915n \
        sa3=241.797n sa4=141.98n sb1=107.158n sb2=144.915n sb3=241.797n \
        spa=100n spa1=100n spa2=100n spa3=100n sap=113.519n sapb=134.009n \
        spba=115.715n spba1=117.043n dfm_flag=0 spmt=1.11111e+15 spomt=0 \
        spomt1=1.11111e+60 spmb=1.11111e+15 spomb=0 spomb1=1.11111e+60
    M53 (net310 net550 net367 VDD) pch_mac l=30n w=900n multi=1 nf=3 \
        sd=100n ad=5.25e-14 as=5.25e-14 pd=1.55u ps=1.55u nrd=0.325952 \
        nrs=0.325952 sa=147.042n sb=147.042n sa1=107.158n sa2=144.915n \
        sa3=241.797n sa4=141.98n sb1=107.158n sb2=144.915n sb3=241.797n \
        spa=100n spa1=100n spa2=100n spa3=100n sap=113.519n sapb=134.009n \
        spba=115.715n spba1=117.043n dfm_flag=0 spmt=1.11111e+15 spomt=0 \
        spomt1=1.11111e+60 spmb=1.11111e+15 spomb=0 spomb1=1.11111e+60
    M26 (net361 net571 net489 VDD) pch_mac l=30n w=900n multi=1 nf=3 \
        sd=100n ad=5.25e-14 as=5.25e-14 pd=1.55u ps=1.55u nrd=0.325952 \
        nrs=0.325952 sa=147.042n sb=147.042n sa1=107.158n sa2=144.915n \
        sa3=241.797n sa4=141.98n sb1=107.158n sb2=144.915n sb3=241.797n \
        spa=100n spa1=100n spa2=100n spa3=100n sap=113.519n sapb=134.009n \
        spba=115.715n spba1=117.043n dfm_flag=0 spmt=1.11111e+15 spomt=0 \
        spomt1=1.11111e+60 spmb=1.11111e+15 spomb=0 spomb1=1.11111e+60
    M29 (net321 net571 net153 VDD) pch_mac l=30n w=900n multi=1 nf=3 \
        sd=100n ad=5.25e-14 as=5.25e-14 pd=1.55u ps=1.55u nrd=0.325952 \
        nrs=0.325952 sa=147.042n sb=147.042n sa1=107.158n sa2=144.915n \
        sa3=241.797n sa4=141.98n sb1=107.158n sb2=144.915n sb3=241.797n \
        spa=100n spa1=100n spa2=100n spa3=100n sap=113.519n sapb=134.009n \
        spba=115.715n spba1=117.043n dfm_flag=0 spmt=1.11111e+15 spomt=0 \
        spomt1=1.11111e+60 spmb=1.11111e+15 spomb=0 spomb1=1.11111e+60
    M24 (net516 net571 net464 VDD) pch_mac l=30n w=900n multi=1 nf=3 \
        sd=100n ad=5.25e-14 as=5.25e-14 pd=1.55u ps=1.55u nrd=0.325952 \
        nrs=0.325952 sa=147.042n sb=147.042n sa1=107.158n sa2=144.915n \
        sa3=241.797n sa4=141.98n sb1=107.158n sb2=144.915n sb3=241.797n \
        spa=100n spa1=100n spa2=100n spa3=100n sap=113.519n sapb=134.009n \
        spba=115.715n spba1=117.043n dfm_flag=0 spmt=1.11111e+15 spomt=0 \
        spomt1=1.11111e+60 spmb=1.11111e+15 spomb=0 spomb1=1.11111e+60
    M46 (net335 net550 net345 VDD) pch_mac l=30n w=900n multi=1 nf=3 \
        sd=100n ad=5.25e-14 as=5.25e-14 pd=1.55u ps=1.55u nrd=0.325952 \
        nrs=0.325952 sa=147.042n sb=147.042n sa1=107.158n sa2=144.915n \
        sa3=241.797n sa4=141.98n sb1=107.158n sb2=144.915n sb3=241.797n \
        spa=100n spa1=100n spa2=100n spa3=100n sap=113.519n sapb=134.009n \
        spba=115.715n spba1=117.043n dfm_flag=0 spmt=1.11111e+15 spomt=0 \
        spomt1=1.11111e+60 spmb=1.11111e+15 spomb=0 spomb1=1.11111e+60
    M27 (net148 net571 net368 VDD) pch_mac l=30n w=900n multi=1 nf=3 \
        sd=100n ad=5.25e-14 as=5.25e-14 pd=1.55u ps=1.55u nrd=0.325952 \
        nrs=0.325952 sa=147.042n sb=147.042n sa1=107.158n sa2=144.915n \
        sa3=241.797n sa4=141.98n sb1=107.158n sb2=144.915n sb3=241.797n \
        spa=100n spa1=100n spa2=100n spa3=100n sap=113.519n sapb=134.009n \
        spba=115.715n spba1=117.043n dfm_flag=0 spmt=1.11111e+15 spomt=0 \
        spomt1=1.11111e+60 spmb=1.11111e+15 spomb=0 spomb1=1.11111e+60
    M47 (net216 net550 net223 VDD) pch_mac l=30n w=900n multi=1 nf=3 \
        sd=100n ad=5.25e-14 as=5.25e-14 pd=1.55u ps=1.55u nrd=0.325952 \
        nrs=0.325952 sa=147.042n sb=147.042n sa1=107.158n sa2=144.915n \
        sa3=241.797n sa4=141.98n sb1=107.158n sb2=144.915n sb3=241.797n \
        spa=100n spa1=100n spa2=100n spa3=100n sap=113.519n sapb=134.009n \
        spba=115.715n spba1=117.043n dfm_flag=0 spmt=1.11111e+15 spomt=0 \
        spomt1=1.11111e+60 spmb=1.11111e+15 spomb=0 spomb1=1.11111e+60
    M52 (net293 net550 net239 VDD) pch_mac l=30n w=900n multi=1 nf=3 \
        sd=100n ad=5.25e-14 as=5.25e-14 pd=1.55u ps=1.55u nrd=0.325952 \
        nrs=0.325952 sa=147.042n sb=147.042n sa1=107.158n sa2=144.915n \
        sa3=241.797n sa4=141.98n sb1=107.158n sb2=144.915n sb3=241.797n \
        spa=100n spa1=100n spa2=100n spa3=100n sap=113.519n sapb=134.009n \
        spba=115.715n spba1=117.043n dfm_flag=0 spmt=1.11111e+15 spomt=0 \
        spomt1=1.11111e+60 spmb=1.11111e+15 spomb=0 spomb1=1.11111e+60
    M30 (net254 net571 net214 VDD) pch_mac l=30n w=900n multi=1 nf=3 \
        sd=100n ad=5.25e-14 as=5.25e-14 pd=1.55u ps=1.55u nrd=0.325952 \
        nrs=0.325952 sa=147.042n sb=147.042n sa1=107.158n sa2=144.915n \
        sa3=241.797n sa4=141.98n sb1=107.158n sb2=144.915n sb3=241.797n \
        spa=100n spa1=100n spa2=100n spa3=100n sap=113.519n sapb=134.009n \
        spba=115.715n spba1=117.043n dfm_flag=0 spmt=1.11111e+15 spomt=0 \
        spomt1=1.11111e+60 spmb=1.11111e+15 spomb=0 spomb1=1.11111e+60
    M25 (net77 net571 net452 VDD) pch_mac l=30n w=900n multi=1 nf=3 \
        sd=100n ad=5.25e-14 as=5.25e-14 pd=1.55u ps=1.55u nrd=0.325952 \
        nrs=0.325952 sa=147.042n sb=147.042n sa1=107.158n sa2=144.915n \
        sa3=241.797n sa4=141.98n sb1=107.158n sb2=144.915n sb3=241.797n \
        spa=100n spa1=100n spa2=100n spa3=100n sap=113.519n sapb=134.009n \
        spba=115.715n spba1=117.043n dfm_flag=0 spmt=1.11111e+15 spomt=0 \
        spomt1=1.11111e+60 spmb=1.11111e+15 spomb=0 spomb1=1.11111e+60
    M54 (net177 net550 net172 VDD) pch_mac l=30n w=900n multi=1 nf=3 \
        sd=100n ad=5.25e-14 as=5.25e-14 pd=1.55u ps=1.55u nrd=0.325952 \
        nrs=0.325952 sa=147.042n sb=147.042n sa1=107.158n sa2=144.915n \
        sa3=241.797n sa4=141.98n sb1=107.158n sb2=144.915n sb3=241.797n \
        spa=100n spa1=100n spa2=100n spa3=100n sap=113.519n sapb=134.009n \
        spba=115.715n spba1=117.043n dfm_flag=0 spmt=1.11111e+15 spomt=0 \
        spomt1=1.11111e+60 spmb=1.11111e+15 spomb=0 spomb1=1.11111e+60
    M32 (net347 net571 net319 VDD) pch_mac l=30n w=900n multi=1 nf=3 \
        sd=100n ad=5.25e-14 as=5.25e-14 pd=1.55u ps=1.55u nrd=0.325952 \
        nrs=0.325952 sa=147.042n sb=147.042n sa1=107.158n sa2=144.915n \
        sa3=241.797n sa4=141.98n sb1=107.158n sb2=144.915n sb3=241.797n \
        spa=100n spa1=100n spa2=100n spa3=100n sap=113.519n sapb=134.009n \
        spba=115.715n spba1=117.043n dfm_flag=0 spmt=1.11111e+15 spomt=0 \
        spomt1=1.11111e+60 spmb=1.11111e+15 spomb=0 spomb1=1.11111e+60
    M45 (net119 net550 net123 VDD) pch_mac l=30n w=900n multi=1 nf=3 \
        sd=100n ad=5.25e-14 as=5.25e-14 pd=1.55u ps=1.55u nrd=0.325952 \
        nrs=0.325952 sa=147.042n sb=147.042n sa1=107.158n sa2=144.915n \
        sa3=241.797n sa4=141.98n sb1=107.158n sb2=144.915n sb3=241.797n \
        spa=100n spa1=100n spa2=100n spa3=100n sap=113.519n sapb=134.009n \
        spba=115.715n spba1=117.043n dfm_flag=0 spmt=1.11111e+15 spomt=0 \
        spomt1=1.11111e+60 spmb=1.11111e+15 spomb=0 spomb1=1.11111e+60
    M23 (net39 net571 net20 VDD) pch_mac l=30n w=900n multi=1 nf=3 sd=100n \
        ad=5.25e-14 as=5.25e-14 pd=1.55u ps=1.55u nrd=0.325952 \
        nrs=0.325952 sa=147.042n sb=147.042n sa1=107.158n sa2=144.915n \
        sa3=241.797n sa4=141.98n sb1=107.158n sb2=144.915n sb3=241.797n \
        spa=100n spa1=100n spa2=100n spa3=100n sap=113.519n sapb=134.009n \
        spba=115.715n spba1=117.043n dfm_flag=0 spmt=1.11111e+15 spomt=0 \
        spomt1=1.11111e+60 spmb=1.11111e+15 spomb=0 spomb1=1.11111e+60
    M28 (net206 net571 net22 VDD) pch_mac l=30n w=900n multi=1 nf=3 \
        sd=100n ad=5.25e-14 as=5.25e-14 pd=1.55u ps=1.55u nrd=0.325952 \
        nrs=0.325952 sa=147.042n sb=147.042n sa1=107.158n sa2=144.915n \
        sa3=241.797n sa4=141.98n sb1=107.158n sb2=144.915n sb3=241.797n \
        spa=100n spa1=100n spa2=100n spa3=100n sap=113.519n sapb=134.009n \
        spba=115.715n spba1=117.043n dfm_flag=0 spmt=1.11111e+15 spomt=0 \
        spomt1=1.11111e+60 spmb=1.11111e+15 spomb=0 spomb1=1.11111e+60
    M51 (net183 net550 net225 VDD) pch_mac l=30n w=900n multi=1 nf=3 \
        sd=100n ad=5.25e-14 as=5.25e-14 pd=1.55u ps=1.55u nrd=0.325952 \
        nrs=0.325952 sa=147.042n sb=147.042n sa1=107.158n sa2=144.915n \
        sa3=241.797n sa4=141.98n sb1=107.158n sb2=144.915n sb3=241.797n \
        spa=100n spa1=100n spa2=100n spa3=100n sap=113.519n sapb=134.009n \
        spba=115.715n spba1=117.043n dfm_flag=0 spmt=1.11111e+15 spomt=0 \
        spomt1=1.11111e+60 spmb=1.11111e+15 spomb=0 spomb1=1.11111e+60
    M49 (net420 net550 net431 VDD) pch_mac l=30n w=900n multi=1 nf=3 \
        sd=100n ad=5.25e-14 as=5.25e-14 pd=1.55u ps=1.55u nrd=0.325952 \
        nrs=0.325952 sa=147.042n sb=147.042n sa1=107.158n sa2=144.915n \
        sa3=241.797n sa4=141.98n sb1=107.158n sb2=144.915n sb3=241.797n \
        spa=100n spa1=100n spa2=100n spa3=100n sap=113.519n sapb=134.009n \
        spba=115.715n spba1=117.043n dfm_flag=0 spmt=1.11111e+15 spomt=0 \
        spomt1=1.11111e+60 spmb=1.11111e+15 spomb=0 spomb1=1.11111e+60
    M31 (net265 net571 net195 VDD) pch_mac l=30n w=900n multi=1 nf=3 \
        sd=100n ad=5.25e-14 as=5.25e-14 pd=1.55u ps=1.55u nrd=0.325952 \
        nrs=0.325952 sa=147.042n sb=147.042n sa1=107.158n sa2=144.915n \
        sa3=241.797n sa4=141.98n sb1=107.158n sb2=144.915n sb3=241.797n \
        spa=100n spa1=100n spa2=100n spa3=100n sap=113.519n sapb=134.009n \
        spba=115.715n spba1=117.043n dfm_flag=0 spmt=1.11111e+15 spomt=0 \
        spomt1=1.11111e+60 spmb=1.11111e+15 spomb=0 spomb1=1.11111e+60
    M50 (net163 net550 net419 VDD) pch_mac l=30n w=900n multi=1 nf=3 \
        sd=100n ad=5.25e-14 as=5.25e-14 pd=1.55u ps=1.55u nrd=0.325952 \
        nrs=0.325952 sa=147.042n sb=147.042n sa1=107.158n sa2=144.915n \
        sa3=241.797n sa4=141.98n sb1=107.158n sb2=144.915n sb3=241.797n \
        spa=100n spa1=100n spa2=100n spa3=100n sap=113.519n sapb=134.009n \
        spba=115.715n spba1=117.043n dfm_flag=0 spmt=1.11111e+15 spomt=0 \
        spomt1=1.11111e+60 spmb=1.11111e+15 spomb=0 spomb1=1.11111e+60
    M48 (net132 net550 net211 VDD) pch_mac l=30n w=900n multi=1 nf=3 \
        sd=100n ad=5.25e-14 as=5.25e-14 pd=1.55u ps=1.55u nrd=0.325952 \
        nrs=0.325952 sa=147.042n sb=147.042n sa1=107.158n sa2=144.915n \
        sa3=241.797n sa4=141.98n sb1=107.158n sb2=144.915n sb3=241.797n \
        spa=100n spa1=100n spa2=100n spa3=100n sap=113.519n sapb=134.009n \
        spba=115.715n spba1=117.043n dfm_flag=0 spmt=1.11111e+15 spomt=0 \
        spomt1=1.11111e+60 spmb=1.11111e+15 spomb=0 spomb1=1.11111e+60
    M66 (net4 net550 net14 VDD) pch_mac l=30n w=900n multi=1 nf=3 sd=100n \
        ad=5.25e-14 as=5.25e-14 pd=1.55u ps=1.55u nrd=0.325952 \
        nrs=0.325952 sa=147.042n sb=147.042n sa1=107.158n sa2=144.915n \
        sa3=241.797n sa4=141.98n sb1=107.158n sb2=144.915n sb3=241.797n \
        spa=100n spa1=100n spa2=100n spa3=100n sap=113.519n sapb=134.009n \
        spba=115.715n spba1=117.043n dfm_flag=0 spmt=1.11111e+15 spomt=0 \
        spomt1=1.11111e+60 spmb=1.11111e+15 spomb=0 spomb1=1.11111e+60
    M22 (net14 net571 net15 VDD) pch_mac l=30n w=900n multi=1 nf=3 sd=100n \
        ad=5.25e-14 as=5.25e-14 pd=1.55u ps=1.55u nrd=0.325952 \
        nrs=0.325952 sa=147.042n sb=147.042n sa1=107.158n sa2=144.915n \
        sa3=241.797n sa4=141.98n sb1=107.158n sb2=144.915n sb3=241.797n \
        spa=100n spa1=100n spa2=100n spa3=100n sap=113.519n sapb=134.009n \
        spba=115.715n spba1=117.043n dfm_flag=0 spmt=1.11111e+15 spomt=0 \
        spomt1=1.11111e+60 spmb=1.11111e+15 spomb=0 spomb1=1.11111e+60
    M33 (net169 net571 net298 VDD) pch_mac l=30n w=900n multi=1 nf=3 \
        sd=100n ad=5.25e-14 as=5.25e-14 pd=1.55u ps=1.55u nrd=0.325952 \
        nrs=0.325952 sa=147.042n sb=147.042n sa1=107.158n sa2=144.915n \
        sa3=241.797n sa4=141.98n sb1=107.158n sb2=144.915n sb3=241.797n \
        spa=100n spa1=100n spa2=100n spa3=100n sap=113.519n sapb=134.009n \
        spba=115.715n spba1=117.043n dfm_flag=0 spmt=1.11111e+15 spomt=0 \
        spomt1=1.11111e+60 spmb=1.11111e+15 spomb=0 spomb1=1.11111e+60
    M34 (net172 net571 net173 VDD) pch_mac l=30n w=900n multi=1 nf=3 \
        sd=100n ad=5.25e-14 as=5.25e-14 pd=1.55u ps=1.55u nrd=0.325952 \
        nrs=0.325952 sa=147.042n sb=147.042n sa1=107.158n sa2=144.915n \
        sa3=241.797n sa4=141.98n sb1=107.158n sb2=144.915n sb3=241.797n \
        spa=100n spa1=100n spa2=100n spa3=100n sap=113.519n sapb=134.009n \
        spba=115.715n spba1=117.043n dfm_flag=0 spmt=1.11111e+15 spomt=0 \
        spomt1=1.11111e+60 spmb=1.11111e+15 spomb=0 spomb1=1.11111e+60
    M38 (net419 net571 net373 VDD) pch_mac l=30n w=900n multi=1 nf=3 \
        sd=100n ad=5.25e-14 as=5.25e-14 pd=1.55u ps=1.55u nrd=0.325952 \
        nrs=0.325952 sa=147.042n sb=147.042n sa1=107.158n sa2=144.915n \
        sa3=241.797n sa4=141.98n sb1=107.158n sb2=144.915n sb3=241.797n \
        spa=100n spa1=100n spa2=100n spa3=100n sap=113.519n sapb=134.009n \
        spba=115.715n spba1=117.043n dfm_flag=0 spmt=1.11111e+15 spomt=0 \
        spomt1=1.11111e+60 spmb=1.11111e+15 spomb=0 spomb1=1.11111e+60
    M37 (net225 net571 net251 VDD) pch_mac l=30n w=900n multi=1 nf=3 \
        sd=100n ad=5.25e-14 as=5.25e-14 pd=1.55u ps=1.55u nrd=0.325952 \
        nrs=0.325952 sa=147.042n sb=147.042n sa1=107.158n sa2=144.915n \
        sa3=241.797n sa4=141.98n sb1=107.158n sb2=144.915n sb3=241.797n \
        spa=100n spa1=100n spa2=100n spa3=100n sap=113.519n sapb=134.009n \
        spba=115.715n spba1=117.043n dfm_flag=0 spmt=1.11111e+15 spomt=0 \
        spomt1=1.11111e+60 spmb=1.11111e+15 spomb=0 spomb1=1.11111e+60
    M36 (net239 net571 net248 VDD) pch_mac l=30n w=900n multi=1 nf=3 \
        sd=100n ad=5.25e-14 as=5.25e-14 pd=1.55u ps=1.55u nrd=0.325952 \
        nrs=0.325952 sa=147.042n sb=147.042n sa1=107.158n sa2=144.915n \
        sa3=241.797n sa4=141.98n sb1=107.158n sb2=144.915n sb3=241.797n \
        spa=100n spa1=100n spa2=100n spa3=100n sap=113.519n sapb=134.009n \
        spba=115.715n spba1=117.043n dfm_flag=0 spmt=1.11111e+15 spomt=0 \
        spomt1=1.11111e+60 spmb=1.11111e+15 spomb=0 spomb1=1.11111e+60
    M40 (net223 net571 net224 VDD) pch_mac l=30n w=900n multi=1 nf=3 \
        sd=100n ad=5.25e-14 as=5.25e-14 pd=1.55u ps=1.55u nrd=0.325952 \
        nrs=0.325952 sa=147.042n sb=147.042n sa1=107.158n sa2=144.915n \
        sa3=241.797n sa4=141.98n sb1=107.158n sb2=144.915n sb3=241.797n \
        spa=100n spa1=100n spa2=100n spa3=100n sap=113.519n sapb=134.009n \
        spba=115.715n spba1=117.043n dfm_flag=0 spmt=1.11111e+15 spomt=0 \
        spomt1=1.11111e+60 spmb=1.11111e+15 spomb=0 spomb1=1.11111e+60
    M41 (net345 net571 net157 VDD) pch_mac l=30n w=900n multi=1 nf=3 \
        sd=100n ad=5.25e-14 as=5.25e-14 pd=1.55u ps=1.55u nrd=0.325952 \
        nrs=0.325952 sa=147.042n sb=147.042n sa1=107.158n sa2=144.915n \
        sa3=241.797n sa4=141.98n sb1=107.158n sb2=144.915n sb3=241.797n \
        spa=100n spa1=100n spa2=100n spa3=100n sap=113.519n sapb=134.009n \
        spba=115.715n spba1=117.043n dfm_flag=0 spmt=1.11111e+15 spomt=0 \
        spomt1=1.11111e+60 spmb=1.11111e+15 spomb=0 spomb1=1.11111e+60
    M42 (net123 net571 net87 VDD) pch_mac l=30n w=900n multi=1 nf=3 \
        sd=100n ad=5.25e-14 as=5.25e-14 pd=1.55u ps=1.55u nrd=0.325952 \
        nrs=0.325952 sa=147.042n sb=147.042n sa1=107.158n sa2=144.915n \
        sa3=241.797n sa4=141.98n sb1=107.158n sb2=144.915n sb3=241.797n \
        spa=100n spa1=100n spa2=100n spa3=100n sap=113.519n sapb=134.009n \
        spba=115.715n spba1=117.043n dfm_flag=0 spmt=1.11111e+15 spomt=0 \
        spomt1=1.11111e+60 spmb=1.11111e+15 spomb=0 spomb1=1.11111e+60
    M58 (net257 net550 net254 VDD) pch_mac l=30n w=900n multi=1 nf=3 \
        sd=100n ad=5.25e-14 as=5.25e-14 pd=1.55u ps=1.55u nrd=0.325952 \
        nrs=0.325952 sa=147.042n sb=147.042n sa1=107.158n sa2=144.915n \
        sa3=241.797n sa4=141.98n sb1=107.158n sb2=144.915n sb3=241.797n \
        spa=100n spa1=100n spa2=100n spa3=100n sap=113.519n sapb=134.009n \
        spba=115.715n spba1=117.043n dfm_flag=0 spmt=1.11111e+15 spomt=0 \
        spomt1=1.11111e+60 spmb=1.11111e+15 spomb=0 spomb1=1.11111e+60
    M57 (net237 net550 net265 VDD) pch_mac l=30n w=900n multi=1 nf=3 \
        sd=100n ad=5.25e-14 as=5.25e-14 pd=1.55u ps=1.55u nrd=0.325952 \
        nrs=0.325952 sa=147.042n sb=147.042n sa1=107.158n sa2=144.915n \
        sa3=241.797n sa4=141.98n sb1=107.158n sb2=144.915n sb3=241.797n \
        spa=100n spa1=100n spa2=100n spa3=100n sap=113.519n sapb=134.009n \
        spba=115.715n spba1=117.043n dfm_flag=0 spmt=1.11111e+15 spomt=0 \
        spomt1=1.11111e+60 spmb=1.11111e+15 spomb=0 spomb1=1.11111e+60
    M56 (net190 net550 net347 VDD) pch_mac l=30n w=900n multi=1 nf=3 \
        sd=100n ad=5.25e-14 as=5.25e-14 pd=1.55u ps=1.55u nrd=0.325952 \
        nrs=0.325952 sa=147.042n sb=147.042n sa1=107.158n sa2=144.915n \
        sa3=241.797n sa4=141.98n sb1=107.158n sb2=144.915n sb3=241.797n \
        spa=100n spa1=100n spa2=100n spa3=100n sap=113.519n sapb=134.009n \
        spba=115.715n spba1=117.043n dfm_flag=0 spmt=1.11111e+15 spomt=0 \
        spomt1=1.11111e+60 spmb=1.11111e+15 spomb=0 spomb1=1.11111e+60
    M59 (net40 net550 net321 VDD) pch_mac l=30n w=900n multi=1 nf=3 \
        sd=100n ad=5.25e-14 as=5.25e-14 pd=1.55u ps=1.55u nrd=0.325952 \
        nrs=0.325952 sa=147.042n sb=147.042n sa1=107.158n sa2=144.915n \
        sa3=241.797n sa4=141.98n sb1=107.158n sb2=144.915n sb3=241.797n \
        spa=100n spa1=100n spa2=100n spa3=100n sap=113.519n sapb=134.009n \
        spba=115.715n spba1=117.043n dfm_flag=0 spmt=1.11111e+15 spomt=0 \
        spomt1=1.11111e+60 spmb=1.11111e+15 spomb=0 spomb1=1.11111e+60
    M60 (net82 net550 net206 VDD) pch_mac l=30n w=900n multi=1 nf=3 \
        sd=100n ad=5.25e-14 as=5.25e-14 pd=1.55u ps=1.55u nrd=0.325952 \
        nrs=0.325952 sa=147.042n sb=147.042n sa1=107.158n sa2=144.915n \
        sa3=241.797n sa4=141.98n sb1=107.158n sb2=144.915n sb3=241.797n \
        spa=100n spa1=100n spa2=100n spa3=100n sap=113.519n sapb=134.009n \
        spba=115.715n spba1=117.043n dfm_flag=0 spmt=1.11111e+15 spomt=0 \
        spomt1=1.11111e+60 spmb=1.11111e+15 spomb=0 spomb1=1.11111e+60
    M61 (net233 net550 net148 VDD) pch_mac l=30n w=900n multi=1 nf=3 \
        sd=100n ad=5.25e-14 as=5.25e-14 pd=1.55u ps=1.55u nrd=0.325952 \
        nrs=0.325952 sa=147.042n sb=147.042n sa1=107.158n sa2=144.915n \
        sa3=241.797n sa4=141.98n sb1=107.158n sb2=144.915n sb3=241.797n \
        spa=100n spa1=100n spa2=100n spa3=100n sap=113.519n sapb=134.009n \
        spba=115.715n spba1=117.043n dfm_flag=0 spmt=1.11111e+15 spomt=0 \
        spomt1=1.11111e+60 spmb=1.11111e+15 spomb=0 spomb1=1.11111e+60
    M65 (net31 net550 net39 VDD) pch_mac l=30n w=900n multi=1 nf=3 sd=100n \
        ad=5.25e-14 as=5.25e-14 pd=1.55u ps=1.55u nrd=0.325952 \
        nrs=0.325952 sa=147.042n sb=147.042n sa1=107.158n sa2=144.915n \
        sa3=241.797n sa4=141.98n sb1=107.158n sb2=144.915n sb3=241.797n \
        spa=100n spa1=100n spa2=100n spa3=100n sap=113.519n sapb=134.009n \
        spba=115.715n spba1=117.043n dfm_flag=0 spmt=1.11111e+15 spomt=0 \
        spomt1=1.11111e+60 spmb=1.11111e+15 spomb=0 spomb1=1.11111e+60
    M64 (net444 net550 net516 VDD) pch_mac l=30n w=900n multi=1 nf=3 \
        sd=100n ad=5.25e-14 as=5.25e-14 pd=1.55u ps=1.55u nrd=0.325952 \
        nrs=0.325952 sa=147.042n sb=147.042n sa1=107.158n sa2=144.915n \
        sa3=241.797n sa4=141.98n sb1=107.158n sb2=144.915n sb3=241.797n \
        spa=100n spa1=100n spa2=100n spa3=100n sap=113.519n sapb=134.009n \
        spba=115.715n spba1=117.043n dfm_flag=0 spmt=1.11111e+15 spomt=0 \
        spomt1=1.11111e+60 spmb=1.11111e+15 spomb=0 spomb1=1.11111e+60
    M63 (net105 net550 net77 VDD) pch_mac l=30n w=900n multi=1 nf=3 \
        sd=100n ad=5.25e-14 as=5.25e-14 pd=1.55u ps=1.55u nrd=0.325952 \
        nrs=0.325952 sa=147.042n sb=147.042n sa1=107.158n sa2=144.915n \
        sa3=241.797n sa4=141.98n sb1=107.158n sb2=144.915n sb3=241.797n \
        spa=100n spa1=100n spa2=100n spa3=100n sap=113.519n sapb=134.009n \
        spba=115.715n spba1=117.043n dfm_flag=0 spmt=1.11111e+15 spomt=0 \
        spomt1=1.11111e+60 spmb=1.11111e+15 spomb=0 spomb1=1.11111e+60
    I109 (net116 SCKO VDD GND) BUFFD2BWP12T30P140
    I108 (net371 net116 VDD GND) BUFFD2BWP12T30P140
    I1608 (net337 SDO VDD GND) BUFFD2BWP12T30P140
    I1473 (net375 OUT_16 VDD GND) BUFFD4BWP12T30P140
    I1497 (net414 OUT_10 VDD GND) BUFFD4BWP12T30P140
    I1483 (net329 OUT_15 VDD GND) BUFFD4BWP12T30P140
    I1489 (net318 OUT_12 VDD GND) BUFFD4BWP12T30P140
    I1475 (net461 OUT_17 VDD GND) BUFFD4BWP12T30P140
    I767 (net7 OUT_21 VDD GND) BUFFD4BWP12T30P140
    I774 (net26 OUT_20 VDD GND) BUFFD4BWP12T30P140
    I1507 (net486 OUT_9 VDD GND) BUFFD4BWP12T30P140
    I1515 (net483 OUT_7 VDD GND) BUFFD4BWP12T30P140
    I1513 (net453 OUT_6 VDD GND) BUFFD4BWP12T30P140
    I1467 (net482 OUT_19 VDD GND) BUFFD4BWP12T30P140
    I1523 (net481 OUT_5 VDD GND) BUFFD4BWP12T30P140
    I1521 (net480 OUT_4 VDD GND) BUFFD4BWP12T30P140
    I1465 (net479 OUT_18 VDD GND) BUFFD4BWP12T30P140
    I1481 (net487 OUT_14 VDD GND) BUFFD4BWP12T30P140
    I1505 (net247 OUT_8 VDD GND) BUFFD4BWP12T30P140
    I1499 (net250 OUT_11 VDD GND) BUFFD4BWP12T30P140
    I1491 (net426 OUT_13 VDD GND) BUFFD4BWP12T30P140
    I1223 (net641 net69 VDD GND) BUFFD4BWP12T30P140
    I1529 (net507 OUT_2 VDD GND) BUFFD4BWP12T30P140
    I1531 (net505 OUT_3 VDD GND) BUFFD4BWP12T30P140
    I1537 (net501 OUT_0 VDD GND) BUFFD4BWP12T30P140
    I1539 (net498 OUT_1 VDD GND) BUFFD4BWP12T30P140
    I1542 (net581 OUT_22 VDD GND) BUFFD4BWP12T30P140
    I1550 (net580 OUT_23 VDD GND) BUFFD4BWP12T30P140
    I1638_26 (VDD GND) DCAP4BWP12T30P140
    I1638_25 (VDD GND) DCAP4BWP12T30P140
    I1638_24 (VDD GND) DCAP4BWP12T30P140
    I1638_23 (VDD GND) DCAP4BWP12T30P140
    I1638_22 (VDD GND) DCAP4BWP12T30P140
    I1638_21 (VDD GND) DCAP4BWP12T30P140
    I1638_20 (VDD GND) DCAP4BWP12T30P140
    I1638_19 (VDD GND) DCAP4BWP12T30P140
    I1638_18 (VDD GND) DCAP4BWP12T30P140
    I1638_17 (VDD GND) DCAP4BWP12T30P140
    I1638_16 (VDD GND) DCAP4BWP12T30P140
    I1638_15 (VDD GND) DCAP4BWP12T30P140
    I1638_14 (VDD GND) DCAP4BWP12T30P140
    I1638_13 (VDD GND) DCAP4BWP12T30P140
    I1638_12 (VDD GND) DCAP4BWP12T30P140
    I1638_11 (VDD GND) DCAP4BWP12T30P140
    I1638_10 (VDD GND) DCAP4BWP12T30P140
    I1638_9 (VDD GND) DCAP4BWP12T30P140
    I1638_8 (VDD GND) DCAP4BWP12T30P140
    I1638_7 (VDD GND) DCAP4BWP12T30P140
    I1638_6 (VDD GND) DCAP4BWP12T30P140
    I1638_5 (VDD GND) DCAP4BWP12T30P140
    I1638_4 (VDD GND) DCAP4BWP12T30P140
    I1638_3 (VDD GND) DCAP4BWP12T30P140
    I1638_2 (VDD GND) DCAP4BWP12T30P140
    I1638_1 (VDD GND) DCAP4BWP12T30P140
    I1643_384 (VDD GND) DCAP4BWP12T30P140
    I1643_383 (VDD GND) DCAP4BWP12T30P140
    I1643_382 (VDD GND) DCAP4BWP12T30P140
    I1643_381 (VDD GND) DCAP4BWP12T30P140
    I1643_380 (VDD GND) DCAP4BWP12T30P140
    I1643_379 (VDD GND) DCAP4BWP12T30P140
    I1643_378 (VDD GND) DCAP4BWP12T30P140
    I1643_377 (VDD GND) DCAP4BWP12T30P140
    I1643_376 (VDD GND) DCAP4BWP12T30P140
    I1643_375 (VDD GND) DCAP4BWP12T30P140
    I1643_374 (VDD GND) DCAP4BWP12T30P140
    I1643_373 (VDD GND) DCAP4BWP12T30P140
    I1643_372 (VDD GND) DCAP4BWP12T30P140
    I1643_371 (VDD GND) DCAP4BWP12T30P140
    I1643_370 (VDD GND) DCAP4BWP12T30P140
    I1643_369 (VDD GND) DCAP4BWP12T30P140
    I1643_368 (VDD GND) DCAP4BWP12T30P140
    I1643_367 (VDD GND) DCAP4BWP12T30P140
    I1643_366 (VDD GND) DCAP4BWP12T30P140
    I1643_365 (VDD GND) DCAP4BWP12T30P140
    I1643_364 (VDD GND) DCAP4BWP12T30P140
    I1643_363 (VDD GND) DCAP4BWP12T30P140
    I1643_362 (VDD GND) DCAP4BWP12T30P140
    I1643_361 (VDD GND) DCAP4BWP12T30P140
    I1643_360 (VDD GND) DCAP4BWP12T30P140
    I1643_359 (VDD GND) DCAP4BWP12T30P140
    I1643_358 (VDD GND) DCAP4BWP12T30P140
    I1643_357 (VDD GND) DCAP4BWP12T30P140
    I1643_356 (VDD GND) DCAP4BWP12T30P140
    I1643_355 (VDD GND) DCAP4BWP12T30P140
    I1643_354 (VDD GND) DCAP4BWP12T30P140
    I1643_353 (VDD GND) DCAP4BWP12T30P140
    I1643_352 (VDD GND) DCAP4BWP12T30P140
    I1643_351 (VDD GND) DCAP4BWP12T30P140
    I1643_350 (VDD GND) DCAP4BWP12T30P140
    I1643_349 (VDD GND) DCAP4BWP12T30P140
    I1643_348 (VDD GND) DCAP4BWP12T30P140
    I1643_347 (VDD GND) DCAP4BWP12T30P140
    I1643_346 (VDD GND) DCAP4BWP12T30P140
    I1643_345 (VDD GND) DCAP4BWP12T30P140
    I1643_344 (VDD GND) DCAP4BWP12T30P140
    I1643_343 (VDD GND) DCAP4BWP12T30P140
    I1643_342 (VDD GND) DCAP4BWP12T30P140
    I1643_341 (VDD GND) DCAP4BWP12T30P140
    I1643_340 (VDD GND) DCAP4BWP12T30P140
    I1643_339 (VDD GND) DCAP4BWP12T30P140
    I1643_338 (VDD GND) DCAP4BWP12T30P140
    I1643_337 (VDD GND) DCAP4BWP12T30P140
    I1643_336 (VDD GND) DCAP4BWP12T30P140
    I1643_335 (VDD GND) DCAP4BWP12T30P140
    I1643_334 (VDD GND) DCAP4BWP12T30P140
    I1643_333 (VDD GND) DCAP4BWP12T30P140
    I1643_332 (VDD GND) DCAP4BWP12T30P140
    I1643_331 (VDD GND) DCAP4BWP12T30P140
    I1643_330 (VDD GND) DCAP4BWP12T30P140
    I1643_329 (VDD GND) DCAP4BWP12T30P140
    I1643_328 (VDD GND) DCAP4BWP12T30P140
    I1643_327 (VDD GND) DCAP4BWP12T30P140
    I1643_326 (VDD GND) DCAP4BWP12T30P140
    I1643_325 (VDD GND) DCAP4BWP12T30P140
    I1643_324 (VDD GND) DCAP4BWP12T30P140
    I1643_323 (VDD GND) DCAP4BWP12T30P140
    I1643_322 (VDD GND) DCAP4BWP12T30P140
    I1643_321 (VDD GND) DCAP4BWP12T30P140
    I1643_320 (VDD GND) DCAP4BWP12T30P140
    I1643_319 (VDD GND) DCAP4BWP12T30P140
    I1643_318 (VDD GND) DCAP4BWP12T30P140
    I1643_317 (VDD GND) DCAP4BWP12T30P140
    I1643_316 (VDD GND) DCAP4BWP12T30P140
    I1643_315 (VDD GND) DCAP4BWP12T30P140
    I1643_314 (VDD GND) DCAP4BWP12T30P140
    I1643_313 (VDD GND) DCAP4BWP12T30P140
    I1643_312 (VDD GND) DCAP4BWP12T30P140
    I1643_311 (VDD GND) DCAP4BWP12T30P140
    I1643_310 (VDD GND) DCAP4BWP12T30P140
    I1643_309 (VDD GND) DCAP4BWP12T30P140
    I1643_308 (VDD GND) DCAP4BWP12T30P140
    I1643_307 (VDD GND) DCAP4BWP12T30P140
    I1643_306 (VDD GND) DCAP4BWP12T30P140
    I1643_305 (VDD GND) DCAP4BWP12T30P140
    I1643_304 (VDD GND) DCAP4BWP12T30P140
    I1643_303 (VDD GND) DCAP4BWP12T30P140
    I1643_302 (VDD GND) DCAP4BWP12T30P140
    I1643_301 (VDD GND) DCAP4BWP12T30P140
    I1643_300 (VDD GND) DCAP4BWP12T30P140
    I1643_299 (VDD GND) DCAP4BWP12T30P140
    I1643_298 (VDD GND) DCAP4BWP12T30P140
    I1643_297 (VDD GND) DCAP4BWP12T30P140
    I1643_296 (VDD GND) DCAP4BWP12T30P140
    I1643_295 (VDD GND) DCAP4BWP12T30P140
    I1643_294 (VDD GND) DCAP4BWP12T30P140
    I1643_293 (VDD GND) DCAP4BWP12T30P140
    I1643_292 (VDD GND) DCAP4BWP12T30P140
    I1643_291 (VDD GND) DCAP4BWP12T30P140
    I1643_290 (VDD GND) DCAP4BWP12T30P140
    I1643_289 (VDD GND) DCAP4BWP12T30P140
    I1643_288 (VDD GND) DCAP4BWP12T30P140
    I1643_287 (VDD GND) DCAP4BWP12T30P140
    I1643_286 (VDD GND) DCAP4BWP12T30P140
    I1643_285 (VDD GND) DCAP4BWP12T30P140
    I1643_284 (VDD GND) DCAP4BWP12T30P140
    I1643_283 (VDD GND) DCAP4BWP12T30P140
    I1643_282 (VDD GND) DCAP4BWP12T30P140
    I1643_281 (VDD GND) DCAP4BWP12T30P140
    I1643_280 (VDD GND) DCAP4BWP12T30P140
    I1643_279 (VDD GND) DCAP4BWP12T30P140
    I1643_278 (VDD GND) DCAP4BWP12T30P140
    I1643_277 (VDD GND) DCAP4BWP12T30P140
    I1643_276 (VDD GND) DCAP4BWP12T30P140
    I1643_275 (VDD GND) DCAP4BWP12T30P140
    I1643_274 (VDD GND) DCAP4BWP12T30P140
    I1643_273 (VDD GND) DCAP4BWP12T30P140
    I1643_272 (VDD GND) DCAP4BWP12T30P140
    I1643_271 (VDD GND) DCAP4BWP12T30P140
    I1643_270 (VDD GND) DCAP4BWP12T30P140
    I1643_269 (VDD GND) DCAP4BWP12T30P140
    I1643_268 (VDD GND) DCAP4BWP12T30P140
    I1643_267 (VDD GND) DCAP4BWP12T30P140
    I1643_266 (VDD GND) DCAP4BWP12T30P140
    I1643_265 (VDD GND) DCAP4BWP12T30P140
    I1643_264 (VDD GND) DCAP4BWP12T30P140
    I1643_263 (VDD GND) DCAP4BWP12T30P140
    I1643_262 (VDD GND) DCAP4BWP12T30P140
    I1643_261 (VDD GND) DCAP4BWP12T30P140
    I1643_260 (VDD GND) DCAP4BWP12T30P140
    I1643_259 (VDD GND) DCAP4BWP12T30P140
    I1643_258 (VDD GND) DCAP4BWP12T30P140
    I1643_257 (VDD GND) DCAP4BWP12T30P140
    I1643_256 (VDD GND) DCAP4BWP12T30P140
    I1643_255 (VDD GND) DCAP4BWP12T30P140
    I1643_254 (VDD GND) DCAP4BWP12T30P140
    I1643_253 (VDD GND) DCAP4BWP12T30P140
    I1643_252 (VDD GND) DCAP4BWP12T30P140
    I1643_251 (VDD GND) DCAP4BWP12T30P140
    I1643_250 (VDD GND) DCAP4BWP12T30P140
    I1643_249 (VDD GND) DCAP4BWP12T30P140
    I1643_248 (VDD GND) DCAP4BWP12T30P140
    I1643_247 (VDD GND) DCAP4BWP12T30P140
    I1643_246 (VDD GND) DCAP4BWP12T30P140
    I1643_245 (VDD GND) DCAP4BWP12T30P140
    I1643_244 (VDD GND) DCAP4BWP12T30P140
    I1643_243 (VDD GND) DCAP4BWP12T30P140
    I1643_242 (VDD GND) DCAP4BWP12T30P140
    I1643_241 (VDD GND) DCAP4BWP12T30P140
    I1643_240 (VDD GND) DCAP4BWP12T30P140
    I1643_239 (VDD GND) DCAP4BWP12T30P140
    I1643_238 (VDD GND) DCAP4BWP12T30P140
    I1643_237 (VDD GND) DCAP4BWP12T30P140
    I1643_236 (VDD GND) DCAP4BWP12T30P140
    I1643_235 (VDD GND) DCAP4BWP12T30P140
    I1643_234 (VDD GND) DCAP4BWP12T30P140
    I1643_233 (VDD GND) DCAP4BWP12T30P140
    I1643_232 (VDD GND) DCAP4BWP12T30P140
    I1643_231 (VDD GND) DCAP4BWP12T30P140
    I1643_230 (VDD GND) DCAP4BWP12T30P140
    I1643_229 (VDD GND) DCAP4BWP12T30P140
    I1643_228 (VDD GND) DCAP4BWP12T30P140
    I1643_227 (VDD GND) DCAP4BWP12T30P140
    I1643_226 (VDD GND) DCAP4BWP12T30P140
    I1643_225 (VDD GND) DCAP4BWP12T30P140
    I1643_224 (VDD GND) DCAP4BWP12T30P140
    I1643_223 (VDD GND) DCAP4BWP12T30P140
    I1643_222 (VDD GND) DCAP4BWP12T30P140
    I1643_221 (VDD GND) DCAP4BWP12T30P140
    I1643_220 (VDD GND) DCAP4BWP12T30P140
    I1643_219 (VDD GND) DCAP4BWP12T30P140
    I1643_218 (VDD GND) DCAP4BWP12T30P140
    I1643_217 (VDD GND) DCAP4BWP12T30P140
    I1643_216 (VDD GND) DCAP4BWP12T30P140
    I1643_215 (VDD GND) DCAP4BWP12T30P140
    I1643_214 (VDD GND) DCAP4BWP12T30P140
    I1643_213 (VDD GND) DCAP4BWP12T30P140
    I1643_212 (VDD GND) DCAP4BWP12T30P140
    I1643_211 (VDD GND) DCAP4BWP12T30P140
    I1643_210 (VDD GND) DCAP4BWP12T30P140
    I1643_209 (VDD GND) DCAP4BWP12T30P140
    I1643_208 (VDD GND) DCAP4BWP12T30P140
    I1643_207 (VDD GND) DCAP4BWP12T30P140
    I1643_206 (VDD GND) DCAP4BWP12T30P140
    I1643_205 (VDD GND) DCAP4BWP12T30P140
    I1643_204 (VDD GND) DCAP4BWP12T30P140
    I1643_203 (VDD GND) DCAP4BWP12T30P140
    I1643_202 (VDD GND) DCAP4BWP12T30P140
    I1643_201 (VDD GND) DCAP4BWP12T30P140
    I1643_200 (VDD GND) DCAP4BWP12T30P140
    I1643_199 (VDD GND) DCAP4BWP12T30P140
    I1643_198 (VDD GND) DCAP4BWP12T30P140
    I1643_197 (VDD GND) DCAP4BWP12T30P140
    I1643_196 (VDD GND) DCAP4BWP12T30P140
    I1643_195 (VDD GND) DCAP4BWP12T30P140
    I1643_194 (VDD GND) DCAP4BWP12T30P140
    I1643_193 (VDD GND) DCAP4BWP12T30P140
    I1643_192 (VDD GND) DCAP4BWP12T30P140
    I1643_191 (VDD GND) DCAP4BWP12T30P140
    I1643_190 (VDD GND) DCAP4BWP12T30P140
    I1643_189 (VDD GND) DCAP4BWP12T30P140
    I1643_188 (VDD GND) DCAP4BWP12T30P140
    I1643_187 (VDD GND) DCAP4BWP12T30P140
    I1643_186 (VDD GND) DCAP4BWP12T30P140
    I1643_185 (VDD GND) DCAP4BWP12T30P140
    I1643_184 (VDD GND) DCAP4BWP12T30P140
    I1643_183 (VDD GND) DCAP4BWP12T30P140
    I1643_182 (VDD GND) DCAP4BWP12T30P140
    I1643_181 (VDD GND) DCAP4BWP12T30P140
    I1643_180 (VDD GND) DCAP4BWP12T30P140
    I1643_179 (VDD GND) DCAP4BWP12T30P140
    I1643_178 (VDD GND) DCAP4BWP12T30P140
    I1643_177 (VDD GND) DCAP4BWP12T30P140
    I1643_176 (VDD GND) DCAP4BWP12T30P140
    I1643_175 (VDD GND) DCAP4BWP12T30P140
    I1643_174 (VDD GND) DCAP4BWP12T30P140
    I1643_173 (VDD GND) DCAP4BWP12T30P140
    I1643_172 (VDD GND) DCAP4BWP12T30P140
    I1643_171 (VDD GND) DCAP4BWP12T30P140
    I1643_170 (VDD GND) DCAP4BWP12T30P140
    I1643_169 (VDD GND) DCAP4BWP12T30P140
    I1643_168 (VDD GND) DCAP4BWP12T30P140
    I1643_167 (VDD GND) DCAP4BWP12T30P140
    I1643_166 (VDD GND) DCAP4BWP12T30P140
    I1643_165 (VDD GND) DCAP4BWP12T30P140
    I1643_164 (VDD GND) DCAP4BWP12T30P140
    I1643_163 (VDD GND) DCAP4BWP12T30P140
    I1643_162 (VDD GND) DCAP4BWP12T30P140
    I1643_161 (VDD GND) DCAP4BWP12T30P140
    I1643_160 (VDD GND) DCAP4BWP12T30P140
    I1643_159 (VDD GND) DCAP4BWP12T30P140
    I1643_158 (VDD GND) DCAP4BWP12T30P140
    I1643_157 (VDD GND) DCAP4BWP12T30P140
    I1643_156 (VDD GND) DCAP4BWP12T30P140
    I1643_155 (VDD GND) DCAP4BWP12T30P140
    I1643_154 (VDD GND) DCAP4BWP12T30P140
    I1643_153 (VDD GND) DCAP4BWP12T30P140
    I1643_152 (VDD GND) DCAP4BWP12T30P140
    I1643_151 (VDD GND) DCAP4BWP12T30P140
    I1643_150 (VDD GND) DCAP4BWP12T30P140
    I1643_149 (VDD GND) DCAP4BWP12T30P140
    I1643_148 (VDD GND) DCAP4BWP12T30P140
    I1643_147 (VDD GND) DCAP4BWP12T30P140
    I1643_146 (VDD GND) DCAP4BWP12T30P140
    I1643_145 (VDD GND) DCAP4BWP12T30P140
    I1643_144 (VDD GND) DCAP4BWP12T30P140
    I1643_143 (VDD GND) DCAP4BWP12T30P140
    I1643_142 (VDD GND) DCAP4BWP12T30P140
    I1643_141 (VDD GND) DCAP4BWP12T30P140
    I1643_140 (VDD GND) DCAP4BWP12T30P140
    I1643_139 (VDD GND) DCAP4BWP12T30P140
    I1643_138 (VDD GND) DCAP4BWP12T30P140
    I1643_137 (VDD GND) DCAP4BWP12T30P140
    I1643_136 (VDD GND) DCAP4BWP12T30P140
    I1643_135 (VDD GND) DCAP4BWP12T30P140
    I1643_134 (VDD GND) DCAP4BWP12T30P140
    I1643_133 (VDD GND) DCAP4BWP12T30P140
    I1643_132 (VDD GND) DCAP4BWP12T30P140
    I1643_131 (VDD GND) DCAP4BWP12T30P140
    I1643_130 (VDD GND) DCAP4BWP12T30P140
    I1643_129 (VDD GND) DCAP4BWP12T30P140
    I1643_128 (VDD GND) DCAP4BWP12T30P140
    I1643_127 (VDD GND) DCAP4BWP12T30P140
    I1643_126 (VDD GND) DCAP4BWP12T30P140
    I1643_125 (VDD GND) DCAP4BWP12T30P140
    I1643_124 (VDD GND) DCAP4BWP12T30P140
    I1643_123 (VDD GND) DCAP4BWP12T30P140
    I1643_122 (VDD GND) DCAP4BWP12T30P140
    I1643_121 (VDD GND) DCAP4BWP12T30P140
    I1643_120 (VDD GND) DCAP4BWP12T30P140
    I1643_119 (VDD GND) DCAP4BWP12T30P140
    I1643_118 (VDD GND) DCAP4BWP12T30P140
    I1643_117 (VDD GND) DCAP4BWP12T30P140
    I1643_116 (VDD GND) DCAP4BWP12T30P140
    I1643_115 (VDD GND) DCAP4BWP12T30P140
    I1643_114 (VDD GND) DCAP4BWP12T30P140
    I1643_113 (VDD GND) DCAP4BWP12T30P140
    I1643_112 (VDD GND) DCAP4BWP12T30P140
    I1643_111 (VDD GND) DCAP4BWP12T30P140
    I1643_110 (VDD GND) DCAP4BWP12T30P140
    I1643_109 (VDD GND) DCAP4BWP12T30P140
    I1643_108 (VDD GND) DCAP4BWP12T30P140
    I1643_107 (VDD GND) DCAP4BWP12T30P140
    I1643_106 (VDD GND) DCAP4BWP12T30P140
    I1643_105 (VDD GND) DCAP4BWP12T30P140
    I1643_104 (VDD GND) DCAP4BWP12T30P140
    I1643_103 (VDD GND) DCAP4BWP12T30P140
    I1643_102 (VDD GND) DCAP4BWP12T30P140
    I1643_101 (VDD GND) DCAP4BWP12T30P140
    I1643_100 (VDD GND) DCAP4BWP12T30P140
    I1643_99 (VDD GND) DCAP4BWP12T30P140
    I1643_98 (VDD GND) DCAP4BWP12T30P140
    I1643_97 (VDD GND) DCAP4BWP12T30P140
    I1643_96 (VDD GND) DCAP4BWP12T30P140
    I1643_95 (VDD GND) DCAP4BWP12T30P140
    I1643_94 (VDD GND) DCAP4BWP12T30P140
    I1643_93 (VDD GND) DCAP4BWP12T30P140
    I1643_92 (VDD GND) DCAP4BWP12T30P140
    I1643_91 (VDD GND) DCAP4BWP12T30P140
    I1643_90 (VDD GND) DCAP4BWP12T30P140
    I1643_89 (VDD GND) DCAP4BWP12T30P140
    I1643_88 (VDD GND) DCAP4BWP12T30P140
    I1643_87 (VDD GND) DCAP4BWP12T30P140
    I1643_86 (VDD GND) DCAP4BWP12T30P140
    I1643_85 (VDD GND) DCAP4BWP12T30P140
    I1643_84 (VDD GND) DCAP4BWP12T30P140
    I1643_83 (VDD GND) DCAP4BWP12T30P140
    I1643_82 (VDD GND) DCAP4BWP12T30P140
    I1643_81 (VDD GND) DCAP4BWP12T30P140
    I1643_80 (VDD GND) DCAP4BWP12T30P140
    I1643_79 (VDD GND) DCAP4BWP12T30P140
    I1643_78 (VDD GND) DCAP4BWP12T30P140
    I1643_77 (VDD GND) DCAP4BWP12T30P140
    I1643_76 (VDD GND) DCAP4BWP12T30P140
    I1643_75 (VDD GND) DCAP4BWP12T30P140
    I1643_74 (VDD GND) DCAP4BWP12T30P140
    I1643_73 (VDD GND) DCAP4BWP12T30P140
    I1643_72 (VDD GND) DCAP4BWP12T30P140
    I1643_71 (VDD GND) DCAP4BWP12T30P140
    I1643_70 (VDD GND) DCAP4BWP12T30P140
    I1643_69 (VDD GND) DCAP4BWP12T30P140
    I1643_68 (VDD GND) DCAP4BWP12T30P140
    I1643_67 (VDD GND) DCAP4BWP12T30P140
    I1643_66 (VDD GND) DCAP4BWP12T30P140
    I1643_65 (VDD GND) DCAP4BWP12T30P140
    I1643_64 (VDD GND) DCAP4BWP12T30P140
    I1643_63 (VDD GND) DCAP4BWP12T30P140
    I1643_62 (VDD GND) DCAP4BWP12T30P140
    I1643_61 (VDD GND) DCAP4BWP12T30P140
    I1643_60 (VDD GND) DCAP4BWP12T30P140
    I1643_59 (VDD GND) DCAP4BWP12T30P140
    I1643_58 (VDD GND) DCAP4BWP12T30P140
    I1643_57 (VDD GND) DCAP4BWP12T30P140
    I1643_56 (VDD GND) DCAP4BWP12T30P140
    I1643_55 (VDD GND) DCAP4BWP12T30P140
    I1643_54 (VDD GND) DCAP4BWP12T30P140
    I1643_53 (VDD GND) DCAP4BWP12T30P140
    I1643_52 (VDD GND) DCAP4BWP12T30P140
    I1643_51 (VDD GND) DCAP4BWP12T30P140
    I1643_50 (VDD GND) DCAP4BWP12T30P140
    I1643_49 (VDD GND) DCAP4BWP12T30P140
    I1643_48 (VDD GND) DCAP4BWP12T30P140
    I1643_47 (VDD GND) DCAP4BWP12T30P140
    I1643_46 (VDD GND) DCAP4BWP12T30P140
    I1643_45 (VDD GND) DCAP4BWP12T30P140
    I1643_44 (VDD GND) DCAP4BWP12T30P140
    I1643_43 (VDD GND) DCAP4BWP12T30P140
    I1643_42 (VDD GND) DCAP4BWP12T30P140
    I1643_41 (VDD GND) DCAP4BWP12T30P140
    I1643_40 (VDD GND) DCAP4BWP12T30P140
    I1643_39 (VDD GND) DCAP4BWP12T30P140
    I1643_38 (VDD GND) DCAP4BWP12T30P140
    I1643_37 (VDD GND) DCAP4BWP12T30P140
    I1643_36 (VDD GND) DCAP4BWP12T30P140
    I1643_35 (VDD GND) DCAP4BWP12T30P140
    I1643_34 (VDD GND) DCAP4BWP12T30P140
    I1643_33 (VDD GND) DCAP4BWP12T30P140
    I1643_32 (VDD GND) DCAP4BWP12T30P140
    I1643_31 (VDD GND) DCAP4BWP12T30P140
    I1643_30 (VDD GND) DCAP4BWP12T30P140
    I1643_29 (VDD GND) DCAP4BWP12T30P140
    I1643_28 (VDD GND) DCAP4BWP12T30P140
    I1643_27 (VDD GND) DCAP4BWP12T30P140
    I1643_26 (VDD GND) DCAP4BWP12T30P140
    I1643_25 (VDD GND) DCAP4BWP12T30P140
    I1643_24 (VDD GND) DCAP4BWP12T30P140
    I1643_23 (VDD GND) DCAP4BWP12T30P140
    I1643_22 (VDD GND) DCAP4BWP12T30P140
    I1643_21 (VDD GND) DCAP4BWP12T30P140
    I1643_20 (VDD GND) DCAP4BWP12T30P140
    I1643_19 (VDD GND) DCAP4BWP12T30P140
    I1643_18 (VDD GND) DCAP4BWP12T30P140
    I1643_17 (VDD GND) DCAP4BWP12T30P140
    I1643_16 (VDD GND) DCAP4BWP12T30P140
    I1643_15 (VDD GND) DCAP4BWP12T30P140
    I1643_14 (VDD GND) DCAP4BWP12T30P140
    I1643_13 (VDD GND) DCAP4BWP12T30P140
    I1643_12 (VDD GND) DCAP4BWP12T30P140
    I1643_11 (VDD GND) DCAP4BWP12T30P140
    I1643_10 (VDD GND) DCAP4BWP12T30P140
    I1643_9 (VDD GND) DCAP4BWP12T30P140
    I1643_8 (VDD GND) DCAP4BWP12T30P140
    I1643_7 (VDD GND) DCAP4BWP12T30P140
    I1643_6 (VDD GND) DCAP4BWP12T30P140
    I1643_5 (VDD GND) DCAP4BWP12T30P140
    I1643_4 (VDD GND) DCAP4BWP12T30P140
    I1643_3 (VDD GND) DCAP4BWP12T30P140
    I1643_2 (VDD GND) DCAP4BWP12T30P140
    I1643_1 (VDD GND) DCAP4BWP12T30P140
    M69 (net368 net2113 VDD VDD) pch_ulvt_mac l=30n w=900n multi=1 nf=3 \
        sd=100n ad=5.25e-14 as=5.25e-14 pd=1.55u ps=1.55u nrd=0.325952 \
        nrs=0.325952 sa=147.042n sb=147.042n sa1=107.158n sa2=144.915n \
        sa3=241.797n sa4=141.98n sb1=107.158n sb2=144.915n sb3=241.797n \
        spa=100n spa1=100n spa2=100n spa3=100n sap=113.519n sapb=134.009n \
        spba=115.715n spba1=117.043n dfm_flag=0 spmt=1.11111e+15 spomt=0 \
        spomt1=1.11111e+60 spmb=1.11111e+15 spomb=0 spomb1=1.11111e+60
    M71 (net153 net2145 VDD VDD) pch_ulvt_mac l=30n w=900n multi=1 nf=3 \
        sd=100n ad=5.25e-14 as=5.25e-14 pd=1.55u ps=1.55u nrd=0.325952 \
        nrs=0.325952 sa=147.042n sb=147.042n sa1=107.158n sa2=144.915n \
        sa3=241.797n sa4=141.98n sb1=107.158n sb2=144.915n sb3=241.797n \
        spa=100n spa1=100n spa2=100n spa3=100n sap=113.519n sapb=134.009n \
        spba=115.715n spba1=117.043n dfm_flag=0 spmt=1.11111e+15 spomt=0 \
        spomt1=1.11111e+60 spmb=1.11111e+15 spomb=0 spomb1=1.11111e+60
    M75 (net298 net2209 VDD VDD) pch_ulvt_mac l=30n w=900n multi=1 nf=3 \
        sd=100n ad=5.25e-14 as=5.25e-14 pd=1.55u ps=1.55u nrd=0.325952 \
        nrs=0.325952 sa=147.042n sb=147.042n sa1=107.158n sa2=144.915n \
        sa3=241.797n sa4=141.98n sb1=107.158n sb2=144.915n sb3=241.797n \
        spa=100n spa1=100n spa2=100n spa3=100n sap=113.519n sapb=134.009n \
        spba=115.715n spba1=117.043n dfm_flag=0 spmt=1.11111e+15 spomt=0 \
        spomt1=1.11111e+60 spmb=1.11111e+15 spomb=0 spomb1=1.11111e+60
    M79 (net251 net2273 VDD VDD) pch_ulvt_mac l=30n w=900n multi=1 nf=3 \
        sd=100n ad=5.25e-14 as=5.25e-14 pd=1.55u ps=1.55u nrd=0.325952 \
        nrs=0.325952 sa=147.042n sb=147.042n sa1=107.158n sa2=144.915n \
        sa3=241.797n sa4=141.98n sb1=107.158n sb2=144.915n sb3=241.797n \
        spa=100n spa1=100n spa2=100n spa3=100n sap=113.519n sapb=134.009n \
        spba=115.715n spba1=117.043n dfm_flag=0 spmt=1.11111e+15 spomt=0 \
        spomt1=1.11111e+60 spmb=1.11111e+15 spomb=0 spomb1=1.11111e+60
    M1 (net20 net472 VDD VDD) pch_ulvt_mac l=30n w=900n multi=1 nf=3 \
        sd=100n ad=5.25e-14 as=5.25e-14 pd=1.55u ps=1.55u nrd=0.325952 \
        nrs=0.325952 sa=147.042n sb=147.042n sa1=107.158n sa2=144.915n \
        sa3=241.797n sa4=141.98n sb1=107.158n sb2=144.915n sb3=241.797n \
        spa=100n spa1=100n spa2=100n spa3=100n sap=113.519n sapb=134.009n \
        spba=115.715n spba1=117.043n dfm_flag=0 spmt=1.11111e+15 spomt=0 \
        spomt1=1.11111e+60 spmb=1.11111e+15 spomb=0 spomb1=1.11111e+60
    M0 (net15 net134 VDD VDD) pch_ulvt_mac l=30n w=900n multi=1 nf=3 \
        sd=100n ad=5.25e-14 as=5.25e-14 pd=1.55u ps=1.55u nrd=0.325952 \
        nrs=0.325952 sa=147.042n sb=147.042n sa1=107.158n sa2=144.915n \
        sa3=241.797n sa4=141.98n sb1=107.158n sb2=144.915n sb3=241.797n \
        spa=100n spa1=100n spa2=100n spa3=100n sap=113.519n sapb=134.009n \
        spba=115.715n spba1=117.043n dfm_flag=0 spmt=1.11111e+15 spomt=0 \
        spomt1=1.11111e+60 spmb=1.11111e+15 spomb=0 spomb1=1.11111e+60
    M77 (net187 net2241 VDD VDD) pch_ulvt_mac l=30n w=900n multi=1 nf=3 \
        sd=100n ad=5.25e-14 as=5.25e-14 pd=1.55u ps=1.55u nrd=0.325952 \
        nrs=0.325952 sa=147.042n sb=147.042n sa1=107.158n sa2=144.915n \
        sa3=241.797n sa4=141.98n sb1=107.158n sb2=144.915n sb3=241.797n \
        spa=100n spa1=100n spa2=100n spa3=100n sap=113.519n sapb=134.009n \
        spba=115.715n spba1=117.043n dfm_flag=0 spmt=1.11111e+15 spomt=0 \
        spomt1=1.11111e+60 spmb=1.11111e+15 spomb=0 spomb1=1.11111e+60
    M74 (net214 net2189 VDD VDD) pch_ulvt_mac l=30n w=900n multi=1 nf=3 \
        sd=100n ad=5.25e-14 as=5.25e-14 pd=1.55u ps=1.55u nrd=0.325952 \
        nrs=0.325952 sa=147.042n sb=147.042n sa1=107.158n sa2=144.915n \
        sa3=241.797n sa4=141.98n sb1=107.158n sb2=144.915n sb3=241.797n \
        spa=100n spa1=100n spa2=100n spa3=100n sap=113.519n sapb=134.009n \
        spba=115.715n spba1=117.043n dfm_flag=0 spmt=1.11111e+15 spomt=0 \
        spomt1=1.11111e+60 spmb=1.11111e+15 spomb=0 spomb1=1.11111e+60
    M70 (net489 net2125 VDD VDD) pch_ulvt_mac l=30n w=900n multi=1 nf=3 \
        sd=100n ad=5.25e-14 as=5.25e-14 pd=1.55u ps=1.55u nrd=0.325952 \
        nrs=0.325952 sa=147.042n sb=147.042n sa1=107.158n sa2=144.915n \
        sa3=241.797n sa4=141.98n sb1=107.158n sb2=144.915n sb3=241.797n \
        spa=100n spa1=100n spa2=100n spa3=100n sap=113.519n sapb=134.009n \
        spba=115.715n spba1=117.043n dfm_flag=0 spmt=1.11111e+15 spomt=0 \
        spomt1=1.11111e+60 spmb=1.11111e+15 spomb=0 spomb1=1.11111e+60
    M68 (net464 net2093 VDD VDD) pch_ulvt_mac l=30n w=900n multi=1 nf=3 \
        sd=100n ad=5.25e-14 as=5.25e-14 pd=1.55u ps=1.55u nrd=0.325952 \
        nrs=0.325952 sa=147.042n sb=147.042n sa1=107.158n sa2=144.915n \
        sa3=241.797n sa4=141.98n sb1=107.158n sb2=144.915n sb3=241.797n \
        spa=100n spa1=100n spa2=100n spa3=100n sap=113.519n sapb=134.009n \
        spba=115.715n spba1=117.043n dfm_flag=0 spmt=1.11111e+15 spomt=0 \
        spomt1=1.11111e+60 spmb=1.11111e+15 spomb=0 spomb1=1.11111e+60
    M80 (net248 net2285 VDD VDD) pch_ulvt_mac l=30n w=900n multi=1 nf=3 \
        sd=100n ad=5.25e-14 as=5.25e-14 pd=1.55u ps=1.55u nrd=0.325952 \
        nrs=0.325952 sa=147.042n sb=147.042n sa1=107.158n sa2=144.915n \
        sa3=241.797n sa4=141.98n sb1=107.158n sb2=144.915n sb3=241.797n \
        spa=100n spa1=100n spa2=100n spa3=100n sap=113.519n sapb=134.009n \
        spba=115.715n spba1=117.043n dfm_flag=0 spmt=1.11111e+15 spomt=0 \
        spomt1=1.11111e+60 spmb=1.11111e+15 spomb=0 spomb1=1.11111e+60
    M82 (net373 net2317 VDD VDD) pch_ulvt_mac l=30n w=900n multi=1 nf=3 \
        sd=100n ad=5.25e-14 as=5.25e-14 pd=1.55u ps=1.55u nrd=0.325952 \
        nrs=0.325952 sa=147.042n sb=147.042n sa1=107.158n sa2=144.915n \
        sa3=241.797n sa4=141.98n sb1=107.158n sb2=144.915n sb3=241.797n \
        spa=100n spa1=100n spa2=100n spa3=100n sap=113.519n sapb=134.009n \
        spba=115.715n spba1=117.043n dfm_flag=0 spmt=1.11111e+15 spomt=0 \
        spomt1=1.11111e+60 spmb=1.11111e+15 spomb=0 spomb1=1.11111e+60
    M67 (net452 net2081 VDD VDD) pch_ulvt_mac l=30n w=900n multi=1 nf=3 \
        sd=100n ad=5.25e-14 as=5.25e-14 pd=1.55u ps=1.55u nrd=0.325952 \
        nrs=0.325952 sa=147.042n sb=147.042n sa1=107.158n sa2=144.915n \
        sa3=241.797n sa4=141.98n sb1=107.158n sb2=144.915n sb3=241.797n \
        spa=100n spa1=100n spa2=100n spa3=100n sap=113.519n sapb=134.009n \
        spba=115.715n spba1=117.043n dfm_flag=0 spmt=1.11111e+15 spomt=0 \
        spomt1=1.11111e+60 spmb=1.11111e+15 spomb=0 spomb1=1.11111e+60
    M78 (net173 net2253 VDD VDD) pch_ulvt_mac l=30n w=900n multi=1 nf=3 \
        sd=100n ad=5.25e-14 as=5.25e-14 pd=1.55u ps=1.55u nrd=0.325952 \
        nrs=0.325952 sa=147.042n sb=147.042n sa1=107.158n sa2=144.915n \
        sa3=241.797n sa4=141.98n sb1=107.158n sb2=144.915n sb3=241.797n \
        spa=100n spa1=100n spa2=100n spa3=100n sap=113.519n sapb=134.009n \
        spba=115.715n spba1=117.043n dfm_flag=0 spmt=1.11111e+15 spomt=0 \
        spomt1=1.11111e+60 spmb=1.11111e+15 spomb=0 spomb1=1.11111e+60
    M76 (net319 net548 VDD VDD) pch_ulvt_mac l=30n w=900n multi=1 nf=3 \
        sd=100n ad=5.25e-14 as=5.25e-14 pd=1.55u ps=1.55u nrd=0.325952 \
        nrs=0.325952 sa=147.042n sb=147.042n sa1=107.158n sa2=144.915n \
        sa3=241.797n sa4=141.98n sb1=107.158n sb2=144.915n sb3=241.797n \
        spa=100n spa1=100n spa2=100n spa3=100n sap=113.519n sapb=134.009n \
        spba=115.715n spba1=117.043n dfm_flag=0 spmt=1.11111e+15 spomt=0 \
        spomt1=1.11111e+60 spmb=1.11111e+15 spomb=0 spomb1=1.11111e+60
    M81 (net334 net2305 VDD VDD) pch_ulvt_mac l=30n w=900n multi=1 nf=3 \
        sd=100n ad=5.25e-14 as=5.25e-14 pd=1.55u ps=1.55u nrd=0.325952 \
        nrs=0.325952 sa=147.042n sb=147.042n sa1=107.158n sa2=144.915n \
        sa3=241.797n sa4=141.98n sb1=107.158n sb2=144.915n sb3=241.797n \
        spa=100n spa1=100n spa2=100n spa3=100n sap=113.519n sapb=134.009n \
        spba=115.715n spba1=117.043n dfm_flag=0 spmt=1.11111e+15 spomt=0 \
        spomt1=1.11111e+60 spmb=1.11111e+15 spomb=0 spomb1=1.11111e+60
    M72 (net22 net2157 VDD VDD) pch_ulvt_mac l=30n w=900n multi=1 nf=3 \
        sd=100n ad=5.25e-14 as=5.25e-14 pd=1.55u ps=1.55u nrd=0.325952 \
        nrs=0.325952 sa=147.042n sb=147.042n sa1=107.158n sa2=144.915n \
        sa3=241.797n sa4=141.98n sb1=107.158n sb2=144.915n sb3=241.797n \
        spa=100n spa1=100n spa2=100n spa3=100n sap=113.519n sapb=134.009n \
        spba=115.715n spba1=117.043n dfm_flag=0 spmt=1.11111e+15 spomt=0 \
        spomt1=1.11111e+60 spmb=1.11111e+15 spomb=0 spomb1=1.11111e+60
    M73 (net195 net2177 VDD VDD) pch_ulvt_mac l=30n w=900n multi=1 nf=3 \
        sd=100n ad=5.25e-14 as=5.25e-14 pd=1.55u ps=1.55u nrd=0.325952 \
        nrs=0.325952 sa=147.042n sb=147.042n sa1=107.158n sa2=144.915n \
        sa3=241.797n sa4=141.98n sb1=107.158n sb2=144.915n sb3=241.797n \
        spa=100n spa1=100n spa2=100n spa3=100n sap=113.519n sapb=134.009n \
        spba=115.715n spba1=117.043n dfm_flag=0 spmt=1.11111e+15 spomt=0 \
        spomt1=1.11111e+60 spmb=1.11111e+15 spomb=0 spomb1=1.11111e+60
    M83 (net157 net2337 VDD VDD) pch_ulvt_mac l=30n w=900n multi=1 nf=3 \
        sd=100n ad=5.25e-14 as=5.25e-14 pd=1.55u ps=1.55u nrd=0.325952 \
        nrs=0.325952 sa=147.042n sb=147.042n sa1=107.158n sa2=144.915n \
        sa3=241.797n sa4=141.98n sb1=107.158n sb2=144.915n sb3=241.797n \
        spa=100n spa1=100n spa2=100n spa3=100n sap=113.519n sapb=134.009n \
        spba=115.715n spba1=117.043n dfm_flag=0 spmt=1.11111e+15 spomt=0 \
        spomt1=1.11111e+60 spmb=1.11111e+15 spomb=0 spomb1=1.11111e+60
    M84 (net224 net2349 VDD VDD) pch_ulvt_mac l=30n w=900n multi=1 nf=3 \
        sd=100n ad=5.25e-14 as=5.25e-14 pd=1.55u ps=1.55u nrd=0.325952 \
        nrs=0.325952 sa=147.042n sb=147.042n sa1=107.158n sa2=144.915n \
        sa3=241.797n sa4=141.98n sb1=107.158n sb2=144.915n sb3=241.797n \
        spa=100n spa1=100n spa2=100n spa3=100n sap=113.519n sapb=134.009n \
        spba=115.715n spba1=117.043n dfm_flag=0 spmt=1.11111e+15 spomt=0 \
        spomt1=1.11111e+60 spmb=1.11111e+15 spomb=0 spomb1=1.11111e+60
    M85 (net113 net2369 VDD VDD) pch_ulvt_mac l=30n w=900n multi=1 nf=3 \
        sd=100n ad=5.25e-14 as=5.25e-14 pd=1.55u ps=1.55u nrd=0.325952 \
        nrs=0.325952 sa=147.042n sb=147.042n sa1=107.158n sa2=144.915n \
        sa3=241.797n sa4=141.98n sb1=107.158n sb2=144.915n sb3=241.797n \
        spa=100n spa1=100n spa2=100n spa3=100n sap=113.519n sapb=134.009n \
        spba=115.715n spba1=117.043n dfm_flag=0 spmt=1.11111e+15 spomt=0 \
        spomt1=1.11111e+60 spmb=1.11111e+15 spomb=0 spomb1=1.11111e+60
    M86 (net87 net2381 VDD VDD) pch_ulvt_mac l=30n w=900n multi=1 nf=3 \
        sd=100n ad=5.25e-14 as=5.25e-14 pd=1.55u ps=1.55u nrd=0.325952 \
        nrs=0.325952 sa=147.042n sb=147.042n sa1=107.158n sa2=144.915n \
        sa3=241.797n sa4=141.98n sb1=107.158n sb2=144.915n sb3=241.797n \
        spa=100n spa1=100n spa2=100n spa3=100n sap=113.519n sapb=134.009n \
        spba=115.715n spba1=117.043n dfm_flag=0 spmt=1.11111e+15 spomt=0 \
        spomt1=1.11111e+60 spmb=1.11111e+15 spomb=0 spomb1=1.11111e+60
    M87 (net559 net2411 VDD VDD) pch_ulvt_mac l=30n w=900n multi=1 nf=3 \
        sd=100n ad=5.25e-14 as=5.25e-14 pd=1.55u ps=1.55u nrd=0.325952 \
        nrs=0.325952 sa=147.042n sb=147.042n sa1=107.158n sa2=144.915n \
        sa3=241.797n sa4=141.98n sb1=107.158n sb2=144.915n sb3=241.797n \
        spa=100n spa1=100n spa2=100n spa3=100n sap=113.519n sapb=134.009n \
        spba=115.715n spba1=117.043n dfm_flag=0 spmt=1.11111e+15 spomt=0 \
        spomt1=1.11111e+60 spmb=1.11111e+15 spomb=0 spomb1=1.11111e+60
    M88 (net561 net2422 VDD VDD) pch_ulvt_mac l=30n w=900n multi=1 nf=3 \
        sd=100n ad=5.25e-14 as=5.25e-14 pd=1.55u ps=1.55u nrd=0.325952 \
        nrs=0.325952 sa=147.042n sb=147.042n sa1=107.158n sa2=144.915n \
        sa3=241.797n sa4=141.98n sb1=107.158n sb2=144.915n sb3=241.797n \
        spa=100n spa1=100n spa2=100n spa3=100n sap=113.519n sapb=134.009n \
        spba=115.715n spba1=117.043n dfm_flag=0 spmt=1.11111e+15 spomt=0 \
        spomt1=1.11111e+60 spmb=1.11111e+15 spomb=0 spomb1=1.11111e+60
    I1621 (REPET_1 net2 net146 VDD GND) CKAN2D4BWP12T30P140
    I1212 (FRAME_8 net69 net150 VDD GND) CKAN2D4BWP12T30P140
    I1193 (FRAME_2 net69 net78 VDD GND) CKAN2D4BWP12T30P140
    I1635 (REPET_7 net2 net24 VDD GND) CKAN2D4BWP12T30P140
    I1191 (FRAME_1 net69 net140 VDD GND) CKAN2D4BWP12T30P140
    I1626 (REPET_8 net2 net34 VDD GND) CKAN2D4BWP12T30P140
    I1210 (FRAME_11 net69 net170 VDD GND) CKAN2D4BWP12T30P140
    I1625 (REPET_6 net2 net114 VDD GND) CKAN2D4BWP12T30P140
    I1628 (REPET_11 net2 net12 VDD GND) CKAN2D4BWP12T30P140
    I1207 (FRAME_9 net69 net6 VDD GND) CKAN2D4BWP12T30P140
    I1627 (REPET_10 net2 net156 VDD GND) CKAN2D4BWP12T30P140
    I1205 (FRAME_10 net69 net160 VDD GND) CKAN2D4BWP12T30P140
    I1204 (FRAME_6 net69 net18 VDD GND) CKAN2D4BWP12T30P140
    I1631 (REPET_14 net2 net44 VDD GND) CKAN2D4BWP12T30P140
    I1202 (FRAME_5 net69 net108 VDD GND) CKAN2D4BWP12T30P140
    I1632 (REPET_15 net2 net54 VDD GND) CKAN2D4BWP12T30P140
    I1629 (REPET_12 net2 net166 VDD GND) CKAN2D4BWP12T30P140
    I1199 (FRAME_7 net69 net28 VDD GND) CKAN2D4BWP12T30P140
    I1630 (REPET_13 net2 net176 VDD GND) CKAN2D4BWP12T30P140
    I1197 (FRAME_4 net69 net98 VDD GND) CKAN2D4BWP12T30P140
    I1633 (REPET_16 net2 net64 VDD GND) CKAN2D4BWP12T30P140
    I1195 (FRAME_3 net69 net88 VDD GND) CKAN2D4BWP12T30P140
    I1634 (REPET_17 net2 net74 VDD GND) CKAN2D4BWP12T30P140
    I1624 (REPET_5 net2 net104 VDD GND) CKAN2D4BWP12T30P140
    I1218 (FRAME_13 net69 net48 VDD GND) CKAN2D4BWP12T30P140
    I1623 (REPET_3 net2 net94 VDD GND) CKAN2D4BWP12T30P140
    I1220 (FRAME_14 net69 net58 VDD GND) CKAN2D4BWP12T30P140
    I1215 (FRAME_15 net69 net68 VDD GND) CKAN2D4BWP12T30P140
    I1622 (REPET_2 net2 net84 VDD GND) CKAN2D4BWP12T30P140
    I1213 (FRAME_12 net69 net38 VDD GND) CKAN2D4BWP12T30P140
    I1189 (FRAME_0 net69 net3 VDD GND) CKAN2D4BWP12T30P140
    I904 (net58 GND net81 net82 net32 net81 net85 VDD net55 net64) \
        LB_crossbar_cell
    I1342 (net38 GND net67 net61 net62 net59 net71 VDD net72 net44) \
        LB_crossbar_cell
    I613 (net6 GND net1 net4 net9 net1 net11 VDD net13 net12) \
        LB_crossbar_cell
    I1299 (net6 GND net51 net40 net42 net37 net52 VDD net57 net12) \
        LB_crossbar_cell
    I882 (net88 GND net19 net22 net32 net19 net41 VDD net55 net94) \
        LB_crossbar_cell
    I1579 (net6 GND net540 net511 net460 net540 net541 VDD net519 net12) \
        LB_crossbar_cell
    I1578 (net28 GND net545 net546 net460 net545 net531 VDD net519 net34) \
        LB_crossbar_cell
    I1577 (net18 GND net542 net546 net460 net542 net545 VDD net519 net24) \
        LB_crossbar_cell
    I1576 (net108 GND net558 net546 net460 net558 net542 VDD net519 \
        net114) LB_crossbar_cell
    I1575 (net98 GND net553 net546 net460 net553 net558 VDD net519 net104) \
        LB_crossbar_cell
    I1574 (net150 GND net531 net511 net460 net531 net540 VDD net519 \
        net156) LB_crossbar_cell
    I1573 (net160 GND net541 net511 net460 net541 net525 VDD net519 \
        net166) LB_crossbar_cell
    I1604 (net38 GND net528 net511 net460 net528 net529 VDD net519 net44) \
        LB_crossbar_cell
    I1603 (net170 GND net525 net511 net460 net525 net528 VDD net519 \
        net176) LB_crossbar_cell
    I1601 (net170 GND net524 net510 net508 net526 net527 VDD net512 \
        net176) LB_crossbar_cell
    I1600 (net38 GND net527 net510 net508 net520 net526 VDD net512 net44) \
        LB_crossbar_cell
    I1599 (net48 GND net526 net510 net508 net522 net520 VDD net512 net54) \
        LB_crossbar_cell
    I1598 (net58 GND net520 net510 net508 net521 net522 VDD net512 net64) \
        LB_crossbar_cell
    I1597 (net68 GND net522 net510 net508 net73 net521 VDD net512 net74) \
        LB_crossbar_cell
    I1570 (net18 GND net543 net549 net508 net530 net544 VDD net512 net24) \
        LB_crossbar_cell
    I1569 (net28 GND net544 net549 net508 net537 net530 VDD net512 net34) \
        LB_crossbar_cell
    I1568 (net150 GND net530 net510 net508 net536 net537 VDD net512 \
        net156) LB_crossbar_cell
    I1567 (net6 GND net537 net510 net508 net524 net536 VDD net512 net12) \
        LB_crossbar_cell
    I1566 (net160 GND net536 net510 net508 net527 net524 VDD net512 \
        net166) LB_crossbar_cell
    I1188 (net160 GND net120 net119 net89 net120 net142 VDD net90 net166) \
        LB_crossbar_cell
    I1187 (net170 GND net142 net119 net89 net142 net141 VDD net90 net176) \
        LB_crossbar_cell
    I1186 (net38 GND net141 net119 net89 net141 net139 VDD net90 net44) \
        LB_crossbar_cell
    I1185 (net48 GND net139 net119 net89 net139 net138 VDD net90 net54) \
        LB_crossbar_cell
    I1184 (net58 GND net138 net119 net89 net138 net136 VDD net90 net64) \
        LB_crossbar_cell
    I1183 (net68 GND net136 net119 net89 net136 net137 VDD net90 net74) \
        LB_crossbar_cell
    I1278 (net88 GND net112 net368 net110 net130 net109 VDD net115 net94) \
        LB_crossbar_cell
    I1277 (net68 GND net127 net105 net79 net129 net128 VDD net99 net74) \
        LB_crossbar_cell
    I1276 (net58 GND net125 net105 net79 net128 net127 VDD net99 net64) \
        LB_crossbar_cell
    I1275 (net48 GND net117 net105 net79 net127 net125 VDD net99 net54) \
        LB_crossbar_cell
    I1274 (net38 GND net106 net105 net79 net125 net117 VDD net99 net44) \
        LB_crossbar_cell
    I1273 (net170 GND net107 net105 net79 net117 net106 VDD net99 net176) \
        LB_crossbar_cell
    I1279 (net78 GND net111 net368 net110 net109 net112 VDD net115 net84) \
        LB_crossbar_cell
    I1172 (net18 GND net124 net123 net89 net124 net122 VDD net90 net24) \
        LB_crossbar_cell
    I1171 (net28 GND net122 net123 net89 net122 net121 VDD net90 net34) \
        LB_crossbar_cell
    I1170 (net150 GND net121 net119 net89 net121 net118 VDD net90 net156) \
        LB_crossbar_cell
    I1169 (net6 GND net118 net119 net89 net118 net120 VDD net90 net12) \
        LB_crossbar_cell
    I1272 (net160 GND net102 net105 net79 net106 net107 VDD net99 net166) \
        LB_crossbar_cell
    I1270 (net150 GND net100 net105 net79 net102 net101 VDD net99 net156) \
        LB_crossbar_cell
    I1269 (net28 GND net75 net77 net79 net101 net100 VDD net99 net34) \
        LB_crossbar_cell
    I1268 (net18 GND net97 net77 net79 net100 net75 VDD net99 net24) \
        LB_crossbar_cell
    I1267 (net108 GND net80 net77 net79 net75 net97 VDD net99 net114) \
        LB_crossbar_cell
    I1162 (net88 GND net95 net87 net89 net95 net96 VDD net90 net94) \
        LB_crossbar_cell
    I1161 (net78 GND net92 net87 net89 net92 net95 VDD net90 net84) \
        LB_crossbar_cell
    I1160 (net140 GND net91 net87 net89 net91 net92 VDD net90 net146) \
        LB_crossbar_cell
    I1159 (net3 GND net90 net87 net89 net2381 net91 VDD net90 GND) \
        LB_crossbar_cell
    I1266 (net98 GND net320 net77 net79 net97 net80 VDD net99 net104) \
        LB_crossbar_cell
    I1265 (net6 GND net101 net105 net79 net107 net102 VDD net99 net12) \
        LB_crossbar_cell
    I1264 (net3 GND net99 net452 net79 net316 net427 VDD net99 GND) \
        LB_crossbar_cell
    I922 (net88 GND net307 net214 net258 net307 net326 VDD net260 net94) \
        LB_crossbar_cell
    I932 (net18 GND net324 net254 net258 net324 net305 VDD net260 net24) \
        LB_crossbar_cell
    I1376 (net38 GND net300 net183 net186 net315 net299 VDD net196 net44) \
        LB_crossbar_cell
    I948 (net160 GND net259 net257 net258 net259 net302 VDD net260 net166) \
        LB_crossbar_cell
    I1350 (net6 GND net312 net310 net154 net309 net314 VDD net159 net12) \
        LB_crossbar_cell
    I1028 (net160 GND net179 net177 net178 net179 net317 VDD net180 \
        net166) LB_crossbar_cell
    I1316 (net6 GND net261 net237 net243 net280 net279 VDD net255 net12) \
        LB_crossbar_cell
    I1329 (net88 GND net291 net298 net62 net308 net290 VDD net72 net94) \
        LB_crossbar_cell
    I1122 (net88 GND net289 net224 net217 net289 net313 VDD net219 net94) \
        LB_crossbar_cell
    I1296 (net78 GND net306 net153 net42 net304 net303 VDD net57 net84) \
        LB_crossbar_cell
    I1132 (net18 GND net311 net223 net217 net311 net287 VDD net219 net24) \
        LB_crossbar_cell
    I1295 (net88 GND net303 net153 net42 net301 net304 VDD net57 net94) \
        LB_crossbar_cell
    I1148 (net160 GND net227 net216 net217 net227 net284 VDD net219 \
        net166) LB_crossbar_cell
    I745 (net68 GND net63 net4 net9 net63 net73 VDD net13 net74) \
        LB_crossbar_cell
    I921 (net78 GND net283 net214 net258 net283 net307 VDD net260 net84) \
        LB_crossbar_cell
    I931 (net28 GND net305 net254 net258 net305 net281 VDD net260 net34) \
        LB_crossbar_cell
    I1375 (net170 GND net182 net183 net186 net299 net300 VDD net196 \
        net176) LB_crossbar_cell
    I1381 (net78 GND net297 net334 net135 net220 net282 VDD net145 net84) \
        LB_crossbar_cell
    I947 (net170 GND net302 net257 net258 net302 net275 VDD net260 net176) \
        LB_crossbar_cell
    I1349 (net3 GND net159 net187 net154 net296 net184 VDD net159 GND) \
        LB_crossbar_cell
    I1049 (net6 GND net292 net293 net240 net292 net294 VDD net242 net12) \
        LB_crossbar_cell
    I1330 (net78 GND net181 net298 net62 net290 net291 VDD net72 net84) \
        LB_crossbar_cell
    I1121 (net78 GND net269 net224 net217 net269 net289 VDD net219 net84) \
        LB_crossbar_cell
    I1294 (net68 GND net285 net233 net110 net288 net286 VDD net115 net74) \
        LB_crossbar_cell
    I1131 (net28 GND net287 net223 net217 net287 net267 VDD net219 net34) \
        LB_crossbar_cell
    I1293 (net58 GND net274 net233 net110 net286 net285 VDD net115 net64) \
        LB_crossbar_cell
    I1292 (net48 GND net273 net233 net110 net285 net274 VDD net115 net54) \
        LB_crossbar_cell
    I1147 (net170 GND net284 net216 net217 net284 net264 VDD net219 \
        net176) LB_crossbar_cell
    I723 (net58 GND net53 net4 net9 net53 net63 VDD net13 net64) \
        LB_crossbar_cell
    I920 (net140 GND net263 net214 net258 net263 net283 VDD net260 net146) \
        LB_crossbar_cell
    I1372 (net150 GND net222 net183 net186 net194 net188 VDD net196 \
        net156) LB_crossbar_cell
    I930 (net150 GND net281 net257 net258 net281 net256 VDD net260 net156) \
        LB_crossbar_cell
    I1380 (net88 GND net282 net334 net135 net221 net220 VDD net145 net94) \
        LB_crossbar_cell
    I946 (net38 GND net275 net257 net258 net275 net276 VDD net260 net44) \
        LB_crossbar_cell
    I1323 (net160 GND net279 net237 net243 net278 net280 VDD net255 \
        net166) LB_crossbar_cell
    I1319 (net18 GND net272 net265 net243 net268 net266 VDD net255 net24) \
        LB_crossbar_cell
    I1054 (net98 GND net271 net239 net240 net271 net238 VDD net242 net104) \
        LB_crossbar_cell
    I1326 (net48 GND net277 net237 net243 net246 net245 VDD net255 net54) \
        LB_crossbar_cell
    I1120 (net140 GND net232 net224 net217 net232 net269 VDD net219 \
        net146) LB_crossbar_cell
    I1291 (net38 GND net230 net233 net110 net274 net273 VDD net115 net44) \
        LB_crossbar_cell
    I1130 (net150 GND net267 net216 net217 net267 net226 VDD net219 \
        net156) LB_crossbar_cell
    I1290 (net170 GND net235 net233 net110 net273 net230 VDD net115 \
        net176) LB_crossbar_cell
    I1146 (net38 GND net264 net216 net217 net264 net215 VDD net219 net44) \
        LB_crossbar_cell
    I701 (net48 GND net43 net4 net9 net43 net53 VDD net13 net54) \
        LB_crossbar_cell
    I919 (net3 GND net260 net214 net258 net2189 net263 VDD net260 GND) \
        LB_crossbar_cell
    I1371 (net28 GND net229 net225 net186 net188 net222 VDD net196 net34) \
        LB_crossbar_cell
    I929 (net6 GND net256 net257 net258 net256 net259 VDD net260 net12) \
        LB_crossbar_cell
    I1025 (net48 GND net252 net177 net178 net252 net253 VDD net180 net54) \
        LB_crossbar_cell
    I1318 (net108 GND net270 net265 net243 net266 net272 VDD net255 \
        net114) LB_crossbar_cell
    I1320 (net28 GND net266 net265 net243 net261 net268 VDD net255 net34) \
        LB_crossbar_cell
    I1053 (net108 GND net238 net239 net240 net238 net241 VDD net242 \
        net114) LB_crossbar_cell
    I1327 (net58 GND net245 net237 net243 net236 net246 VDD net255 net64) \
        LB_crossbar_cell
    I1119 (net3 GND net219 net224 net217 net2349 net232 VDD net219 GND) \
        LB_crossbar_cell
    I1289 (net160 GND net234 net233 net110 net230 net235 VDD net115 \
        net166) LB_crossbar_cell
    I1129 (net6 GND net226 net216 net217 net226 net227 VDD net219 net12) \
        LB_crossbar_cell
    I1145 (net48 GND net215 net216 net217 net215 net218 VDD net219 net54) \
        LB_crossbar_cell
    I679 (net38 GND net36 net4 net9 net36 net43 VDD net13 net44) \
        LB_crossbar_cell
    I1370 (net18 GND net228 net225 net186 net222 net229 VDD net196 net24) \
        LB_crossbar_cell
    I569 (net28 GND net23 net14 net9 net23 net33 VDD net13 net34) \
        LB_crossbar_cell
    I1385 (net98 GND net220 net211 net135 net212 net221 VDD net145 net104) \
        LB_crossbar_cell
    I881 (net78 GND net151 net22 net32 net151 net19 VDD net55 net84) \
        LB_crossbar_cell
    I891 (net28 GND net205 net206 net32 net205 net207 VDD net55 net34) \
        LB_crossbar_cell
    I1392 (net170 GND net147 net132 net135 net208 net210 VDD net145 \
        net176) LB_crossbar_cell
    I1398 (net78 GND net201 net157 net198 net197 net202 VDD net203 net84) \
        LB_crossbar_cell
    I907 (net170 GND net199 net82 net32 net199 net200 VDD net55 net176) \
        LB_crossbar_cell
    I1367 (net6 GND net188 net183 net186 net182 net194 VDD net196 net12) \
        LB_crossbar_cell
    I987 (net170 GND net189 net190 net191 net189 net192 VDD net193 net176) \
        LB_crossbar_cell
    I1332 (net3 GND net72 net298 net62 net181 net396 VDD net72 GND) \
        LB_crossbar_cell
    I999 (net3 GND net180 net173 net178 net2253 net185 VDD net180 GND) \
        LB_crossbar_cell
    I1337 (net28 GND net171 net169 net62 net161 net174 VDD net72 net34) \
        LB_crossbar_cell
    I1009 (net6 GND net175 net177 net178 net175 net179 VDD net180 net12) \
        LB_crossbar_cell
    I1346 (net88 GND net155 net187 net154 net152 net158 VDD net159 net94) \
        LB_crossbar_cell
    I1107 (net170 GND net162 net163 net164 net162 net167 VDD net168 \
        net176) LB_crossbar_cell
    I547 (net18 GND net16 net14 net9 net16 net23 VDD net13 net24) \
        LB_crossbar_cell
    I1384 (net6 GND net144 net132 net135 net147 net131 VDD net145 net12) \
        LB_crossbar_cell
    I880 (net140 GND net149 net22 net32 net149 net151 VDD net55 net146) \
        LB_crossbar_cell
    I1389 (net150 GND net143 net132 net135 net131 net144 VDD net145 \
        net156) LB_crossbar_cell
    I890 (net150 GND net207 net82 net32 net207 net434 VDD net55 net156) \
        LB_crossbar_cell
    I1397 (net88 GND net202 net157 net198 net405 net197 VDD net203 net94) \
        LB_crossbar_cell
    I906 (net38 GND net200 net82 net32 net200 net430 VDD net55 net44) \
        LB_crossbar_cell
    I1366 (net3 GND net196 net251 net186 net383 net562 VDD net196 GND) \
        LB_crossbar_cell
    I986 (net38 GND net192 net190 net191 net192 net428 VDD net193 net44) \
        LB_crossbar_cell
    I1331 (net140 GND net396 net298 net62 net291 net181 VDD net72 net146) \
        LB_crossbar_cell
    I1336 (net18 GND net404 net169 net62 net174 net171 VDD net72 net24) \
        LB_crossbar_cell
    I1340 (net160 GND net402 net61 net62 net67 net403 VDD net72 net166) \
        LB_crossbar_cell
    I1312 (net88 GND net398 net195 net243 net270 net400 VDD net255 net94) \
        LB_crossbar_cell
    I1106 (net38 GND net167 net163 net164 net167 net415 VDD net168 net44) \
        LB_crossbar_cell
    I525 (net108 GND net103 net14 net9 net103 net16 VDD net13 net114) \
        LB_crossbar_cell
    I1383 (net3 GND net145 net334 net135 net297 net463 VDD net145 GND) \
        LB_crossbar_cell
    I879 (net3 GND net55 net22 net32 net2157 net149 VDD net55 GND) \
        LB_crossbar_cell
    I1388 (net28 GND net397 net211 net135 net144 net143 VDD net145 net34) \
        LB_crossbar_cell
    I889 (net6 GND net434 net82 net32 net434 net435 VDD net55 net12) \
        LB_crossbar_cell
    I1396 (net68 GND net390 net132 net135 net389 net394 VDD net145 net74) \
        LB_crossbar_cell
    I905 (net48 GND net430 net82 net32 net430 net81 VDD net55 net54) \
        LB_crossbar_cell
    I1365 (net140 GND net562 net251 net186 net359 net383 VDD net196 \
        net146) LB_crossbar_cell
    I985 (net48 GND net428 net190 net191 net428 net401 VDD net193 net54) \
        LB_crossbar_cell
    I1089 (net6 GND net421 net163 net164 net421 net422 VDD net168 net12) \
        LB_crossbar_cell
    I1311 (net68 GND net379 net40 net42 net376 net382 VDD net57 net74) \
        LB_crossbar_cell
    I1105 (net48 GND net415 net163 net164 net415 net416 VDD net168 net54) \
        LB_crossbar_cell
    I503 (net98 GND net93 net14 net9 net93 net103 VDD net13 net104) \
        LB_crossbar_cell
    I850 (net150 GND net412 net360 net364 net412 net392 VDD net366 net156) \
        LB_crossbar_cell
    I854 (net98 GND net411 net361 net364 net411 net391 VDD net366 net104) \
        LB_crossbar_cell
    I1409 (net170 GND net357 net335 net198 net336 net355 VDD net203 \
        net176) LB_crossbar_cell
    I1413 (net68 GND net333 net335 net198 net137 net354 VDD net203 net74) \
        LB_crossbar_cell
    I864 (net58 GND net407 net360 net364 net407 net387 VDD net366 net64) \
        LB_crossbar_cell
    I868 (net160 GND net393 net360 net364 net393 net385 VDD net366 net166) \
        LB_crossbar_cell
    I1382 (net140 GND net463 net334 net135 net282 net297 VDD net145 \
        net146) LB_crossbar_cell
    I1353 (net18 GND net369 net367 net154 net332 net370 VDD net159 net24) \
        LB_crossbar_cell
    I1363 (net88 GND net359 net251 net186 net358 net362 VDD net196 net94) \
        LB_crossbar_cell
    I984 (net58 GND net401 net190 net191 net401 net380 VDD net193 net64) \
        LB_crossbar_cell
    I1325 (net38 GND net278 net237 net243 net245 net277 VDD net255 net44) \
        LB_crossbar_cell
    I1065 (net48 GND net378 net293 net240 net378 net399 VDD net242 net54) \
        LB_crossbar_cell
    I1301 (net108 GND net301 net321 net42 net322 net351 VDD net57 net114) \
        LB_crossbar_cell
    I1081 (net78 GND net395 net373 net164 net395 net372 VDD net168 net84) \
        LB_crossbar_cell
    I481 (net88 GND net83 net15 net9 net83 net93 VDD net13 net94) \
        LB_crossbar_cell
    I1406 (net150 GND net348 net335 net198 net356 net344 VDD net203 \
        net156) LB_crossbar_cell
    I849 (net6 GND net392 net360 net364 net392 net393 VDD net366 net12) \
        LB_crossbar_cell
    I853 (net108 GND net391 net361 net364 net391 net363 VDD net366 net114) \
        LB_crossbar_cell
    I1408 (net160 GND net356 net335 net198 net355 net357 VDD net203 \
        net166) LB_crossbar_cell
    I1412 (net58 GND net343 net335 net198 net354 net333 VDD net203 net64) \
        LB_crossbar_cell
    I863 (net68 GND net387 net360 net364 net387 net129 VDD net366 net74) \
        LB_crossbar_cell
    I867 (net170 GND net385 net360 net364 net385 net386 VDD net366 net176) \
        LB_crossbar_cell
    I973 (net108 GND net384 net347 net191 net384 net349 VDD net193 net114) \
        LB_crossbar_cell
    I1358 (net170 GND net309 net310 net154 net353 net331 VDD net159 \
        net176) LB_crossbar_cell
    I1362 (net68 GND net330 net310 net154 net342 net325 VDD net159 net74) \
        LB_crossbar_cell
    I983 (net68 GND net380 net190 net191 net380 net381 VDD net193 net74) \
        LB_crossbar_cell
    I1066 (net38 GND net340 net293 net240 net340 net378 VDD net242 net44) \
        LB_crossbar_cell
    I1302 (net18 GND net351 net321 net42 net323 net322 VDD net57 net24) \
        LB_crossbar_cell
    I1082 (net88 GND net372 net373 net164 net372 net374 VDD net168 net94) \
        LB_crossbar_cell
    I459 (net78 GND net76 net15 net9 net76 net83 VDD net13 net84) \
        LB_crossbar_cell
    I1405 (net28 GND net346 net345 net198 net344 net348 VDD net203 net34) \
        LB_crossbar_cell
    I852 (net18 GND net363 net361 net364 net363 net365 VDD net366 net24) \
        LB_crossbar_cell
    I1411 (net48 GND net336 net335 net198 net333 net343 VDD net203 net54) \
        LB_crossbar_cell
    I1355 (net150 GND net332 net310 net154 net314 net312 VDD net159 \
        net156) LB_crossbar_cell
    I1357 (net160 GND net314 net310 net154 net331 net309 VDD net159 \
        net166) LB_crossbar_cell
    I972 (net18 GND net349 net347 net191 net349 net350 VDD net193 net24) \
        LB_crossbar_cell
    I1361 (net58 GND net328 net310 net154 net325 net330 VDD net159 net64) \
        LB_crossbar_cell
    I1063 (net68 GND net341 net293 net240 net341 net342 VDD net242 net74) \
        LB_crossbar_cell
    I1067 (net170 GND net339 net293 net240 net339 net340 VDD net242 \
        net176) LB_crossbar_cell
    I1303 (net28 GND net322 net321 net42 net51 net323 VDD net57 net34) \
        LB_crossbar_cell
    I787 (net170 GND net27 net31 net21 net47 net50 VDD net25 net176) \
        LB_crossbar_cell
    I786 (net38 GND net50 net31 net21 net49 net47 VDD net25 net44) \
        LB_crossbar_cell
    I785 (net48 GND net47 net31 net21 net66 net49 VDD net25 net54) \
        LB_crossbar_cell
    I784 (net58 GND net49 net31 net21 net244 net66 VDD net25 net64) \
        LB_crossbar_cell
    I783 (net68 GND net66 net31 net21 net204 net244 VDD net25 net74) \
        LB_crossbar_cell
    I781 (net98 GND net8 net39 net21 net35 net5 VDD net25 net104) \
        LB_crossbar_cell
    I780 (net108 GND net5 net39 net21 net30 net35 VDD net25 net114) \
        LB_crossbar_cell
    I779 (net18 GND net35 net39 net21 net65 net30 VDD net25 net24) \
        LB_crossbar_cell
    I778 (net28 GND net30 net39 net21 net45 net65 VDD net25 net34) \
        LB_crossbar_cell
    I777 (net150 GND net65 net31 net21 net46 net45 VDD net25 net156) \
        LB_crossbar_cell
    I776 (net6 GND net45 net31 net21 net27 net46 VDD net25 net12) \
        LB_crossbar_cell
    I773 (net88 GND net60 net20 net21 net5 net8 VDD net25 net94) \
        LB_crossbar_cell
    I772 (net78 GND net56 net20 net21 net8 net60 VDD net25 net84) \
        LB_crossbar_cell
    I771 (net140 GND net126 net20 net21 net60 net56 VDD net25 net146) \
        LB_crossbar_cell
    I770 (net3 GND net25 net20 net21 net56 net126 VDD net25 GND) \
        LB_crossbar_cell
    I1425 (net160 GND net424 net420 net408 net442 net418 VDD net409 \
        net166) LB_crossbar_cell
    I1426 (net170 GND net418 net420 net408 net441 net442 VDD net409 \
        net176) LB_crossbar_cell
    I1427 (net38 GND net442 net420 net408 net440 net441 VDD net409 net44) \
        LB_crossbar_cell
    I1428 (net48 GND net441 net420 net408 net438 net440 VDD net409 net54) \
        LB_crossbar_cell
    I1429 (net58 GND net440 net420 net408 net439 net438 VDD net409 net64) \
        LB_crossbar_cell
    I1430 (net68 GND net438 net420 net408 net641 net439 VDD net409 net74) \
        LB_crossbar_cell
    I814 (net98 GND net468 net516 net445 net468 net518 VDD net447 net104) \
        LB_crossbar_cell
    I813 (net108 GND net518 net516 net445 net518 net517 VDD net447 net114) \
        LB_crossbar_cell
    I812 (net18 GND net517 net516 net445 net517 net515 VDD net447 net24) \
        LB_crossbar_cell
    I811 (net28 GND net515 net516 net445 net515 net514 VDD net447 net34) \
        LB_crossbar_cell
    I810 (net150 GND net514 net444 net445 net514 net513 VDD net447 net156) \
        LB_crossbar_cell
    I809 (net6 GND net513 net444 net445 net513 net477 VDD net447 net12) \
        LB_crossbar_cell
    I1419 (net98 GND net413 net431 net408 net436 net437 VDD net409 net104) \
        LB_crossbar_cell
    I1420 (net108 GND net437 net431 net408 net432 net436 VDD net409 \
        net114) LB_crossbar_cell
    I1421 (net18 GND net436 net431 net408 net429 net432 VDD net409 net24) \
        LB_crossbar_cell
    I788 (net160 GND net46 net31 net21 net50 net27 VDD net25 net166) \
        LB_crossbar_cell
    I1079 (net3 GND net168 net373 net164 net2317 net495 VDD net168 GND) \
        LB_crossbar_cell
    I1304 (net150 GND net323 net40 net42 net52 net51 VDD net57 net156) \
        LB_crossbar_cell
    I437 (net140 GND net133 net15 net9 net133 net76 VDD net13 net146) \
        LB_crossbar_cell
    I961 (net78 GND net502 net319 net191 net502 net503 VDD net193 net84) \
        LB_crossbar_cell
    I1354 (net28 GND net370 net367 net154 net312 net332 VDD net159 net34) \
        LB_crossbar_cell
    I971 (net28 GND net350 net347 net191 net350 net500 VDD net193 net34) \
        LB_crossbar_cell
    I1360 (net48 GND net353 net310 net154 net330 net328 VDD net159 net54) \
        LB_crossbar_cell
    I1364 (net78 GND net383 net251 net186 net362 net359 VDD net196 net84) \
        LB_crossbar_cell
    I1064 (net58 GND net399 net293 net240 net399 net341 VDD net242 net64) \
        LB_crossbar_cell
    I1068 (net160 GND net294 net293 net240 net294 net339 VDD net242 \
        net166) LB_crossbar_cell
    I1300 (net98 GND net304 net321 net42 net351 net301 VDD net57 net104) \
        LB_crossbar_cell
    I1080 (net140 GND net495 net373 net164 net495 net395 VDD net168 \
        net146) LB_crossbar_cell
    I415 (net3 GND net13 net15 net9 net134 net133 VDD net13 GND) \
        LB_crossbar_cell
    I1404 (net18 GND net433 net345 net198 net348 net346 VDD net203 net24) \
        LB_crossbar_cell
    I851 (net28 GND net365 net361 net364 net365 net412 VDD net366 net34) \
        LB_crossbar_cell
    I1403 (net108 GND net405 net345 net198 net346 net433 VDD net203 \
        net114) LB_crossbar_cell
    I1402 (net98 GND net197 net345 net198 net433 net405 VDD net203 net104) \
        LB_crossbar_cell
    I842 (net88 GND net492 net489 net364 net492 net411 VDD net366 net94) \
        LB_crossbar_cell
    I841 (net78 GND net491 net489 net364 net491 net492 VDD net366 net84) \
        LB_crossbar_cell
    I840 (net140 GND net490 net489 net364 net490 net491 VDD net366 net146) \
        LB_crossbar_cell
    I839 (net3 GND net366 net489 net364 net2125 net490 VDD net366 GND) \
        LB_crossbar_cell
    I1262 (net78 GND net316 net452 net79 net320 net417 VDD net99 net84) \
        LB_crossbar_cell
    I1401 (net6 GND net344 net335 net198 net357 net356 VDD net203 net12) \
        LB_crossbar_cell
    I1400 (net3 GND net203 net157 net198 net201 net231 VDD net203 GND) \
        LB_crossbar_cell
    I1399 (net140 GND net231 net157 net198 net202 net201 VDD net203 \
        net146) LB_crossbar_cell
    I828 (net160 GND net477 net444 net445 net477 net476 VDD net447 net166) \
        LB_crossbar_cell
    I827 (net170 GND net476 net444 net445 net476 net443 VDD net447 net176) \
        LB_crossbar_cell
    I1333 (net6 GND net161 net61 net62 net403 net402 VDD net72 net12) \
        LB_crossbar_cell
    I1422 (net28 GND net432 net431 net408 net423 net429 VDD net409 net34) \
        LB_crossbar_cell
    I1423 (net150 GND net429 net420 net408 net424 net423 VDD net409 \
        net156) LB_crossbar_cell
    I1418 (net6 GND net423 net420 net408 net418 net424 VDD net409 net12) \
        LB_crossbar_cell
    I802 (net88 GND net467 net464 net445 net467 net468 VDD net447 net94) \
        LB_crossbar_cell
    I801 (net78 GND net466 net464 net445 net466 net467 VDD net447 net84) \
        LB_crossbar_cell
    I800 (net140 GND net465 net464 net445 net465 net466 VDD net447 net146) \
        LB_crossbar_cell
    I799 (net3 GND net447 net464 net445 net2093 net465 VDD net447 GND) \
        LB_crossbar_cell
    I1261 (net88 GND net417 net452 net79 net80 net320 VDD net99 net94) \
        LB_crossbar_cell
    I1415 (net78 GND net406 net113 net408 net413 net410 VDD net409 net84) \
        LB_crossbar_cell
    I1416 (net140 GND net86 net113 net408 net410 net406 VDD net409 net146) \
        LB_crossbar_cell
    I1417 (net3 GND net409 net113 net408 net406 net86 VDD net409 GND) \
        LB_crossbar_cell
    I823 (net68 GND net449 net444 net445 net449 net204 VDD net447 net74) \
        LB_crossbar_cell
    I824 (net58 GND net448 net444 net445 net448 net449 VDD net447 net64) \
        LB_crossbar_cell
    I825 (net48 GND net446 net444 net445 net446 net448 VDD net447 net54) \
        LB_crossbar_cell
    I826 (net38 GND net443 net444 net445 net443 net446 VDD net447 net44) \
        LB_crossbar_cell
    I1287 (net150 GND net462 net233 net110 net234 net469 VDD net115 \
        net156) LB_crossbar_cell
    I1286 (net28 GND net455 net148 net110 net469 net462 VDD net115 net34) \
        LB_crossbar_cell
    I1285 (net18 GND net456 net148 net110 net462 net455 VDD net115 net24) \
        LB_crossbar_cell
    I1133 (net108 GND net579 net223 net217 net579 net311 VDD net219 \
        net114) LB_crossbar_cell
    I1092 (net18 GND net535 net419 net164 net535 net578 VDD net168 net24) \
        LB_crossbar_cell
    I1307 (net170 GND net37 net40 net42 net450 net459 VDD net57 net176) \
        LB_crossbar_cell
    I1347 (net78 GND net296 net187 net154 net158 net155 VDD net159 net84) \
        LB_crossbar_cell
    I1010 (net150 GND net574 net177 net178 net574 net175 VDD net180 \
        net156) LB_crossbar_cell
    I1338 (net150 GND net174 net61 net62 net402 net161 VDD net72 net156) \
        LB_crossbar_cell
    I1000 (net140 GND net185 net173 net178 net185 net572 VDD net180 \
        net146) LB_crossbar_cell
    I865 (net48 GND net554 net360 net364 net554 net407 VDD net366 net54) \
        LB_crossbar_cell
    I1414 (net88 GND net410 net113 net408 net437 net413 VDD net409 net94) \
        LB_crossbar_cell
    I1410 (net38 GND net355 net335 net198 net343 net336 VDD net203 net44) \
        LB_crossbar_cell
    I1324 (net170 GND net280 net237 net243 net277 net278 VDD net255 \
        net176) LB_crossbar_cell
    I1051 (net28 GND net567 net239 net240 net567 net568 VDD net242 net34) \
        LB_crossbar_cell
    I1041 (net78 GND net563 net248 net240 net563 net564 VDD net242 net84) \
        LB_crossbar_cell
    I1315 (net3 GND net255 net195 net243 net458 net262 VDD net255 GND) \
        LB_crossbar_cell
    I988 (net160 GND net533 net190 net191 net533 net189 VDD net193 net166) \
        LB_crossbar_cell
    I892 (net18 GND net560 net206 net32 net560 net205 VDD net55 net24) \
        LB_crossbar_cell
    I1393 (net38 GND net210 net132 net135 net457 net208 VDD net145 net44) \
        LB_crossbar_cell
    I908 (net160 GND net435 net82 net32 net435 net199 VDD net55 net166) \
        LB_crossbar_cell
    I1368 (net98 GND net362 net225 net186 net228 net358 VDD net196 net104) \
        LB_crossbar_cell
    I962 (net88 GND net503 net319 net191 net503 net556 VDD net193 net94) \
        LB_crossbar_cell
    I866 (net38 GND net386 net360 net364 net386 net554 VDD net366 net44) \
        LB_crossbar_cell
    I943 (net68 GND net551 net257 net258 net551 net376 VDD net260 net74) \
        LB_crossbar_cell
    I1351 (net98 GND net158 net367 net154 net369 net152 VDD net159 net104) \
        LB_crossbar_cell
    I1024 (net58 GND net253 net177 net178 net253 net547 VDD net180 net64) \
        LB_crossbar_cell
    I591 (net150 GND net33 net4 net9 net33 net1 VDD net13 net156) \
        LB_crossbar_cell
    I1284 (net108 GND net130 net148 net110 net455 net456 VDD net115 \
        net114) LB_crossbar_cell
    I1103 (net68 GND net538 net163 net164 net538 net539 VDD net168 net74) \
        LB_crossbar_cell
    I1309 (net48 GND net450 net40 net42 net379 net454 VDD net57 net54) \
        LB_crossbar_cell
    I1093 (net108 GND net534 net419 net164 net534 net535 VDD net168 \
        net114) LB_crossbar_cell
    I969 (net6 GND net532 net190 net191 net532 net533 VDD net193 net12) \
        LB_crossbar_cell
    I1352 (net108 GND net152 net367 net154 net370 net369 VDD net159 \
        net114) LB_crossbar_cell
    I1377 (net48 GND net299 net183 net186 net473 net315 VDD net196 net54) \
        LB_crossbar_cell
    I933 (net108 GND net616 net254 net258 net616 net324 VDD net260 net114) \
        LB_crossbar_cell
    I1369 (net108 GND net358 net225 net186 net229 net228 VDD net196 \
        net114) LB_crossbar_cell
    I1334 (net98 GND net290 net169 net62 net404 net308 VDD net72 net104) \
        LB_crossbar_cell
    I1001 (net78 GND net572 net173 net178 net572 net595 VDD net180 net84) \
        LB_crossbar_cell
    I1011 (net28 GND net592 net172 net178 net592 net574 VDD net180 net34) \
        LB_crossbar_cell
    I1341 (net170 GND net403 net61 net62 net71 net67 VDD net72 net176) \
        LB_crossbar_cell
    I970 (net150 GND net500 net190 net191 net500 net532 VDD net193 net156) \
        LB_crossbar_cell
    I974 (net98 GND net556 net347 net191 net556 net384 VDD net193 net104) \
        LB_crossbar_cell
    I1359 (net38 GND net331 net310 net154 net328 net353 VDD net159 net44) \
        LB_crossbar_cell
    I1283 (net98 GND net109 net148 net110 net456 net130 VDD net115 net104) \
        LB_crossbar_cell
    I1134 (net98 GND net313 net223 net217 net313 net579 VDD net219 net104) \
        LB_crossbar_cell
    I1282 (net6 GND net469 net233 net110 net235 net234 VDD net115 net12) \
        LB_crossbar_cell
    I1144 (net58 GND net218 net216 net217 net218 net613 VDD net219 net64) \
        LB_crossbar_cell
    I657 (net170 GND net165 net4 net9 net165 net36 VDD net13 net176) \
        LB_crossbar_cell
    I903 (net68 GND net85 net82 net32 net85 net288 VDD net55 net74) \
        LB_crossbar_cell
    I1394 (net48 GND net208 net132 net135 net390 net457 VDD net145 net54) \
        LB_crossbar_cell
    I893 (net108 GND net594 net206 net32 net594 net560 VDD net55 net114) \
        LB_crossbar_cell
    I1386 (net108 GND net221 net211 net135 net397 net212 VDD net145 \
        net114) LB_crossbar_cell
    I1344 (net58 GND net59 net61 net62 net471 net470 VDD net72 net64) \
        LB_crossbar_cell
    I1013 (net108 GND net628 net172 net178 net628 net587 VDD net180 \
        net114) LB_crossbar_cell
    I1335 (net108 GND net308 net169 net62 net171 net404 VDD net72 net114) \
        LB_crossbar_cell
    I1281 (net3 GND net115 net368 net110 net111 net485 VDD net115 GND) \
        LB_crossbar_cell
    I1328 (net68 GND net246 net237 net243 net381 net236 VDD net255 net74) \
        LB_crossbar_cell
    I1052 (net18 GND net241 net239 net240 net241 net567 VDD net242 net24) \
        LB_crossbar_cell
    I1321 (net150 GND net268 net237 net243 net279 net261 VDD net255 \
        net156) LB_crossbar_cell
    I1343 (net48 GND net71 net61 net62 net470 net59 VDD net72 net54) \
        LB_crossbar_cell
    I1298 (net3 GND net57 net153 net42 net306 net209 VDD net57 GND) \
        LB_crossbar_cell
    I1094 (net98 GND net374 net419 net164 net374 net534 VDD net168 net104) \
        LB_crossbar_cell
    I1310 (net58 GND net454 net40 net42 net382 net379 VDD net57 net64) \
        LB_crossbar_cell
    I1104 (net58 GND net416 net163 net164 net416 net538 VDD net168 net64) \
        LB_crossbar_cell
    I1014 (net98 GND net623 net172 net178 net623 net628 VDD net180 net104) \
        LB_crossbar_cell
    I1345 (net68 GND net470 net61 net62 net626 net471 VDD net72 net74) \
        LB_crossbar_cell
    I1090 (net150 GND net618 net163 net164 net618 net421 VDD net168 \
        net156) LB_crossbar_cell
    I1023 (net68 GND net547 net177 net178 net547 net626 VDD net180 net74) \
        LB_crossbar_cell
    I1042 (net88 GND net564 net248 net240 net564 net271 VDD net242 net94) \
        LB_crossbar_cell
    I1012 (net18 GND net587 net172 net178 net587 net592 VDD net180 net24) \
        LB_crossbar_cell
    I1002 (net88 GND net595 net173 net178 net595 net623 VDD net180 net94) \
        LB_crossbar_cell
    I1313 (net78 GND net458 net195 net243 net400 net398 VDD net255 net84) \
        LB_crossbar_cell
    I1297 (net140 GND net209 net153 net42 net303 net306 VDD net57 net146) \
        LB_crossbar_cell
    I1091 (net28 GND net578 net419 net164 net578 net618 VDD net168 net34) \
        LB_crossbar_cell
    I1306 (net160 GND net52 net40 net42 net459 net37 VDD net57 net166) \
        LB_crossbar_cell
    I944 (net58 GND net590 net257 net258 net590 net551 VDD net260 net64) \
        LB_crossbar_cell
    I1378 (net58 GND net315 net183 net186 net474 net473 VDD net196 net64) \
        LB_crossbar_cell
    I934 (net98 GND net326 net254 net258 net326 net616 VDD net260 net104) \
        LB_crossbar_cell
    I1374 (net160 GND net194 net183 net186 net300 net182 VDD net196 \
        net166) LB_crossbar_cell
    I1143 (net68 GND net613 net216 net217 net613 net389 VDD net219 net74) \
        LB_crossbar_cell
    I635 (net160 GND net11 net4 net9 net11 net165 VDD net13 net166) \
        LB_crossbar_cell
    I1387 (net18 GND net212 net211 net135 net143 net397 VDD net145 net24) \
        LB_crossbar_cell
    I1391 (net160 GND net131 net132 net135 net210 net147 VDD net145 \
        net166) LB_crossbar_cell
    I894 (net98 GND net41 net206 net32 net41 net594 VDD net55 net104) \
        LB_crossbar_cell
    I1395 (net58 GND net457 net132 net135 net394 net390 VDD net145 net64) \
        LB_crossbar_cell
    I1308 (net38 GND net459 net40 net42 net454 net450 VDD net57 net44) \
        LB_crossbar_cell
    I1108 (net160 GND net422 net163 net164 net422 net162 VDD net168 \
        net166) LB_crossbar_cell
    I1280 (net140 GND net485 net368 net110 net112 net111 VDD net115 \
        net146) LB_crossbar_cell
    I959 (net3 GND net193 net319 net191 net548 net607 VDD net193 GND) \
        LB_crossbar_cell
    I945 (net48 GND net276 net257 net258 net276 net590 VDD net260 net54) \
        LB_crossbar_cell
    I1379 (net68 GND net473 net183 net186 net539 net474 VDD net196 net74) \
        LB_crossbar_cell
    I1314 (net140 GND net262 net195 net243 net398 net458 VDD net255 \
        net146) LB_crossbar_cell
    I1348 (net140 GND net184 net187 net154 net155 net296 VDD net159 \
        net146) LB_crossbar_cell
    I960 (net140 GND net607 net319 net191 net607 net502 VDD net193 net146) \
        LB_crossbar_cell
    I1026 (net38 GND net589 net177 net178 net589 net252 VDD net180 net44) \
        LB_crossbar_cell
    I1039 (net3 GND net242 net248 net240 net2285 net599 VDD net242 GND) \
        LB_crossbar_cell
    I1317 (net98 GND net400 net265 net243 net272 net270 VDD net255 net104) \
        LB_crossbar_cell
    I1027 (net170 GND net317 net177 net178 net317 net589 VDD net180 \
        net176) LB_crossbar_cell
    I1040 (net140 GND net599 net248 net240 net599 net563 VDD net242 \
        net146) LB_crossbar_cell
    I1050 (net150 GND net568 net293 net240 net568 net292 VDD net242 \
        net156) LB_crossbar_cell
    I1263 (net140 GND net427 net452 net79 net417 net316 VDD net99 net146) \
        LB_crossbar_cell
    I1545 (net3 GND net512 net559 net508 net566 net575 VDD net512 GND) \
        LB_crossbar_cell
    I1546 (net140 GND net575 net559 net508 net569 net566 VDD net512 \
        net146) LB_crossbar_cell
    I1547 (net78 GND net566 net559 net508 net555 net569 VDD net512 net84) \
        LB_crossbar_cell
    I1548 (net88 GND net569 net559 net508 net557 net555 VDD net512 net94) \
        LB_crossbar_cell
    I1174 (net98 GND net96 net123 net89 net96 net600 VDD net90 net104) \
        LB_crossbar_cell
    I1173 (net108 GND net600 net123 net89 net600 net124 VDD net90 net114) \
        LB_crossbar_cell
    I1553 (net3 GND net519 net561 net460 net2422 net576 VDD net519 GND) \
        LB_crossbar_cell
    I1554 (net140 GND net576 net561 net460 net576 net565 VDD net519 \
        net146) LB_crossbar_cell
    I1555 (net78 GND net565 net561 net460 net565 net570 VDD net519 net84) \
        LB_crossbar_cell
    I1556 (net88 GND net570 net561 net460 net570 net553 VDD net519 net94) \
        LB_crossbar_cell
    I1605 (net48 GND net529 net511 net460 net529 net509 VDD net519 net54) \
        LB_crossbar_cell
    I1606 (net58 GND net509 net511 net460 net509 net523 VDD net519 net64) \
        LB_crossbar_cell
    I1607 (net68 GND net523 net511 net460 net523 net337 VDD net519 net74) \
        LB_crossbar_cell
    I1571 (net108 GND net557 net549 net508 net544 net543 VDD net512 \
        net114) LB_crossbar_cell
    I1572 (net98 GND net555 net549 net508 net543 net557 VDD net512 net104) \
        LB_crossbar_cell
    I1260 (SDI net10 net641 VDD GND) DFQD1BWP12T30P140
    I1557 (net2411 net460 net2422 VDD GND) DFQD1BWP12T30P140
    I1477 (net2113 net364 net2125 VDD GND) DFQD1BWP12T30P140
    I1493 (net2177 net258 net2189 VDD GND) DFQD1BWP12T30P140
    I1509 (net2241 net178 net2253 VDD GND) DFQD1BWP12T30P140
    I1517 (net2273 net240 net2285 VDD GND) DFQD1BWP12T30P140
    I1470 (net485 net110 net2113 VDD GND) DFQD1BWP12T30P140
    I1486 (net262 net243 net2177 VDD GND) DFQD1BWP12T30P140
    I1485 (net2145 net32 net2157 VDD GND) DFQD1BWP12T30P140
    I1469 (net2081 net445 net2093 VDD GND) DFQD1BWP12T30P140
    I1478 (net209 net42 net2145 VDD GND) DFQD1BWP12T30P140
    I1518 (net463 net135 net2305 VDD GND) DFQD1BWP12T30P140
    I1460 (net472 net9 net134 VDD GND) DFQD1BWP12T30P140
    I1494 (net396 net62 net2209 VDD GND) DFQD1BWP12T30P140
    I1510 (net562 net186 net2273 VDD GND) DFQD1BWP12T30P140
    I1501 (net2209 net191 net548 VDD GND) DFQD1BWP12T30P140
    I1502 (net184 net154 net2241 VDD GND) DFQD1BWP12T30P140
    I1526 (net231 net198 net2337 VDD GND) DFQD1BWP12T30P140
    I1461 (net126 net21 net472 VDD GND) DFQD1BWP12T30P140
    I1534 (net86 net408 net2369 VDD GND) DFQD1BWP12T30P140
    I1533 (net2337 net217 net2349 VDD GND) DFQD1BWP12T30P140
    I1541 (net2369 net89 net2381 VDD GND) DFQD1BWP12T30P140
    I1462 (net427 net79 net2081 VDD GND) DFQD1BWP12T30P140
    I1549 (net575 net508 net2411 VDD GND) DFQD1BWP12T30P140
    I1525 (net2305 net164 net2317 VDD GND) DFQD1BWP12T30P140
    I1431 (net352 net10 VDD GND) INVD0BWP12T30P140
    I1474 (net377 net368 net375 VDD GND) NR2D1BWP12T30P140
    I1484 (net327 net22 net329 VDD GND) NR2D1BWP12T30P140
    I1490 (net295 net195 net318 VDD GND) NR2D1BWP12T30P140
    I1500 (net249 net319 net250 VDD GND) NR2D1BWP12T30P140
    I1506 (net213 net187 net247 VDD GND) NR2D1BWP12T30P140
    I1492 (net425 net214 net426 VDD GND) NR2D1BWP12T30P140
    I1498 (net475 net298 net414 VDD GND) NR2D1BWP12T30P140
    I1514 (net451 net251 net453 VDD GND) NR2D1BWP12T30P140
    I1468 (net484 net464 net482 VDD GND) NR2D1BWP12T30P140
    I1476 (net338 net489 net461 VDD GND) NR2D1BWP12T30P140
    I1466 (net478 net452 net479 VDD GND) NR2D1BWP12T30P140
    I411 (net17 net15 net7 VDD GND) NR2D1BWP12T30P140
    I1482 (net488 net153 net487 VDD GND) NR2D1BWP12T30P140
    I1524 (net493 net373 net481 VDD GND) NR2D1BWP12T30P140
    I1508 (net70 net173 net486 VDD GND) NR2D1BWP12T30P140
    I1530 (net506 net157 net507 VDD GND) NR2D1BWP12T30P140
    I1532 (net504 net224 net505 VDD GND) NR2D1BWP12T30P140
    I1538 (net499 net113 net501 VDD GND) NR2D1BWP12T30P140
    I1543 (net577 net559 net581 VDD GND) NR2D1BWP12T30P140
    I1540 (net497 net87 net498 VDD GND) NR2D1BWP12T30P140
    I1432 (net29 net20 net26 VDD GND) NR2D1BWP12T30P140
    I1551 (net582 net561 net580 VDD GND) NR2D1BWP12T30P140
    I1522 (net494 net334 net480 VDD GND) NR2D1BWP12T30P140
    I1516 (net496 net248 net483 VDD GND) NR2D1BWP12T30P140
    I1504 (net173 net70 VDD GND) DEL050D1BWP12T30P140
    I1472 (net489 net338 VDD GND) DEL050D1BWP12T30P140
    I1487 (net195 net295 VDD GND) DEL050D1BWP12T30P140
    I1503 (net187 net213 VDD GND) DEL050D1BWP12T30P140
    I1471 (net368 net377 VDD GND) DEL050D1BWP12T30P140
    I1511 (net251 net451 VDD GND) DEL050D1BWP12T30P140
    I1480 (net22 net327 VDD GND) DEL050D1BWP12T30P140
    I769 (net20 net29 VDD GND) DEL050D1BWP12T30P140
    I412 (net15 net17 VDD GND) DEL050D1BWP12T30P140
    I1520 (net373 net493 VDD GND) DEL050D1BWP12T30P140
    I1488 (net214 net425 VDD GND) DEL050D1BWP12T30P140
    I1479 (net153 net488 VDD GND) DEL050D1BWP12T30P140
    I1464 (net464 net484 VDD GND) DEL050D1BWP12T30P140
    I1495 (net298 net475 VDD GND) DEL050D1BWP12T30P140
    I1512 (net248 net496 VDD GND) DEL050D1BWP12T30P140
    I1527 (net157 net506 VDD GND) DEL050D1BWP12T30P140
    I1496 (net319 net249 VDD GND) DEL050D1BWP12T30P140
    I1528 (net224 net504 VDD GND) DEL050D1BWP12T30P140
    I1535 (net113 net499 VDD GND) DEL050D1BWP12T30P140
    I1536 (net87 net497 VDD GND) DEL050D1BWP12T30P140
    I1463 (net452 net478 VDD GND) DEL050D1BWP12T30P140
    I1544 (net559 net577 VDD GND) DEL050D1BWP12T30P140
    I1552 (net561 net582 VDD GND) DEL050D1BWP12T30P140
    I1519 (net334 net494 VDD GND) DEL050D1BWP12T30P140
    I1639_39 (VDD GND) DCAP8BWP12T30P140
    I1639_38 (VDD GND) DCAP8BWP12T30P140
    I1639_37 (VDD GND) DCAP8BWP12T30P140
    I1639_36 (VDD GND) DCAP8BWP12T30P140
    I1639_35 (VDD GND) DCAP8BWP12T30P140
    I1639_34 (VDD GND) DCAP8BWP12T30P140
    I1639_33 (VDD GND) DCAP8BWP12T30P140
    I1639_32 (VDD GND) DCAP8BWP12T30P140
    I1639_31 (VDD GND) DCAP8BWP12T30P140
    I1639_30 (VDD GND) DCAP8BWP12T30P140
    I1639_29 (VDD GND) DCAP8BWP12T30P140
    I1639_28 (VDD GND) DCAP8BWP12T30P140
    I1639_27 (VDD GND) DCAP8BWP12T30P140
    I1639_26 (VDD GND) DCAP8BWP12T30P140
    I1639_25 (VDD GND) DCAP8BWP12T30P140
    I1639_24 (VDD GND) DCAP8BWP12T30P140
    I1639_23 (VDD GND) DCAP8BWP12T30P140
    I1639_22 (VDD GND) DCAP8BWP12T30P140
    I1639_21 (VDD GND) DCAP8BWP12T30P140
    I1639_20 (VDD GND) DCAP8BWP12T30P140
    I1639_19 (VDD GND) DCAP8BWP12T30P140
    I1639_18 (VDD GND) DCAP8BWP12T30P140
    I1639_17 (VDD GND) DCAP8BWP12T30P140
    I1639_16 (VDD GND) DCAP8BWP12T30P140
    I1639_15 (VDD GND) DCAP8BWP12T30P140
    I1639_14 (VDD GND) DCAP8BWP12T30P140
    I1639_13 (VDD GND) DCAP8BWP12T30P140
    I1639_12 (VDD GND) DCAP8BWP12T30P140
    I1639_11 (VDD GND) DCAP8BWP12T30P140
    I1639_10 (VDD GND) DCAP8BWP12T30P140
    I1639_9 (VDD GND) DCAP8BWP12T30P140
    I1639_8 (VDD GND) DCAP8BWP12T30P140
    I1639_7 (VDD GND) DCAP8BWP12T30P140
    I1639_6 (VDD GND) DCAP8BWP12T30P140
    I1639_5 (VDD GND) DCAP8BWP12T30P140
    I1639_4 (VDD GND) DCAP8BWP12T30P140
    I1639_3 (VDD GND) DCAP8BWP12T30P140
    I1639_2 (VDD GND) DCAP8BWP12T30P140
    I1639_1 (VDD GND) DCAP8BWP12T30P140
    I1640_4 (VDD GND) DCAP16BWP12T30P140
    I1640_3 (VDD GND) DCAP16BWP12T30P140
    I1640_2 (VDD GND) DCAP16BWP12T30P140
    I1640_1 (VDD GND) DCAP16BWP12T30P140
    I1641_8 (VDD GND) DCAP32BWP12T30P140
    I1641_7 (VDD GND) DCAP32BWP12T30P140
    I1641_6 (VDD GND) DCAP32BWP12T30P140
    I1641_5 (VDD GND) DCAP32BWP12T30P140
    I1641_4 (VDD GND) DCAP32BWP12T30P140
    I1641_3 (VDD GND) DCAP32BWP12T30P140
    I1641_2 (VDD GND) DCAP32BWP12T30P140
    I1641_1 (VDD GND) DCAP32BWP12T30P140
    I1642 (VDD GND) DCAP64BWP12T30P140
    I130 (SCKI net371 VDD GND) DEL100D1BWP12T30P140
// @RNL(author="rnl-virtuoso") {
//   %block_symbol = @DEFINE-SYMBOL(box=[1, -16, 22, 2]) {
//     @LINE {(22, -5) (18, -5)};
//     @LINE {(22, -1) (18, -1)};
//     @LINE {(12, -16) (12, -12)};
//     @LINE {(1, -5) (10, -5)};
//     @LINE {(1, -5) (5, -5)};
//     @LINE {(22, -9) (18, -9)};
//     @LINE {(22, -3) (18, -3)};
//     @LINE {(22, -11) (18, -11)};
//     @LINE {(11, -1) (17, -1)};
//     @RECTANGLE {(10, -12) (18, 2)};
//     @LINE {(11, -3) (17, -3)};
//     @LINE {(11, -5) (17, -5)};
//     @LINE {(11, -7) (17, -7)};
//     @LINE {(11, -9) (17, -9)};
//     @LINE {(12, -10) (12, 0)};
//     @LINE {(14, -10) (14, 0)};
//     @LINE {(16, -10) (16, 0)};
//     @LINE {(16, -16) (16, -12)};
//     @LINE {(22, -7) (18, -7)};
//     @LINE {(22, 1) (18, 1)};
//     ? @TEXT("${name}", size=1, halign="start", valign="middle", key="name") => @PLACE(19, 3);
//     ? @TEXT("${model}", size=1, halign="middle", valign="middle", key="model") => @PLACE(14.5, 3);
//     (22, -5) @PIN(terminal="SDI");
//     (21.4, -4) @TEXT("SDI", size=1, halign="end", valign="middle");
//     (12, -16) @PIN(terminal=["FRAME_15", "FRAME_14", "FRAME_13", "FRAME_12", "FRAME_11", "FRAME_10", "FRAME_9", "FRAME_8", "FRAME_7", "FRAME_6", "FRAME_5", "FRAME_4", "FRAME_3", "FRAME_2", "FRAME_1", "FRAME_0"]);
//     (11.4, -13) @TEXT("FRAME<15:0>", size=1, halign="end", valign="middle");
//     (22, -7) @PIN(terminal="RST");
//     (21.4, -6) @TEXT("RST", size=1, halign="end", valign="middle");
//     (22, -9) @PIN(terminal="VDD");
//     (21.4, -8) @TEXT("VDD", size=1, halign="end", valign="middle");
//     (22, -3) @PIN(terminal="SDO");
//     (21.4, -2) @TEXT("SDO", size=1, halign="end", valign="middle");
//     (22, -11) @PIN(terminal="GND");
//     (21.4, -10) @TEXT("GND", size=1, halign="end", valign="middle");
//     (16, -16) @PIN(terminal=["REPET_17", "REPET_16", "REPET_15", "REPET_14", "REPET_13", "REPET_12", "REPET_11", "REPET_10", "REPET_9", "REPET_8", "REPET_7", "REPET_6", "REPET_5", "REPET_4", "REPET_3", "REPET_2", "REPET_1"]);
//     (16.6, -13) @TEXT("REPET<17:1>", size=1, halign="start", valign="middle");
//     (1, -5) @PIN(terminal=["OUT_23", "OUT_22", "OUT_21", "OUT_20", "OUT_19", "OUT_18", "OUT_17", "OUT_16", "OUT_15", "OUT_14", "OUT_13", "OUT_12", "OUT_11", "OUT_10", "OUT_9", "OUT_8", "OUT_7", "OUT_6", "OUT_5", "OUT_4", "OUT_3", "OUT_2", "OUT_1", "OUT_0"]);
//     (1.6, -4) @TEXT("OUT<23:0>", size=1, halign="start", valign="middle");
//     (22, 1) @PIN(terminal="SCKI");
//     (21.4, 2) @TEXT("SCKI", size=1, halign="end", valign="middle");
//     (22, -1) @PIN(terminal="SCKO");
//     (21.4, 0) @TEXT("SCKO", size=1, halign="end", valign="middle")
//   };
//   # @SET-SYMBOL %block_symbol;
//   #"I1323" @PLACE(266, -308) => @ORIENT("R0");
//   %symbol_0 = @DEFINE-SYMBOL(box=[-11, -4, -4, 2]) {
//     @LINE {(-8, 2) (-8, 0.3)};
//     @LINE {(-6, -1) (-4, -1)};
//     @LINE {(-8, -4) (-8, -2.4)};
//     @LINE {(-9, 1) (-9, -3)};
//     @LINE {(-9, 1) (-6, -1)};
//     @LINE {(-9, -3) (-6, -1)};
//     @LINE {(-11, -1) (-9, -1)};
//     ? @TEXT("${model}", size=0.4, halign="end", valign="baseline", key="model") => @PLACE(-4, -4);
//     ? @TEXT("${name}", size=0.4, halign="end", valign="top", key="name") => @PLACE(-4, 2);
//     (-8, 2) @PIN(terminal=3);
//     (-7.1, 2) @TEXT("VDD", size=0.4, halign="start", valign="middle");
//     (-8, -4) @PIN(terminal=4);
//     (-7.1, -4) @TEXT("VSS", size=0.4, halign="start", valign="middle");
//     (-4, -1) @PIN(terminal=2);
//     (-6.4, -1) @TEXT("Z", size=0.4, halign="end", valign="middle");
//     (-11, -1) @PIN(terminal=1);
//     (-8.8, -1) @TEXT("I", size=0.4, halign="start", valign="middle")
//   };
//   #"I767" @SET-SYMBOL %symbol_0;
//   #"I767" @PLACE(-63, 4) => @ORIENT("MY");
//   %symbol_1 = @DEFINE-SYMBOL(box=[-4, -10, 8, -4]) {
//     @LINE {(2, -4) (2, -5)};
//     @LINE {(2, -10) (2, -9)};
//     @LINE {(-4, -7) (-2, -7)};
//     @LINE {(6, -7) (8, -7)};
//     @RECTANGLE {(-2, -9) (6, -5)};
//     ? @TEXT("${model}", size=0.4, halign="end", valign="baseline", key="model") => @PLACE(8, -10);
//     ? @TEXT("${name}", size=0.4, halign="end", valign="top", key="name") => @PLACE(8, -4);
//     (2, -10) @PIN(terminal=4);
//     (2.9, -10) @TEXT("VSS", size=0.4, halign="start", valign="middle");
//     (2, -4) @PIN(terminal=3);
//     (2.9, -4) @TEXT("VDD", size=0.4, halign="start", valign="middle");
//     (8, -7) @PIN(terminal=2);
//     (7, -6.6) @TEXT("Z", size=0.4, halign="end", valign="middle");
//     (-4, -7) @PIN(terminal=1);
//     (-2.9, -6.6) @TEXT("I", size=0.4, halign="start", valign="middle")
//   };
//   #"I1479" @SET-SYMBOL %symbol_1;
//   #"I1479" @PLACE(-30, -234) => @ORIENT("MY");
//   #"I1329" @PLACE(72, -378) => @ORIENT("R0");
//   %symbol_2 = @DEFINE-SYMBOL(box=[-4, -10, 8, -4]) {
//     @LINE {(2, -4) (2, -5)};
//     @LINE {(2, -10) (2, -9)};
//     @LINE {(-4, -7) (-2, -7)};
//     @LINE {(6, -7) (8, -7)};
//     @RECTANGLE {(-2, -9) (6, -5)};
//     ? @TEXT("${model}", size=0.4, halign="end", valign="baseline", key="model") => @PLACE(8, -10);
//     ? @TEXT("${name}", size=0.4, halign="end", valign="top", key="name") => @PLACE(8, -4);
//     (2, -10) @PIN(terminal=4);
//     (2.9, -10) @TEXT("VSS", size=0.4, halign="start", valign="middle");
//     (2, -4) @PIN(terminal=3);
//     (2.9, -4) @TEXT("VDD", size=0.4, halign="start", valign="middle");
//     (8, -7) @PIN(terminal=2);
//     (7, -6.6) @TEXT("Z", size=0.4, halign="end", valign="middle");
//     (-4, -7) @PIN(terminal=1);
//     (-2.9, -6.6) @TEXT("I", size=0.4, halign="start", valign="middle")
//   };
//   #"I130" @SET-SYMBOL %symbol_2;
//   #"I130" @PLACE(468, -736) => @ORIENT("MY");
//   #"I1091" @PLACE(182, -553) => @ORIENT("R0");
//   #"I1388" @PLACE(182, -588) => @ORIENT("R0");
//   #"I1598" @PLACE(362, 42) => @ORIENT("R0");
//   #"I771" @PLACE(24, -28) => @ORIENT("R0");
//   #"I1320" @PLACE(182, -308) => @ORIENT("R0");
//   #"I1272" @PLACE(266, -98) => @ORIENT("R0");
//   %symbol_3 = @DEFINE-SYMBOL(box=[8, -3, 16, 5]) {
//     @LINE {(11, 5) (11, 3)};
//     @LINE {(14, 1) (16, 1)};
//     @LINE {(11, -3) (11, -1)};
//     @LINE {(10, 3) (10, -1)};
//     @LINE {(10, 3) (12, 3)};
//     @LINE {(10, -1) (12, -1)};
//     @ARC {(12, -1) (14, 1) (12, 3)};
//     @LINE {(8, 2) (10, 2)};
//     @LINE {(8, 0) (10, 0)};
//     ? @TEXT("${model}", size=0.4, halign="end", valign="baseline", key="model") => @PLACE(16, -3);
//     ? @TEXT("${name}", size=0.4, halign="end", valign="top", key="name") => @PLACE(16, 5);
//     (11, 5) @PIN(terminal=4);
//     (11.9, 5) @TEXT("VDD", size=0.4, halign="start", valign="middle");
//     (11, -3) @PIN(terminal=5);
//     (11.9, -3) @TEXT("VSS", size=0.4, halign="start", valign="middle");
//     (16, 1) @PIN(terminal=3);
//     (13.6, 1) @TEXT("Z", size=0.4, halign="end", valign="middle");
//     (8, 2) @PIN(terminal=1);
//     (10.4, 2) @TEXT("A1", size=0.4, halign="start", valign="middle");
//     (8, 0) @PIN(terminal=2);
//     (10.4, 0) @TEXT("A2", size=0.4, halign="start", valign="middle")
//   };
//   #"I1193" @SET-SYMBOL %symbol_3;
//   #"I1193" @PLACE(53, -764) => @ORIENT("R90");
//   %symbol_4 = @DEFINE-SYMBOL(box=[-0.1, -2.8, 3.8, 2.8]) {
//     @LINE {(2, 1.5) (4, 1.5) (4, 3)};
//     @LINE {(2, -1.5) (2, 1.5)};
//     @LINE {(3, -1) (4, -1.5) (3, -2)};
//     @LINE {(0, 0) (1.5, 0)};
//     @LINE {(1.5, 1.5) (1.5, -1.5)};
//     @LINE {(2, -1.5) (4, -1.5) (4, -3)};
//     ? @TEXT("${name}", size=0.8, halign="start", valign="baseline", key="name") => @PLACE(5, 3.5);
//     ? @TEXT("${model}", size=0.8, halign="end", valign="baseline", key="model") => @PLACE(3.2, 3.2);
//     (4, -1) @PIN(terminal=4);
//     (4, -3) @PIN(terminal=3);
//     (4, 3) @PIN(terminal=1);
//     (0, 0) @PIN(terminal=2)
//   };
//   #"M144" @SET-SYMBOL %symbol_4;
//   #"M144" @PLACE(104, -514) => @ORIENT("R270");
//   %symbol_5 = @DEFINE-SYMBOL(box=[-0.1, -2.8, 3.8, 2.8]) {
//     @LINE {(0, 0) (0.7, 0)};
//     @LINE {(1.5, 1.5) (1.5, -1.5)};
//     @LINE {(2, -1.5) (4, -1.5) (4, -3)};
//     @LINE {(2, 1.5) (4, 1.5) (4, 3)};
//     (1.1, 0) @CIRCLE(radius=0.4);
//     @LINE {(3.7, 2) (2.7, 1.5) (3.7, 1)};
//     @LINE {(2, -1.5) (2, 1.5)};
//     ? @TEXT("${name}", size=0.8, halign="start", valign="baseline", key="name") => @PLACE(4.9, 3.4);
//     ? @TEXT("${model}", size=0.8, halign="end", valign="baseline", key="model") => @PLACE(3.3, 3.2);
//     (4, 3) @PIN(terminal=3);
//     (4, 1) @PIN(terminal=4);
//     (0, 0) @PIN(terminal=2);
//     (4, -3) @PIN(terminal=1)
//   };
//   #"M55" @SET-SYMBOL %symbol_5;
//   #"M55" @PLACE(208, -388) => @ORIENT("R90");
//   #"I1520" @SET-SYMBOL %symbol_1;
//   #"I1520" @PLACE(-30, -549) => @ORIENT("MY");
//   #"I1067" @PLACE(290, -483) => @ORIENT("R0");
//   #"I1331" @PLACE(24, -378) => @ORIENT("R0");
//   #"I1621" @SET-SYMBOL %symbol_3;
//   #"I1621" @PLACE(40, -764) => @ORIENT("R90");
//   #"M167" @SET-SYMBOL %symbol_4;
//   #"M167" @PLACE(212, -199) => @ORIENT("R270");
//   #"M37" @SET-SYMBOL %symbol_5;
//   #"M37" @PLACE(100, -528) => @ORIENT("R90");
//   %symbol_6 = @DEFINE-SYMBOL(box=[-11, -4, -4, 2]) {
//     @LINE {(-8, 2) (-8, 0.3)};
//     @LINE {(-6, -1) (-4, -1)};
//     @LINE {(-8, -4) (-8, -2.4)};
//     @LINE {(-9, 1) (-9, -3)};
//     @LINE {(-9, 1) (-6, -1)};
//     @LINE {(-9, -3) (-6, -1)};
//     @LINE {(-11, -1) (-9, -1)};
//     ? @TEXT("${model}", size=0.4, halign="end", valign="baseline", key="model") => @PLACE(-4, -4);
//     ? @TEXT("${name}", size=0.4, halign="end", valign="top", key="name") => @PLACE(-4, 2);
//     (-8, 2) @PIN(terminal=3);
//     (-7.1, 2) @TEXT("VDD", size=0.4, halign="start", valign="middle");
//     (-8, -4) @PIN(terminal=4);
//     (-7.1, -4) @TEXT("VSS", size=0.4, halign="start", valign="middle");
//     (-4, -1) @PIN(terminal=2);
//     (-6.4, -1) @TEXT("Z", size=0.4, halign="end", valign="middle");
//     (-11, -1) @PIN(terminal=1);
//     (-8.8, -1) @TEXT("I", size=0.4, halign="start", valign="middle")
//   };
//   #"I1608" @SET-SYMBOL %symbol_6;
//   #"I1608" @PLACE(441, 87) => @ORIENT("R0");
//   #"I1426" @PLACE(290, -728) => @ORIENT("R0");
//   #"I1081" @PLACE(48, -553) => @ORIENT("R0");
//   #"M159" @SET-SYMBOL %symbol_4;
//   #"M159" @PLACE(212, -479) => @ORIENT("R270");
//   #"I1082" @PLACE(72, -553) => @ORIENT("R0");
//   %symbol_7 = @DEFINE-SYMBOL(box=[-8, -8, -1, -2]) {
//     @LINE {(-6, -3) (-6, -7)};
//     @LINE {(-8, -5) (-6, -5)};
//     @LINE {(-6, -3) (-3, -5)};
//     @LINE {(-6, -7) (-3, -5)};
//     @LINE {(-2, -5) (-1, -5)};
//     @LINE {(-5, -2) (-5, -3.7)};
//     @LINE {(-5, -8) (-5, -6.4)};
//     (-2.5, -5) @CIRCLE(radius=0.5);
//     ? @TEXT("${model}", size=0.4, halign="end", valign="baseline", key="model") => @PLACE(-1, -8);
//     ? @TEXT("${name}", size=0.4, halign="end", valign="top", key="name") => @PLACE(-1, -2);
//     (-5, -8) @PIN(terminal=4);
//     (-4.1, -8) @TEXT("VSS", size=0.4, halign="start", valign="middle");
//     (-5, -2) @PIN(terminal=3);
//     (-4.1, -2) @TEXT("VDD", size=0.4, halign="start", valign="middle");
//     (-1, -5) @PIN(terminal=2);
//     (-3.4, -5) @TEXT("ZN", size=0.4, halign="end", valign="middle");
//     (-8, -5) @PIN(terminal=1);
//     (-5.8, -5) @TEXT("I", size=0.4, halign="start", valign="middle")
//   };
//   #"I902" @SET-SYMBOL %symbol_7;
//   #"I902" @PLACE(409, -213) => @ORIENT("MY");
//   #"I1292" @PLACE(338, -168) => @ORIENT("R0");
//   #"M135" @SET-SYMBOL %symbol_4;
//   #"M135" @PLACE(104, -199) => @ORIENT("R270");
//   #"M48" @SET-SYMBOL %symbol_5;
//   #"M48" @PLACE(208, -598) => @ORIENT("R90");
//   #"I802" @PLACE(72, -63) => @ORIENT("R0");
//   %symbol_8 = @DEFINE-SYMBOL(box=[-0.1, -2.8, 3.8, 2.8]) {
//     @LINE {(0, 0) (0.7, 0)};
//     @LINE {(1.5, 1.5) (1.5, -1.5)};
//     @LINE {(2, -1.5) (4, -1.5) (4, -3)};
//     @LINE {(2, 1.5) (4, 1.5) (4, 3)};
//     (1.1, 0) @CIRCLE(radius=0.4);
//     @LINE {(3.7, 2) (2.7, 1.5) (3.7, 1)};
//     @LINE {(2, -1.5) (2, 1.5)};
//     ? @TEXT("${name}", size=0.8, halign="start", valign="baseline", key="name") => @PLACE(4.9, 3.4);
//     ? @TEXT("${model}", size=0.8, halign="end", valign="baseline", key="model") => @PLACE(3.3, 3.2);
//     (4, 3) @PIN(terminal=3);
//     (4, 1) @PIN(terminal=4);
//     (0, 0) @PIN(terminal=2);
//     (4, -3) @PIN(terminal=1)
//   };
//   #"M80" @SET-SYMBOL %symbol_8;
//   #"M80" @PLACE(-10, -477) => @ORIENT("R0");
//   #"I1221" @SET-SYMBOL %symbol_7;
//   #"I1221" @PLACE(99, -781) => @ORIENT("R90");
//   #"M150" @SET-SYMBOL %symbol_4;
//   #"M150" @PLACE(104, -724) => @ORIENT("R270");
//   #"I1634" @SET-SYMBOL %symbol_3;
//   #"I1634" @PLACE(402, -764) => @ORIENT("R90");
//   #"I1380" @PLACE(72, -588) => @ORIENT("R0");
//   %symbol_9 = @DEFINE-SYMBOL(box=[12, -1, 20, 9]) {
//     @LINE {(12, 2) (14, 2)};
//     @LINE {(14, 6) (12, 6)};
//     @LINE {(16, 9) (16, 8)};
//     @LINE {(16, 0) (16, -1)};
//     @LINE {(14, 8) (14, 0)};
//     @LINE {(14, 3) (15.4, 2) (14, 1)};
//     @LINE {(18, 8) (18, 0)};
//     @LINE {(14, 8) (18, 8)};
//     @LINE {(14, 0) (18, 0)};
//     @LINE {(20, 4) (18, 4)};
//     ? @TEXT("${model}", size=0.4, halign="end", valign="baseline", key="model") => @PLACE(20, -1);
//     ? @TEXT("${name}", size=0.4, halign="end", valign="top", key="name") => @PLACE(20, 9);
//     (16, -1) @PIN(terminal=5);
//     (14.4, -1) @TEXT("VSS", size=0.4, halign="start", valign="middle");
//     (16, 9) @PIN(terminal=4);
//     (14.4, 9) @TEXT("VDD", size=0.4, halign="start", valign="middle");
//     (20, 4) @PIN(terminal=3);
//     (17.9, 4) @TEXT("Q", size=0.4, halign="end", valign="middle");
//     (12, 6) @PIN(terminal=1);
//     (14.4, 6) @TEXT("D", size=0.4, halign="start", valign="middle");
//     (12, 2) @PIN(terminal=2);
//     (14.1, 2) @TEXT("CP", size=0.4, halign="start", valign="middle")
//   };
//   #"I1509" @SET-SYMBOL %symbol_9;
//   #"I1509" @PLACE(-32, -411) => @ORIENT("R0");
//   #"I1312" @PLACE(72, -308) => @ORIENT("R0");
//   #"I1570" @PLACE(158, 42) => @ORIENT("R0");
//   #"M131" @SET-SYMBOL %symbol_4;
//   #"M131" @PLACE(104, -59) => @ORIENT("R270");
//   #"I1394" @PLACE(338, -588) => @ORIENT("R0");
//   #"I1489" @SET-SYMBOL %symbol_0;
//   #"I1489" @PLACE(-63, -311) => @ORIENT("MY");
//   #"M23" @SET-SYMBOL %symbol_5;
//   #"M23" @PLACE(100, -38) => @ORIENT("R90");
//   #"I772" @PLACE(48, -28) => @ORIENT("R0");
//   #"I947" @PLACE(290, -273) => @ORIENT("R0");
//   #"I1122" @PLACE(72, -623) => @ORIENT("R0");
//   #"I1316" @PLACE(242, -308) => @ORIENT("R0");
//   #"I822" @SET-SYMBOL %symbol_7;
//   #"I822" @PLACE(409, -73) => @ORIENT("MY");
//   #"M149" @SET-SYMBOL %symbol_4;
//   #"M149" @PLACE(104, -689) => @ORIENT("R270");
//   #"I1366" @PLACE(0, -518) => @ORIENT("R0");
//   #"M0" @SET-SYMBOL %symbol_8;
//   #"M0" @PLACE(-10, 13) => @ORIENT("R0");
//   #"M86" @SET-SYMBOL %symbol_8;
//   #"M86" @PLACE(-10, -687) => @ORIENT("R0");
//   #"I1185" @PLACE(338, -693) => @ORIENT("R0");
//   #"M28" @SET-SYMBOL %symbol_5;
//   #"M28" @PLACE(100, -213) => @ORIENT("R90");
//   #"I1531" @SET-SYMBOL %symbol_0;
//   #"I1531" @PLACE(-63, -626) => @ORIENT("MY");
//   #"I1603" @PLACE(290, 77) => @ORIENT("R0");
//   #"I1556" @PLACE(72, 77) => @ORIENT("R0");
//   #"I1353" @PLACE(158, -448) => @ORIENT("R0");
//   #"I1274" @PLACE(314, -98) => @ORIENT("R0");
//   #"M154" @SET-SYMBOL %symbol_4;
//   #"M154" @PLACE(212, -619) => @ORIENT("R270");
//   #"M134" @SET-SYMBOL %symbol_4;
//   #"M134" @PLACE(104, -164) => @ORIENT("R270");
//   #"I1478" @SET-SYMBOL %symbol_9;
//   #"I1478" @PLACE(8, -236) => @ORIENT("MY");
//   #"I1174" @PLACE(110, -693) => @ORIENT("R0");
//   #"I1408" @PLACE(266, -658) => @ORIENT("R0");
//   #"I1063" @PLACE(386, -483) => @ORIENT("R0");
//   #"I1197" @SET-SYMBOL %symbol_3;
//   #"I1197" @PLACE(115, -764) => @ORIENT("R90");
//   #"I1145" @PLACE(338, -623) => @ORIENT("R0");
//   %symbol_10 = @DEFINE-SYMBOL(box=[8, -3, 17, 5]) {
//     (15.5, 1) @CIRCLE(radius=0.5);
//     @LINE {(12, 5) (12, 3)};
//     @LINE {(16, 1) (17, 1)};
//     @LINE {(12, -3) (12, -1)};
//     @LINE {(9, 3) (12, 3)};
//     @LINE {(9, -1) (12, -1)};
//     @ARC {(9, -1) (11, 1) (9, 3)};
//     @LINE {(8, 2) (10.7, 2)};
//     @LINE {(8, 0) (10.7, 0)};
//     @ARC {(14.9, 0.9) (13.8, 2.4) (12, 2.9)};
//     @ARC {(12, -1) (13.8, -0.5) (15, 1)};
//     ? @TEXT("${name}", size=0.4, halign="end", valign="top", key="name") => @PLACE(17, 5);
//     ? @TEXT("${model}", size=0.4, halign="end", valign="baseline", key="model") => @PLACE(17, -3);
//     (12, -3) @PIN(terminal=5);
//     (12.9, -3) @TEXT("VSS", size=0.4, halign="start", valign="middle");
//     (17, 1) @PIN(terminal=3);
//     (14.6, 1) @TEXT("ZN", size=0.4, halign="end", valign="middle");
//     (12, 5) @PIN(terminal=4);
//     (12.9, 5) @TEXT("VDD", size=0.4, halign="start", valign="middle");
//     (8, 2) @PIN(terminal=1);
//     (11.4, 2) @TEXT("A1", size=0.4, halign="start", valign="middle");
//     (8, 0) @PIN(terminal=2);
//     (11.4, 0) @TEXT("A2", size=0.4, halign="start", valign="middle")
//   };
//   #"I1500" @SET-SYMBOL %symbol_10;
//   #"I1500" @PLACE(-32, -348) => @ORIENT("MY");
//   #"I1023" @PLACE(386, -413) => @ORIENT("R0");
//   #"I1404" @PLACE(158, -658) => @ORIENT("R0");
//   #"I1277" @PLACE(386, -98) => @ORIENT("R0");
//   #"I1390" @SET-SYMBOL %symbol_7;
//   #"I1390" @PLACE(409, -598) => @ORIENT("MY");
//   #"M143" @SET-SYMBOL %symbol_4;
//   #"M143" @PLACE(104, -479) => @ORIENT("R270");
//   #"I1391" @PLACE(266, -588) => @ORIENT("R0");
//   #"I657" @PLACE(290, 7) => @ORIENT("R0");
//   #"I412" @SET-SYMBOL %symbol_1;
//   #"I412" @PLACE(-30, 11) => @ORIENT("MY");
//   #"I1328" @PLACE(386, -308) => @ORIENT("R0");
//   #"I1064" @PLACE(362, -483) => @ORIENT("R0");
//   #"I1335" @PLACE(134, -378) => @ORIENT("R0");
//   #"I1202" @SET-SYMBOL %symbol_3;
//   #"I1202" @PLACE(139, -764) => @ORIENT("R90");
//   #"I1536" @SET-SYMBOL %symbol_1;
//   #"I1536" @PLACE(-30, -689) => @ORIENT("MY");
//   #"I1470" @SET-SYMBOL %symbol_9;
//   #"I1470" @PLACE(8, -166) => @ORIENT("MY");
//   #"I1337" @PLACE(182, -378) => @ORIENT("R0");
//   #"I745" @PLACE(386, 7) => @ORIENT("R0");
//   #"I1276" @PLACE(362, -98) => @ORIENT("R0");
//   #"M152" @SET-SYMBOL %symbol_4;
//   #"M152" @PLACE(212, -689) => @ORIENT("R270");
//   #"I1287" @PLACE(218, -168) => @ORIENT("R0");
//   #"I1318" @PLACE(134, -308) => @ORIENT("R0");
//   #"I1496" @SET-SYMBOL %symbol_1;
//   #"I1496" @PLACE(-30, -339) => @ORIENT("MY");
//   #"I1205" @SET-SYMBOL %symbol_3;
//   #"I1205" @PLACE(271, -764) => @ORIENT("R90");
//   #"I1065" @PLACE(338, -483) => @ORIENT("R0");
//   #"I1409" @PLACE(290, -658) => @ORIENT("R0");
//   #"I1300" @PLACE(110, -238) => @ORIENT("R0");
//   #"I1105" @PLACE(338, -553) => @ORIENT("R0");
//   #"I905" @PLACE(338, -203) => @ORIENT("R0");
//   #"I960" @PLACE(24, -343) => @ORIENT("R0");
//   #"I1146" @PLACE(314, -623) => @ORIENT("R0");
//   #"I1425" @PLACE(266, -728) => @ORIENT("R0");
//   #"M88" @SET-SYMBOL %symbol_8;
//   #"M88" @PLACE(-10, 83) => @ORIENT("R0");
//   #"I1513" @SET-SYMBOL %symbol_0;
//   #"I1513" @PLACE(-63, -521) => @ORIENT("MY");
//   #"I1498" @SET-SYMBOL %symbol_10;
//   #"I1498" @PLACE(-32, -383) => @ORIENT("MY");
//   #"M153" @SET-SYMBOL %symbol_4;
//   #"M153" @PLACE(212, -654) => @ORIENT("R270");
//   #"I1490" @SET-SYMBOL %symbol_10;
//   #"I1490" @PLACE(-32, -313) => @ORIENT("MY");
//   #"I1350" @PLACE(242, -448) => @ORIENT("R0");
//   #"I1551" @SET-SYMBOL %symbol_10;
//   #"I1551" @PLACE(-32, 72) => @ORIENT("MY");
//   #"I889" @PLACE(242, -203) => @ORIENT("R0");
//   #"I894" @PLACE(110, -203) => @ORIENT("R0");
//   #"I788" @PLACE(266, -28) => @ORIENT("R0");
//   #"I1413" @PLACE(386, -658) => @ORIENT("R0");
//   #"I1289" @PLACE(266, -168) => @ORIENT("R0");
//   #"I1631" @SET-SYMBOL %symbol_3;
//   #"I1631" @PLACE(330, -764) => @ORIENT("R90");
//   #"I1518" @SET-SYMBOL %symbol_9;
//   #"I1518" @PLACE(8, -586) => @ORIENT("MY");
//   #"I1389" @PLACE(218, -588) => @ORIENT("R0");
//   #"I1372" @PLACE(218, -518) => @ORIENT("R0");
//   #"M45" @SET-SYMBOL %symbol_5;
//   #"M45" @PLACE(208, -703) => @ORIENT("R90");
//   #"I1549" @SET-SYMBOL %symbol_9;
//   #"I1549" @PLACE(8, 44) => @ORIENT("MY");
//   #"I1133" @PLACE(134, -623) => @ORIENT("R0");
//   #"I814" @PLACE(110, -63) => @ORIENT("R0");
//   #"I1406" @PLACE(218, -658) => @ORIENT("R0");
//   #"I986" @PLACE(314, -343) => @ORIENT("R0");
//   #"I1385" @PLACE(110, -588) => @ORIENT("R0");
//   #"I1285" @PLACE(158, -168) => @ORIENT("R0");
//   #"I1264" @PLACE(0, -98) => @ORIENT("R0");
//   #"I1626" @SET-SYMBOL %symbol_3;
//   #"I1626" @PLACE(198, -764) => @ORIENT("R90");
//   #"I1424" @SET-SYMBOL %symbol_7;
//   #"I1424" @PLACE(409, -738) => @ORIENT("MY");
//   #"I1607" @PLACE(386, 77) => @ORIENT("R0");
//   #"I1341" @PLACE(290, -378) => @ORIENT("R0");
//   #"I1338" @PLACE(218, -378) => @ORIENT("R0");
//   #"I780" @PLACE(134, -28) => @ORIENT("R0");
//   #"I1624" @SET-SYMBOL %symbol_3;
//   #"I1624" @PLACE(126, -764) => @ORIENT("R90");
//   #"I1485" @SET-SYMBOL %symbol_9;
//   #"I1485" @PLACE(-32, -201) => @ORIENT("R0");
//   #"I1011" @PLACE(182, -413) => @ORIENT("R0");
//   #"I823" @PLACE(386, -63) => @ORIENT("R0");
//   #"I971" @PLACE(182, -343) => @ORIENT("R0");
//   #"M30" @SET-SYMBOL %symbol_5;
//   #"M30" @PLACE(100, -283) => @ORIENT("R90");
//   #"I1374" @PLACE(266, -518) => @ORIENT("R0");
//   #"I906" @PLACE(314, -203) => @ORIENT("R0");
//   #"M63" @SET-SYMBOL %symbol_5;
//   #"M63" @PLACE(208, -108) => @ORIENT("R90");
//   #"I868" @PLACE(266, -133) => @ORIENT("R0");
//   #"I946" @PLACE(314, -273) => @ORIENT("R0");
//   #"I1131" @PLACE(182, -623) => @ORIENT("R0");
//   #"M59" @SET-SYMBOL %symbol_5;
//   #"M59" @PLACE(208, -248) => @ORIENT("R90");
//   #"M147" @SET-SYMBOL %symbol_4;
//   #"M147" @PLACE(104, -619) => @ORIENT("R270");
//   #"I812" @PLACE(158, -63) => @ORIENT("R0");
//   #"I1066" @PLACE(314, -483) => @ORIENT("R0");
//   #"I1090" @PLACE(218, -553) => @ORIENT("R0");
//   #"I1169" @PLACE(242, -693) => @ORIENT("R0");
//   #"M32" @SET-SYMBOL %symbol_5;
//   #"M32" @PLACE(100, -353) => @ORIENT("R90");
//   #"I1601" @PLACE(290, 42) => @ORIENT("R0");
//   #"I1371" @PLACE(182, -518) => @ORIENT("R0");
//   #"M27" @SET-SYMBOL %symbol_5;
//   #"M27" @PLACE(100, -178) => @ORIENT("R90");
//   #"I1494" @SET-SYMBOL %symbol_9;
//   #"I1494" @PLACE(8, -376) => @ORIENT("MY");
//   #"I1412" @PLACE(362, -658) => @ORIENT("R0");
//   #"I1398" @PLACE(48, -658) => @ORIENT("R0");
//   #"M133" @SET-SYMBOL %symbol_4;
//   #"M133" @PLACE(104, -129) => @ORIENT("R270");
//   #"I840" @PLACE(24, -133) => @ORIENT("R0");
//   %bundle_0 = {#"I1643_384" #"I1643_383" #"I1643_382" #"I1643_381" #"I1643_380" #"I1643_379" #"I1643_378" #"I1643_377" #"I1643_376" #"I1643_375" #"I1643_374" #"I1643_373" #"I1643_372" #"I1643_371" #"I1643_370" #"I1643_369" #"I1643_368" #"I1643_367" #"I1643_366" #"I1643_365" #"I1643_364" #"I1643_363" #"I1643_362" #"I1643_361" #"I1643_360" #"I1643_359" #"I1643_358" #"I1643_357" #"I1643_356" #"I1643_355" #"I1643_354" #"I1643_353" #"I1643_352" #"I1643_351" #"I1643_350" #"I1643_349" #"I1643_348" #"I1643_347" #"I1643_346" #"I1643_345" #"I1643_344" #"I1643_343" #"I1643_342" #"I1643_341" #"I1643_340" #"I1643_339" #"I1643_338" #"I1643_337" #"I1643_336" #"I1643_335" #"I1643_334" #"I1643_333" #"I1643_332" #"I1643_331" #"I1643_330" #"I1643_329" #"I1643_328" #"I1643_327" #"I1643_326" #"I1643_325" #"I1643_324" #"I1643_323" #"I1643_322" #"I1643_321" #"I1643_320" #"I1643_319" #"I1643_318" #"I1643_317" #"I1643_316" #"I1643_315" #"I1643_314" #"I1643_313" #"I1643_312" #"I1643_311" #"I1643_310" #"I1643_309" #"I1643_308" #"I1643_307" #"I1643_306" #"I1643_305" #"I1643_304" #"I1643_303" #"I1643_302" #"I1643_301" #"I1643_300" #"I1643_299" #"I1643_298" #"I1643_297" #"I1643_296" #"I1643_295" #"I1643_294" #"I1643_293" #"I1643_292" #"I1643_291" #"I1643_290" #"I1643_289" #"I1643_288" #"I1643_287" #"I1643_286" #"I1643_285" #"I1643_284" #"I1643_283" #"I1643_282" #"I1643_281" #"I1643_280" #"I1643_279" #"I1643_278" #"I1643_277" #"I1643_276" #"I1643_275" #"I1643_274" #"I1643_273" #"I1643_272" #"I1643_271" #"I1643_270" #"I1643_269" #"I1643_268" #"I1643_267" #"I1643_266" #"I1643_265" #"I1643_264" #"I1643_263" #"I1643_262" #"I1643_261" #"I1643_260" #"I1643_259" #"I1643_258" #"I1643_257" #"I1643_256" #"I1643_255" #"I1643_254" #"I1643_253" #"I1643_252" #"I1643_251" #"I1643_250" #"I1643_249" #"I1643_248" #"I1643_247" #"I1643_246" #"I1643_245" #"I1643_244" #"I1643_243" #"I1643_242" #"I1643_241" #"I1643_240" #"I1643_239" #"I1643_238" #"I1643_237" #"I1643_236" #"I1643_235" #"I1643_234" #"I1643_233" #"I1643_232" #"I1643_231" #"I1643_230" #"I1643_229" #"I1643_228" #"I1643_227" #"I1643_226" #"I1643_225" #"I1643_224" #"I1643_223" #"I1643_222" #"I1643_221" #"I1643_220" #"I1643_219" #"I1643_218" #"I1643_217" #"I1643_216" #"I1643_215" #"I1643_214" #"I1643_213" #"I1643_212" #"I1643_211" #"I1643_210" #"I1643_209" #"I1643_208" #"I1643_207" #"I1643_206" #"I1643_205" #"I1643_204" #"I1643_203" #"I1643_202" #"I1643_201" #"I1643_200" #"I1643_199" #"I1643_198" #"I1643_197" #"I1643_196" #"I1643_195" #"I1643_194" #"I1643_193" #"I1643_192" #"I1643_191" #"I1643_190" #"I1643_189" #"I1643_188" #"I1643_187" #"I1643_186" #"I1643_185" #"I1643_184" #"I1643_183" #"I1643_182" #"I1643_181" #"I1643_180" #"I1643_179" #"I1643_178" #"I1643_177" #"I1643_176" #"I1643_175" #"I1643_174" #"I1643_173" #"I1643_172" #"I1643_171" #"I1643_170" #"I1643_169" #"I1643_168" #"I1643_167" #"I1643_166" #"I1643_165" #"I1643_164" #"I1643_163" #"I1643_162" #"I1643_161" #"I1643_160" #"I1643_159" #"I1643_158" #"I1643_157" #"I1643_156" #"I1643_155" #"I1643_154" #"I1643_153" #"I1643_152" #"I1643_151" #"I1643_150" #"I1643_149" #"I1643_148" #"I1643_147" #"I1643_146" #"I1643_145" #"I1643_144" #"I1643_143" #"I1643_142" #"I1643_141" #"I1643_140" #"I1643_139" #"I1643_138" #"I1643_137" #"I1643_136" #"I1643_135" #"I1643_134" #"I1643_133" #"I1643_132" #"I1643_131" #"I1643_130" #"I1643_129" #"I1643_128" #"I1643_127" #"I1643_126" #"I1643_125" #"I1643_124" #"I1643_123" #"I1643_122" #"I1643_121" #"I1643_120" #"I1643_119" #"I1643_118" #"I1643_117" #"I1643_116" #"I1643_115" #"I1643_114" #"I1643_113" #"I1643_112" #"I1643_111" #"I1643_110" #"I1643_109" #"I1643_108" #"I1643_107" #"I1643_106" #"I1643_105" #"I1643_104" #"I1643_103" #"I1643_102" #"I1643_101" #"I1643_100" #"I1643_99" #"I1643_98" #"I1643_97" #"I1643_96" #"I1643_95" #"I1643_94" #"I1643_93" #"I1643_92" #"I1643_91" #"I1643_90" #"I1643_89" #"I1643_88" #"I1643_87" #"I1643_86" #"I1643_85" #"I1643_84" #"I1643_83" #"I1643_82" #"I1643_81" #"I1643_80" #"I1643_79" #"I1643_78" #"I1643_77" #"I1643_76" #"I1643_75" #"I1643_74" #"I1643_73" #"I1643_72" #"I1643_71" #"I1643_70" #"I1643_69" #"I1643_68" #"I1643_67" #"I1643_66" #"I1643_65" #"I1643_64" #"I1643_63" #"I1643_62" #"I1643_61" #"I1643_60" #"I1643_59" #"I1643_58" #"I1643_57" #"I1643_56" #"I1643_55" #"I1643_54" #"I1643_53" #"I1643_52" #"I1643_51" #"I1643_50" #"I1643_49" #"I1643_48" #"I1643_47" #"I1643_46" #"I1643_45" #"I1643_44" #"I1643_43" #"I1643_42" #"I1643_41" #"I1643_40" #"I1643_39" #"I1643_38" #"I1643_37" #"I1643_36" #"I1643_35" #"I1643_34" #"I1643_33" #"I1643_32" #"I1643_31" #"I1643_30" #"I1643_29" #"I1643_28" #"I1643_27" #"I1643_26" #"I1643_25" #"I1643_24" #"I1643_23" #"I1643_22" #"I1643_21" #"I1643_20" #"I1643_19" #"I1643_18" #"I1643_17" #"I1643_16" #"I1643_15" #"I1643_14" #"I1643_13" #"I1643_12" #"I1643_11" #"I1643_10" #"I1643_9" #"I1643_8" #"I1643_7" #"I1643_6" #"I1643_5" #"I1643_4" #"I1643_3" #"I1643_2" #"I1643_1"} @BUNDLE;
//   %symbol_11 = @DEFINE-SYMBOL(box=[1, 3, 3, 6]) {
//     @LINE {(2, 3) (2, 4)};
//     @LINE {(1, 5) (3, 5)};
//     @LINE {(2, 6) (2, 5)};
//     @LINE {(1, 4) (3, 4)};
//     ? @TEXT("${name}", size=0.4, halign="end", valign="top", key="name") => @PLACE(3, 6);
//     ? @TEXT("${model}", size=0.4, halign="end", valign="baseline", key="model") => @PLACE(3, 3);
//     (2, 6) @PIN(terminal=1);
//     (2.9, 6) @TEXT("VDD", size=0.4, halign="start", valign="middle");
//     (2, 3) @PIN(terminal=2);
//     (2.9, 3) @TEXT("VSS", size=0.4, halign="start", valign="middle")
//   };
//   %bundle_0 @SET-SYMBOL %symbol_11;
//   %bundle_0 @PLACE(-104, 23) => @ORIENT("R0");
//   %bundle_0 @TEXT("I1643<384:1>", key="name");
//   #"I942" @SET-SYMBOL %symbol_7;
//   #"I942" @PLACE(409, -283) => @ORIENT("MY");
//   #"I437" @PLACE(24, 7) => @ORIENT("R0");
//   #"I1345" @PLACE(386, -378) => @ORIENT("R0");
//   #"I933" @PLACE(134, -273) => @ORIENT("R0");
//   #"M1" @SET-SYMBOL %symbol_8;
//   #"M1" @PLACE(-14, -22) => @ORIENT("MY");
//   #"I1195" @SET-SYMBOL %symbol_3;
//   #"I1195" @PLACE(77, -764) => @ORIENT("R90");
//   #"I879" @PLACE(0, -203) => @ORIENT("R0");
//   #"I1275" @PLACE(338, -98) => @ORIENT("R0");
//   #"I1186" @PLACE(314, -693) => @ORIENT("R0");
//   #"I1629" @SET-SYMBOL %symbol_3;
//   #"I1629" @PLACE(282, -764) => @ORIENT("R90");
//   #"I1001" @PLACE(48, -413) => @ORIENT("R0");
//   #"I1340" @PLACE(266, -378) => @ORIENT("R0");
//   #"I1294" @PLACE(386, -168) => @ORIENT("R0");
//   #"I1120" @PLACE(24, -623) => @ORIENT("R0");
//   #"I1290" @PLACE(290, -168) => @ORIENT("R0");
//   #"I1599" @PLACE(338, 42) => @ORIENT("R0");
//   #"I1104" @PLACE(362, -553) => @ORIENT("R0");
//   #"I1369" @PLACE(134, -518) => @ORIENT("R0");
//   #"M176" @SET-SYMBOL %symbol_4;
//   #"M176" @PLACE(104, 81) => @ORIENT("R270");
//   #"I1480" @SET-SYMBOL %symbol_1;
//   #"I1480" @PLACE(-30, -199) => @ORIENT("MY");
//   #"I1333" @PLACE(242, -378) => @ORIENT("R0");
//   #"I1218" @SET-SYMBOL %symbol_3;
//   #"I1218" @PLACE(343, -764) => @ORIENT("R90");
//   #"I1224" @SET-SYMBOL %symbol_7;
//   #"I1224" @PLACE(432, -738) => @ORIENT("MY");
//   #"I1376" @PLACE(314, -518) => @ORIENT("R0");
//   #"M73" @SET-SYMBOL %symbol_8;
//   #"M73" @PLACE(-14, -302) => @ORIENT("MY");
//   #"I1355" @PLACE(218, -448) => @ORIENT("R0");
//   #"I1159" @PLACE(0, -693) => @ORIENT("R0");
//   #"M75" @SET-SYMBOL %symbol_8;
//   #"M75" @PLACE(-14, -372) => @ORIENT("MY");
//   #"I982" @SET-SYMBOL %symbol_7;
//   #"I982" @PLACE(409, -353) => @ORIENT("MY");
//   #"M148" @SET-SYMBOL %symbol_4;
//   #"M148" @PLACE(104, -654) => @ORIENT("R270");
//   #"M33" @SET-SYMBOL %symbol_5;
//   #"M33" @PLACE(100, -388) => @ORIENT("R90");
//   #"I1527" @SET-SYMBOL %symbol_1;
//   #"I1527" @PLACE(-30, -654) => @ORIENT("MY");
//   #"I1298" @PLACE(0, -238) => @ORIENT("R0");
//   #"I1410" @PLACE(314, -658) => @ORIENT("R0");
//   #"I1304" @PLACE(218, -238) => @ORIENT("R0");
//   #"M62" @SET-SYMBOL %symbol_5;
//   #"M62" @PLACE(208, -143) => @ORIENT("R90");
//   #"I1514" @SET-SYMBOL %symbol_10;
//   #"I1514" @PLACE(-32, -523) => @ORIENT("MY");
//   #"I1395" @PLACE(362, -588) => @ORIENT("R0");
//   #"I1010" @PLACE(218, -413) => @ORIENT("R0");
//   #"I1400" @PLACE(0, -658) => @ORIENT("R0");
//   #"I1121" @PLACE(48, -623) => @ORIENT("R0");
//   #"I1184" @PLACE(362, -693) => @ORIENT("R0");
//   #"M146" @SET-SYMBOL %symbol_4;
//   #"M146" @PLACE(104, -584) => @ORIENT("R270");
//   #"M61" @SET-SYMBOL %symbol_5;
//   #"M61" @PLACE(208, -178) => @ORIENT("R90");
//   #"I1387" @PLACE(158, -588) => @ORIENT("R0");
//   #"I1427" @PLACE(314, -728) => @ORIENT("R0");
//   #"I1569" @PLACE(182, 42) => @ORIENT("R0");
//   #"M139" @SET-SYMBOL %symbol_4;
//   #"M139" @PLACE(104, -339) => @ORIENT("R270");
//   #"M172" @SET-SYMBOL %symbol_4;
//   #"M172" @PLACE(212, -24) => @ORIENT("R270");
//   #"I1535" @SET-SYMBOL %symbol_1;
//   #"I1535" @PLACE(-30, -724) => @ORIENT("MY");
//   #"I1482" @SET-SYMBOL %symbol_10;
//   #"I1482" @PLACE(-32, -243) => @ORIENT("MY");
//   #"I1352" @PLACE(134, -448) => @ORIENT("R0");
//   #"I1262" @PLACE(48, -98) => @ORIENT("R0");
//   #"M136" @SET-SYMBOL %symbol_4;
//   #"M136" @PLACE(104, -234) => @ORIENT("R270");
//   #"I1625" @SET-SYMBOL %symbol_3;
//   #"I1625" @PLACE(150, -764) => @ORIENT("R90");
//   #"M173" @SET-SYMBOL %symbol_4;
//   #"M173" @PLACE(212, 46) => @ORIENT("R270");
//   #"I1542" @SET-SYMBOL %symbol_0;
//   #"I1542" @PLACE(-63, 39) => @ORIENT("MY");
//   #"I1512" @SET-SYMBOL %symbol_1;
//   #"I1512" @PLACE(-30, -479) => @ORIENT("MY");
//   #"I1597" @PLACE(386, 42) => @ORIENT("R0");
//   #"M60" @SET-SYMBOL %symbol_5;
//   #"M60" @PLACE(208, -213) => @ORIENT("R90");
//   #"I1486" @SET-SYMBOL %symbol_9;
//   #"I1486" @PLACE(8, -306) => @ORIENT("MY");
//   #"I1273" @PLACE(290, -98) => @ORIENT("R0");
//   #"I773" @PLACE(72, -28) => @ORIENT("R0");
//   #"I881" @PLACE(48, -203) => @ORIENT("R0");
//   #"I1596" @SET-SYMBOL %symbol_7;
//   #"I1596" @PLACE(409, 32) => @ORIENT("MY");
//   #"I1210" @SET-SYMBOL %symbol_3;
//   #"I1210" @PLACE(295, -764) => @ORIENT("R90");
//   #"M36" @SET-SYMBOL %symbol_5;
//   #"M36" @PLACE(100, -493) => @ORIENT("R90");
//   #"I411" @SET-SYMBOL %symbol_10;
//   #"I411" @PLACE(-32, 2) => @ORIENT("MY");
//   #"I1284" @PLACE(134, -168) => @ORIENT("R0");
//   #"I1368" @PLACE(110, -518) => @ORIENT("R0");
//   #"I999" @PLACE(0, -413) => @ORIENT("R0");
//   #"M164" @SET-SYMBOL %symbol_4;
//   #"M164" @PLACE(212, -304) => @ORIENT("R270");
//   #"I1526" @SET-SYMBOL %symbol_9;
//   #"I1526" @PLACE(8, -656) => @ORIENT("MY");
//   #"I1014" @PLACE(110, -413) => @ORIENT("R0");
//   #"I459" @PLACE(48, 7) => @ORIENT("R0");
//   #"I983" @PLACE(386, -343) => @ORIENT("R0");
//   #"I1566" @PLACE(266, 42) => @ORIENT("R0");
//   #"I1547" @PLACE(48, 42) => @ORIENT("R0");
//   #"I984" @PLACE(362, -343) => @ORIENT("R0");
//   #"M41" @SET-SYMBOL %symbol_5;
//   #"M41" @PLACE(100, -668) => @ORIENT("R90");
//   #"I1473" @SET-SYMBOL %symbol_0;
//   #"I1473" @PLACE(-63, -171) => @ORIENT("MY");
//   #"I1472" @SET-SYMBOL %symbol_1;
//   #"I1472" @PLACE(-30, -129) => @ORIENT("MY");
//   #"I1401" @PLACE(242, -658) => @ORIENT("R0");
//   #"I1417" @PLACE(0, -728) => @ORIENT("R0");
//   #"I774" @SET-SYMBOL %symbol_0;
//   #"I774" @PLACE(-63, -31) => @ORIENT("MY");
//   #"I824" @PLACE(362, -63) => @ORIENT("R0");
//   #"I1269" @PLACE(182, -98) => @ORIENT("R0");
//   #"I1271" @SET-SYMBOL %symbol_7;
//   #"I1271" @PLACE(409, -108) => @ORIENT("MY");
//   #"I1314" @PLACE(24, -308) => @ORIENT("R0");
//   #"I1288" @SET-SYMBOL %symbol_7;
//   #"I1288" @PLACE(409, -178) => @ORIENT("MY");
//   #"I1550" @SET-SYMBOL %symbol_0;
//   #"I1550" @PLACE(-63, 74) => @ORIENT("MY");
//   %bundle_1 = {#"I1640_4" #"I1640_3" #"I1640_2" #"I1640_1"} @BUNDLE;
//   %symbol_12 = @DEFINE-SYMBOL(box=[1, 3, 3, 6]) {
//     @LINE {(2, 3) (2, 4)};
//     @LINE {(1, 5) (3, 5)};
//     @LINE {(2, 6) (2, 5)};
//     @LINE {(1, 4) (3, 4)};
//     ? @TEXT("${name}", size=0.4, halign="end", valign="top", key="name") => @PLACE(3, 6);
//     ? @TEXT("${model}", size=0.4, halign="end", valign="baseline", key="model") => @PLACE(3, 3);
//     (2, 6) @PIN(terminal=1);
//     (2.9, 6) @TEXT("VDD", size=0.4, halign="start", valign="middle");
//     (2, 3) @PIN(terminal=2);
//     (2.9, 3) @TEXT("VSS", size=0.4, halign="start", valign="middle")
//   };
//   %bundle_1 @SET-SYMBOL %symbol_12;
//   %bundle_1 @PLACE(-96, 31) => @ORIENT("R0");
//   %bundle_1 @TEXT("I1640<4:1>", key="name");
//   #"I1484" @SET-SYMBOL %symbol_10;
//   #"I1484" @PLACE(-32, -208) => @ORIENT("MY");
//   #"I1477" @SET-SYMBOL %symbol_9;
//   #"I1477" @PLACE(-32, -131) => @ORIENT("R0");
//   #"I1572" @PLACE(110, 42) => @ORIENT("R0");
//   #"I810" @PLACE(218, -63) => @ORIENT("R0");
//   #"I1382" @PLACE(24, -588) => @ORIENT("R0");
//   #"I679" @PLACE(314, 7) => @ORIENT("R0");
//   #"I1025" @PLACE(338, -413) => @ORIENT("R0");
//   #"I1220" @SET-SYMBOL %symbol_3;
//   #"I1220" @PLACE(367, -764) => @ORIENT("R90");
//   #"M84" @SET-SYMBOL %symbol_8;
//   #"M84" @PLACE(-10, -617) => @ORIENT("R0");
//   #"M82" @SET-SYMBOL %symbol_8;
//   #"M82" @PLACE(-10, -547) => @ORIENT("R0");
//   #"I108" @SET-SYMBOL %symbol_6;
//   #"I108" @PLACE(443, -742) => @ORIENT("MY");
//   #"M145" @SET-SYMBOL %symbol_4;
//   #"M145" @PLACE(104, -549) => @ORIENT("R270");
//   %bundle_2 = {#"I1639_39" #"I1639_38" #"I1639_37" #"I1639_36" #"I1639_35" #"I1639_34" #"I1639_33" #"I1639_32" #"I1639_31" #"I1639_30" #"I1639_29" #"I1639_28" #"I1639_27" #"I1639_26" #"I1639_25" #"I1639_24" #"I1639_23" #"I1639_22" #"I1639_21" #"I1639_20" #"I1639_19" #"I1639_18" #"I1639_17" #"I1639_16" #"I1639_15" #"I1639_14" #"I1639_13" #"I1639_12" #"I1639_11" #"I1639_10" #"I1639_9" #"I1639_8" #"I1639_7" #"I1639_6" #"I1639_5" #"I1639_4" #"I1639_3" #"I1639_2" #"I1639_1"} @BUNDLE;
//   %symbol_13 = @DEFINE-SYMBOL(box=[1, 3, 3, 6]) {
//     @LINE {(2, 3) (2, 4)};
//     @LINE {(1, 5) (3, 5)};
//     @LINE {(2, 6) (2, 5)};
//     @LINE {(1, 4) (3, 4)};
//     ? @TEXT("${name}", size=0.4, halign="end", valign="top", key="name") => @PLACE(3, 6);
//     ? @TEXT("${model}", size=0.4, halign="end", valign="baseline", key="model") => @PLACE(3, 3);
//     (2, 6) @PIN(terminal=1);
//     (2.9, 6) @TEXT("VDD", size=0.4, halign="start", valign="middle");
//     (2, 3) @PIN(terminal=2);
//     (2.9, 3) @TEXT("VSS", size=0.4, halign="start", valign="middle")
//   };
//   %bundle_2 @SET-SYMBOL %symbol_13;
//   %bundle_2 @PLACE(-100, 31) => @ORIENT("R0");
//   %bundle_2 @TEXT("I1639<39:1>", key="name");
//   #"I1460" @SET-SYMBOL %symbol_9;
//   #"I1460" @PLACE(-32, 9) => @ORIENT("R0");
//   #"I1548" @PLACE(72, 42) => @ORIENT("R0");
//   #"I1357" @PLACE(266, -448) => @ORIENT("R0");
//   #"I1362" @PLACE(386, -448) => @ORIENT("R0");
//   #"I1052" @PLACE(158, -483) => @ORIENT("R0");
//   #"I1511" @SET-SYMBOL %symbol_1;
//   #"I1511" @PLACE(-30, -514) => @ORIENT("MY");
//   #"M78" @SET-SYMBOL %symbol_8;
//   #"M78" @PLACE(-10, -407) => @ORIENT("R0");
//   #"M165" @SET-SYMBOL %symbol_4;
//   #"M165" @PLACE(212, -269) => @ORIENT("R270");
//   #"M42" @SET-SYMBOL %symbol_5;
//   #"M42" @PLACE(100, -703) => @ORIENT("R90");
//   #"I1523" @SET-SYMBOL %symbol_0;
//   #"I1523" @PLACE(-63, -556) => @ORIENT("MY");
//   #"I1187" @PLACE(290, -693) => @ORIENT("R0");
//   #"I1173" @PLACE(134, -693) => @ORIENT("R0");
//   #"I826" @PLACE(314, -63) => @ORIENT("R0");
//   #"I635" @PLACE(266, 7) => @ORIENT("R0");
//   #"I1375" @PLACE(290, -518) => @ORIENT("R0");
//   #"I1622" @SET-SYMBOL %symbol_3;
//   #"I1622" @PLACE(64, -764) => @ORIENT("R90");
//   #"I1461" @SET-SYMBOL %symbol_9;
//   #"I1461" @PLACE(8, -26) => @ORIENT("MY");
//   #"I1303" @PLACE(182, -238) => @ORIENT("R0");
//   #"M138" @SET-SYMBOL %symbol_4;
//   #"M138" @PLACE(104, -304) => @ORIENT("R270");
//   #"I863" @PLACE(386, -133) => @ORIENT("R0");
//   #"I930" @PLACE(218, -273) => @ORIENT("R0");
//   #"I1342" @PLACE(314, -378) => @ORIENT("R0");
//   #"I1397" @PLACE(72, -658) => @ORIENT("R0");
//   #"I1199" @SET-SYMBOL %symbol_3;
//   #"I1199" @PLACE(187, -764) => @ORIENT("R90");
//   #"I1325" @PLACE(314, -308) => @ORIENT("R0");
//   #"I1268" @PLACE(158, -98) => @ORIENT("R0");
//   #"I1407" @SET-SYMBOL %symbol_7;
//   #"I1407" @PLACE(409, -668) => @ORIENT("MY");
//   #"M57" @SET-SYMBOL %symbol_5;
//   #"M57" @PLACE(208, -318) => @ORIENT("R90");
//   #"I1515" @SET-SYMBOL %symbol_0;
//   #"I1515" @PLACE(-63, -486) => @ORIENT("MY");
//   #"I1419" @PLACE(110, -728) => @ORIENT("R0");
//   #"I1339" @SET-SYMBOL %symbol_7;
//   #"I1339" @PLACE(409, -388) => @ORIENT("MY");
//   #"I1343" @PLACE(338, -378) => @ORIENT("R0");
//   #"M155" @SET-SYMBOL %symbol_4;
//   #"M155" @PLACE(212, -374) => @ORIENT("R270");
//   #"I839" @PLACE(0, -133) => @ORIENT("R0");
//   #"I1336" @PLACE(158, -378) => @ORIENT("R0");
//   #"I1054" @PLACE(110, -483) => @ORIENT("R0");
//   #"I1330" @PLACE(48, -378) => @ORIENT("R0");
//   #"I1455" @SET-SYMBOL %symbol_7;
//   #"I1455" @PLACE(207, -770) => @ORIENT("R90");
//   #"I1042" @PLACE(72, -483) => @ORIENT("R0");
//   #"I1279" @PLACE(48, -168) => @ORIENT("R0");
//   #"I1454" @SET-SYMBOL %symbol_7;
//   #"I1454" @PLACE(99, -770) => @ORIENT("R90");
//   #"I1505" @SET-SYMBOL %symbol_0;
//   #"I1505" @PLACE(-63, -451) => @ORIENT("MY");
//   #"I1379" @PLACE(386, -518) => @ORIENT("R0");
//   #"I841" @PLACE(48, -133) => @ORIENT("R0");
//   #"M67" @SET-SYMBOL %symbol_8;
//   #"M67" @PLACE(-14, -92) => @ORIENT("MY");
//   #"M157" @SET-SYMBOL %symbol_4;
//   #"M157" @PLACE(212, -549) => @ORIENT("R270");
//   #"M49" @SET-SYMBOL %symbol_5;
//   #"M49" @PLACE(208, -738) => @ORIENT("R90");
//   #"I1049" @PLACE(242, -483) => @ORIENT("R0");
//   #"M85" @SET-SYMBOL %symbol_8;
//   #"M85" @PLACE(-14, -722) => @ORIENT("MY");
//   #"I1420" @PLACE(134, -728) => @ORIENT("R0");
//   #"I1555" @PLACE(48, 77) => @ORIENT("R0");
//   #"I1282" @PLACE(242, -168) => @ORIENT("R0");
//   #"I1295" @PLACE(72, -238) => @ORIENT("R0");
//   #"I959" @PLACE(0, -343) => @ORIENT("R0");
//   #"I701" @PLACE(338, 7) => @ORIENT("R0");
//   #"I1162" @PLACE(72, -693) => @ORIENT("R0");
//   #"I1026" @PLACE(314, -413) => @ORIENT("R0");
//   #"I1578" @PLACE(182, 77) => @ORIENT("R0");
//   #"I786" @PLACE(314, -28) => @ORIENT("R0");
//   #"M141" @SET-SYMBOL %symbol_4;
//   #"M141" @PLACE(104, -409) => @ORIENT("R270");
//   #"I1396" @PLACE(386, -588) => @ORIENT("R0");
//   #"I1027" @PLACE(290, -413) => @ORIENT("R0");
//   #"I825" @PLACE(338, -63) => @ORIENT("R0");
//   #"I1297" @PLACE(24, -238) => @ORIENT("R0");
//   #"I777" @PLACE(218, -28) => @ORIENT("R0");
//   #"I1392" @PLACE(290, -588) => @ORIENT("R0");
//   #"M65" @SET-SYMBOL %symbol_5;
//   #"M65" @PLACE(208, -38) => @ORIENT("R90");
//   #"I801" @PLACE(48, -63) => @ORIENT("R0");
//   #"I1170" @PLACE(218, -693) => @ORIENT("R0");
//   #"M166" @SET-SYMBOL %symbol_4;
//   #"M166" @PLACE(212, -234) => @ORIENT("R270");
//   #"M64" @SET-SYMBOL %symbol_5;
//   #"M64" @PLACE(208, -73) => @ORIENT("R90");
//   #"I1491" @SET-SYMBOL %symbol_0;
//   #"I1491" @PLACE(-63, -276) => @ORIENT("MY");
//   #"I770" @PLACE(0, -28) => @ORIENT("R0");
//   #"M76" @SET-SYMBOL %symbol_8;
//   #"M76" @PLACE(-10, -337) => @ORIENT("R0");
//   #"I1557" @SET-SYMBOL %symbol_9;
//   #"I1557" @PLACE(-32, 79) => @ORIENT("R0");
//   #"I1291" @PLACE(314, -168) => @ORIENT("R0");
//   #"I1260" @SET-SYMBOL %symbol_9;
//   #"I1260" @PLACE(453, -723) => @ORIENT("MY");
//   #"I864" @PLACE(362, -133) => @ORIENT("R0");
//   #"I1130" @PLACE(218, -623) => @ORIENT("R0");
//   #"I1508" @SET-SYMBOL %symbol_10;
//   #"I1508" @PLACE(-32, -418) => @ORIENT("MY");
//   #"I1568" @PLACE(218, 42) => @ORIENT("R0");
//   #"I1627" @SET-SYMBOL %symbol_3;
//   #"I1627" @PLACE(234, -764) => @ORIENT("R90");
//   #"I1539" @SET-SYMBOL %symbol_0;
//   #"I1539" @PLACE(-63, -696) => @ORIENT("MY");
//   #"I1517" @SET-SYMBOL %symbol_9;
//   #"I1517" @PLACE(-32, -481) => @ORIENT("R0");
//   #"I1399" @PLACE(24, -658) => @ORIENT("R0");
//   #"I1497" @SET-SYMBOL %symbol_0;
//   #"I1497" @PLACE(-63, -381) => @ORIENT("MY");
//   #"I1306" @PLACE(266, -238) => @ORIENT("R0");
//   #"I1573" @PLACE(266, 77) => @ORIENT("R0");
//   #"M92" @SET-SYMBOL %symbol_5;
//   #"M92" @PLACE(208, 67) => @ORIENT("R90");
//   #"I1281" @PLACE(0, -168) => @ORIENT("R0");
//   #"I1207" @SET-SYMBOL %symbol_3;
//   #"I1207" @PLACE(247, -764) => @ORIENT("R90");
//   #"I1467" @SET-SYMBOL %symbol_0;
//   #"I1467" @PLACE(-63, -66) => @ORIENT("MY");
//   #"I922" @PLACE(72, -273) => @ORIENT("R0");
//   #"M43" @SET-SYMBOL %symbol_5;
//   #"M43" @PLACE(100, -738) => @ORIENT("R90");
//   #"I1487" @SET-SYMBOL %symbol_1;
//   #"I1487" @PLACE(-30, -304) => @ORIENT("MY");
//   %symbol_14 = @DEFINE-SYMBOL(box=[-8, -8, -1, -2]) {
//     @LINE {(-6, -3) (-6, -7)};
//     @LINE {(-8, -5) (-6, -5)};
//     @LINE {(-6, -3) (-3, -5)};
//     @LINE {(-6, -7) (-3, -5)};
//     @LINE {(-2, -5) (-1, -5)};
//     @LINE {(-5, -2) (-5, -3.7)};
//     @LINE {(-5, -8) (-5, -6.4)};
//     (-2.5, -5) @CIRCLE(radius=0.5);
//     ? @TEXT("${model}", size=0.4, halign="end", valign="baseline", key="model") => @PLACE(-1, -8);
//     ? @TEXT("${name}", size=0.4, halign="end", valign="top", key="name") => @PLACE(-1, -2);
//     (-5, -8) @PIN(terminal=4);
//     (-4.1, -8) @TEXT("VSS", size=0.4, halign="start", valign="middle");
//     (-5, -2) @PIN(terminal=3);
//     (-4.1, -2) @TEXT("VDD", size=0.4, halign="start", valign="middle");
//     (-1, -5) @PIN(terminal=2);
//     (-3.4, -5) @TEXT("ZN", size=0.4, halign="end", valign="middle");
//     (-8, -5) @PIN(terminal=1);
//     (-5.8, -5) @TEXT("I", size=0.4, halign="start", valign="middle")
//   };
//   #"I1431" @SET-SYMBOL %symbol_14;
//   #"I1431" @PLACE(434, -727) => @ORIENT("R0");
//   #"I1576" @PLACE(134, 77) => @ORIENT("R0");
//   #"I1493" @SET-SYMBOL %symbol_9;
//   #"I1493" @PLACE(-32, -271) => @ORIENT("R0");
//   #"I1553" @PLACE(0, 77) => @ORIENT("R0");
//   #"I1040" @PLACE(24, -483) => @ORIENT("R0");
//   #"I1313" @PLACE(48, -308) => @ORIENT("R0");
//   #"M66" @SET-SYMBOL %symbol_5;
//   #"M66" @PLACE(208, -3) => @ORIENT("R90");
//   #"I783" @PLACE(386, -28) => @ORIENT("R0");
//   #"I1319" @PLACE(158, -308) => @ORIENT("R0");
//   #"I944" @PLACE(362, -273) => @ORIENT("R0");
//   #"I1411" @PLACE(338, -658) => @ORIENT("R0");
//   #"I1119" @PLACE(0, -623) => @ORIENT("R0");
//   #"M25" @SET-SYMBOL %symbol_5;
//   #"M25" @PLACE(100, -108) => @ORIENT("R90");
//   #"I1544" @SET-SYMBOL %symbol_1;
//   #"I1544" @PLACE(-30, 46) => @ORIENT("MY");
//   #"I1428" @PLACE(338, -728) => @ORIENT("R0");
//   #"I525" @PLACE(134, 7) => @ORIENT("R0");
//   #"I828" @PLACE(266, -63) => @ORIENT("R0");
//   #"I1421" @PLACE(158, -728) => @ORIENT("R0");
//   #"M74" @SET-SYMBOL %symbol_8;
//   #"M74" @PLACE(-10, -267) => @ORIENT("R0");
//   #"I785" @PLACE(338, -28) => @ORIENT("R0");
//   #"I1002" @PLACE(72, -413) => @ORIENT("R0");
//   #"I1182" @SET-SYMBOL %symbol_7;
//   #"I1182" @PLACE(409, -703) => @ORIENT("MY");
//   #"I852" @PLACE(158, -133) => @ORIENT("R0");
//   #"I109" @SET-SYMBOL %symbol_6;
//   #"I109" @PLACE(460, -758) => @ORIENT("R0");
//   #"I569" @PLACE(182, 7) => @ORIENT("R0");
//   #"I890" @PLACE(218, -203) => @ORIENT("R0");
//   #"M156" @SET-SYMBOL %symbol_4;
//   #"M156" @PLACE(212, -584) => @ORIENT("R270");
//   #"M163" @SET-SYMBOL %symbol_4;
//   #"M163" @PLACE(212, -339) => @ORIENT("R270");
//   #"I1537" @SET-SYMBOL %symbol_0;
//   #"I1537" @PLACE(-63, -731) => @ORIENT("MY");
//   #"I1466" @SET-SYMBOL %symbol_10;
//   #"I1466" @PLACE(-32, -103) => @ORIENT("MY");
//   #"I1506" @SET-SYMBOL %symbol_10;
//   #"I1506" @PLACE(-32, -453) => @ORIENT("MY");
//   #"I961" @PLACE(48, -343) => @ORIENT("R0");
//   #"I853" @PLACE(134, -133) => @ORIENT("R0");
//   #"I613" @PLACE(242, 7) => @ORIENT("R0");
//   #"I776" @PLACE(242, -28) => @ORIENT("R0");
//   #"I1106" @PLACE(314, -553) => @ORIENT("R0");
//   #"I931" @PLACE(182, -273) => @ORIENT("R0");
//   #"I1305" @SET-SYMBOL %symbol_7;
//   #"I1305" @PLACE(409, -248) => @ORIENT("MY");
//   #"I1481" @SET-SYMBOL %symbol_0;
//   #"I1481" @PLACE(-63, -241) => @ORIENT("MY");
//   #"I1009" @PLACE(242, -413) => @ORIENT("R0");
//   #"I1102" @SET-SYMBOL %symbol_7;
//   #"I1102" @PLACE(409, -563) => @ORIENT("MY");
//   #"I969" @PLACE(242, -343) => @ORIENT("R0");
//   #"I1393" @PLACE(314, -588) => @ORIENT("R0");
//   #"I1360" @PLACE(338, -448) => @ORIENT("R0");
//   #"M34" @SET-SYMBOL %symbol_5;
//   #"M34" @PLACE(100, -423) => @ORIENT("R90");
//   #"I1377" @PLACE(338, -518) => @ORIENT("R0");
//   #"I1575" @PLACE(110, 77) => @ORIENT("R0");
//   #"I851" @PLACE(182, -133) => @ORIENT("R0");
//   #"I1541" @SET-SYMBOL %symbol_9;
//   #"I1541" @PLACE(-32, -691) => @ORIENT("R0");
//   #"I1423" @PLACE(218, -728) => @ORIENT("R0");
//   #"I1266" @PLACE(110, -98) => @ORIENT("R0");
//   #"I1522" @SET-SYMBOL %symbol_10;
//   #"I1522" @PLACE(-32, -593) => @ORIENT("MY");
//   #"I970" @PLACE(218, -343) => @ORIENT("R0");
//   #"I1344" @PLACE(362, -378) => @ORIENT("R0");
//   #"I1334" @PLACE(110, -378) => @ORIENT("R0");
//   #"I809" @PLACE(242, -63) => @ORIENT("R0");
//   #"M68" @SET-SYMBOL %symbol_8;
//   #"M68" @PLACE(-10, -57) => @ORIENT("R0");
//   #"M51" @SET-SYMBOL %symbol_5;
//   #"M51" @PLACE(208, -528) => @ORIENT("R90");
//   #"M161" @SET-SYMBOL %symbol_4;
//   #"M161" @PLACE(212, -409) => @ORIENT("R270");
//   #"I1280" @PLACE(24, -168) => @ORIENT("R0");
//   #"I1308" @PLACE(314, -238) => @ORIENT("R0");
//   #"I1633" @SET-SYMBOL %symbol_3;
//   #"I1633" @PLACE(378, -764) => @ORIENT("R90");
//   #"M89" @SET-SYMBOL %symbol_5;
//   #"M89" @PLACE(208, 32) => @ORIENT("R90");
//   #"M26" @SET-SYMBOL %symbol_5;
//   #"M26" @PLACE(100, -143) => @ORIENT("R90");
//   #"M54" @SET-SYMBOL %symbol_5;
//   #"M54" @PLACE(208, -423) => @ORIENT("R90");
//   #"I1381" @PLACE(48, -588) => @ORIENT("R0");
//   #"I1635" @SET-SYMBOL %symbol_3;
//   #"I1635" @PLACE(174, -764) => @ORIENT("R90");
//   #"I1519" @SET-SYMBOL %symbol_1;
//   #"I1519" @PLACE(-30, -584) => @ORIENT("MY");
//   #"I1378" @PLACE(362, -518) => @ORIENT("R0");
//   #"I1191" @SET-SYMBOL %symbol_3;
//   #"I1191" @PLACE(29, -764) => @ORIENT("R90");
//   #"I1361" @PLACE(362, -448) => @ORIENT("R0");
//   #"I854" @PLACE(110, -133) => @ORIENT("R0");
//   #"I1053" @PLACE(134, -483) => @ORIENT("R0");
//   #"I1574" @PLACE(218, 77) => @ORIENT("R0");
//   #"I1464" @SET-SYMBOL %symbol_1;
//   #"I1464" @PLACE(-30, -59) => @ORIENT("MY");
//   #"I1309" @PLACE(338, -238) => @ORIENT("R0");
//   #"M137" @SET-SYMBOL %symbol_4;
//   #"M137" @PLACE(104, -269) => @ORIENT("R270");
//   #"I1538" @SET-SYMBOL %symbol_10;
//   #"I1538" @PLACE(-32, -733) => @ORIENT("MY");
//   #"I1143" @PLACE(386, -623) => @ORIENT("R0");
//   #"I842" @PLACE(72, -133) => @ORIENT("R0");
//   #"I547" @PLACE(158, 7) => @ORIENT("R0");
//   #"I1604" @PLACE(314, 77) => @ORIENT("R0");
//   #"I1213" @SET-SYMBOL %symbol_3;
//   #"I1213" @PLACE(319, -764) => @ORIENT("R90");
//   #"I782" @SET-SYMBOL %symbol_7;
//   #"I782" @PLACE(409, -38) => @ORIENT("MY");
//   #"M47" @SET-SYMBOL %symbol_5;
//   #"M47" @PLACE(208, -633) => @ORIENT("R90");
//   #"I1416" @PLACE(24, -728) => @ORIENT("R0");
//   #"I787" @PLACE(290, -28) => @ORIENT("R0");
//   #"I1267" @PLACE(134, -98) => @ORIENT("R0");
//   #"I1383" @PLACE(0, -588) => @ORIENT("R0");
//   #"I1326" @PLACE(338, -308) => @ORIENT("R0");
//   #"I1265" @PLACE(242, -98) => @ORIENT("R0");
//   #"I1567" @PLACE(242, 42) => @ORIENT("R0");
//   #"I1632" @SET-SYMBOL %symbol_3;
//   #"I1632" @PLACE(354, -764) => @ORIENT("R90");
//   #"I945" @PLACE(338, -273) => @ORIENT("R0");
//   #"I929" @PLACE(242, -273) => @ORIENT("R0");
//   #"I1418" @PLACE(242, -728) => @ORIENT("R0");
//   #"M87" @SET-SYMBOL %symbol_8;
//   #"M87" @PLACE(-14, 48) => @ORIENT("MY");
//   #"I1499" @SET-SYMBOL %symbol_0;
//   #"I1499" @PLACE(-63, -346) => @ORIENT("MY");
//   #"I1545" @PLACE(0, 42) => @ORIENT("R0");
//   #"I1405" @PLACE(182, -658) => @ORIENT("R0");
//   #"I1144" @PLACE(362, -623) => @ORIENT("R0");
//   #"I1606" @PLACE(362, 77) => @ORIENT("R0");
//   #"I1079" @PLACE(0, -553) => @ORIENT("R0");
//   #"I1367" @PLACE(242, -518) => @ORIENT("R0");
//   #"I1307" @PLACE(290, -238) => @ORIENT("R0");
//   #"I415" @PLACE(0, 7) => @ORIENT("R0");
//   #"I1384" @PLACE(242, -588) => @ORIENT("R0");
//   #"M174" @SET-SYMBOL %symbol_4;
//   #"M174" @PLACE(104, 46) => @ORIENT("R270");
//   #"I862" @SET-SYMBOL %symbol_7;
//   #"I862" @PLACE(409, -143) => @ORIENT("MY");
//   #"M171" @SET-SYMBOL %symbol_4;
//   #"M171" @PLACE(212, -59) => @ORIENT("R270");
//   #"M29" @SET-SYMBOL %symbol_5;
//   #"M29" @PLACE(100, -248) => @ORIENT("R90");
//   #"I1521" @SET-SYMBOL %symbol_0;
//   #"I1521" @PLACE(-63, -591) => @ORIENT("MY");
//   #"I1321" @PLACE(218, -308) => @ORIENT("R0");
//   #"I1092" @PLACE(158, -553) => @ORIENT("R0");
//   #"I1354" @PLACE(182, -448) => @ORIENT("R0");
//   #"I850" @PLACE(218, -133) => @ORIENT("R0");
//   #"I1359" @PLACE(314, -448) => @ORIENT("R0");
//   #"I1080" @PLACE(24, -553) => @ORIENT("R0");
//   #"M40" @SET-SYMBOL %symbol_5;
//   #"M40" @PLACE(100, -633) => @ORIENT("R90");
//   #"I1533" @SET-SYMBOL %symbol_9;
//   #"I1533" @PLACE(-32, -621) => @ORIENT("R0");
//   #"I892" @PLACE(158, -203) => @ORIENT("R0");
//   #"I778" @PLACE(182, -28) => @ORIENT("R0");
//   #"I1476" @SET-SYMBOL %symbol_10;
//   #"I1476" @PLACE(-32, -138) => @ORIENT("MY");
//   #"I1364" @PLACE(48, -518) => @ORIENT("R0");
//   #"I1094" @PLACE(110, -553) => @ORIENT("R0");
//   #"I904" @PLACE(362, -203) => @ORIENT("R0");
//   #"I1212" @SET-SYMBOL %symbol_3;
//   #"I1212" @PLACE(223, -764) => @ORIENT("R90");
//   #"M58" @SET-SYMBOL %symbol_5;
//   #"M58" @PLACE(208, -283) => @ORIENT("R90");
//   #"I1495" @SET-SYMBOL %symbol_1;
//   #"I1495" @PLACE(-30, -374) => @ORIENT("MY");
//   #"I1501" @SET-SYMBOL %symbol_9;
//   #"I1501" @PLACE(-32, -341) => @ORIENT("R0");
//   #"I1356" @SET-SYMBOL %symbol_7;
//   #"I1356" @PLACE(409, -458) => @ORIENT("MY");
//   #"I1543" @SET-SYMBOL %symbol_10;
//   #"I1543" @PLACE(-32, 37) => @ORIENT("MY");
//   #"I1171" @PLACE(182, -693) => @ORIENT("R0");
//   #"I934" @PLACE(110, -273) => @ORIENT("R0");
//   #"I1283" @PLACE(110, -168) => @ORIENT("R0");
//   #"I1188" @PLACE(266, -693) => @ORIENT("R0");
//   #"I1062" @SET-SYMBOL %symbol_7;
//   #"I1062" @PLACE(409, -493) => @ORIENT("MY");
//   #"I1488" @SET-SYMBOL %symbol_1;
//   #"I1488" @PLACE(-30, -269) => @ORIENT("MY");
//   #"I1475" @SET-SYMBOL %symbol_0;
//   #"I1475" @PLACE(-63, -136) => @ORIENT("MY");
//   #"I880" @PLACE(24, -203) => @ORIENT("R0");
//   #"I867" @PLACE(290, -133) => @ORIENT("R0");
//   #"I1579" @PLACE(242, 77) => @ORIENT("R0");
//   %bundle_3 = {#"I1638_26" #"I1638_25" #"I1638_24" #"I1638_23" #"I1638_22" #"I1638_21" #"I1638_20" #"I1638_19" #"I1638_18" #"I1638_17" #"I1638_16" #"I1638_15" #"I1638_14" #"I1638_13" #"I1638_12" #"I1638_11" #"I1638_10" #"I1638_9" #"I1638_8" #"I1638_7" #"I1638_6" #"I1638_5" #"I1638_4" #"I1638_3" #"I1638_2" #"I1638_1"} @BUNDLE;
//   %bundle_3 @SET-SYMBOL %symbol_11;
//   %bundle_3 @PLACE(-104, 31) => @ORIENT("R0");
//   %bundle_3 @TEXT("I1638<26:1>", key="name");
//   #"I1317" @PLACE(110, -308) => @ORIENT("R0");
//   #"I1089" @PLACE(242, -553) => @ORIENT("R0");
//   #"I1161" @PLACE(48, -693) => @ORIENT("R0");
//   #"M160" @SET-SYMBOL %symbol_4;
//   #"M160" @PLACE(212, -444) => @ORIENT("R270");
//   #"I1000" @PLACE(24, -413) => @ORIENT("R0");
//   #"M52" @SET-SYMBOL %symbol_5;
//   #"M52" @PLACE(208, -493) => @ORIENT("R90");
//   #"I987" @PLACE(290, -343) => @ORIENT("R0");
//   #"I591" @PLACE(218, 7) => @ORIENT("R0");
//   #"I503" @PLACE(110, 7) => @ORIENT("R0");
//   #"M162" @SET-SYMBOL %symbol_4;
//   #"M162" @PLACE(212, -164) => @ORIENT("R270");
//   #"I1525" @SET-SYMBOL %symbol_9;
//   #"I1525" @PLACE(-32, -551) => @ORIENT("R0");
//   #"I1605" @PLACE(338, 77) => @ORIENT("R0");
//   #"I1351" @PLACE(110, -448) => @ORIENT("R0");
//   #"I481" @PLACE(72, 7) => @ORIENT("R0");
//   #"I1278" @PLACE(72, -168) => @ORIENT("R0");
//   #"I1532" @SET-SYMBOL %symbol_10;
//   #"I1532" @PLACE(-32, -628) => @ORIENT("MY");
//   #"I784" @PLACE(362, -28) => @ORIENT("R0");
//   #"I1204" @SET-SYMBOL %symbol_3;
//   #"I1204" @PLACE(163, -764) => @ORIENT("R90");
//   #"M69" @SET-SYMBOL %symbol_8;
//   #"M69" @PLACE(-14, -162) => @ORIENT("MY");
//   #"M53" @SET-SYMBOL %symbol_5;
//   #"M53" @PLACE(208, -458) => @ORIENT("R90");
//   #"M22" @SET-SYMBOL %symbol_5;
//   #"M22" @PLACE(100, -3) => @ORIENT("R90");
//   #"I1530" @SET-SYMBOL %symbol_10;
//   #"I1530" @PLACE(-32, -663) => @ORIENT("MY");
//   #"I1013" @PLACE(134, -413) => @ORIENT("R0");
//   #"I1022" @SET-SYMBOL %symbol_7;
//   #"I1022" @PLACE(409, -423) => @ORIENT("MY");
//   #"I1129" @PLACE(242, -623) => @ORIENT("R0");
//   #"I1012" @PLACE(158, -413) => @ORIENT("R0");
//   #"I1024" @PLACE(362, -413) => @ORIENT("R0");
//   #"I908" @PLACE(266, -203) => @ORIENT("R0");
//   #"M83" @SET-SYMBOL %symbol_8;
//   #"M83" @PLACE(-14, -652) => @ORIENT("MY");
//   #"M175" @SET-SYMBOL %symbol_4;
//   #"M175" @PLACE(212, 81) => @ORIENT("R270");
//   #"I1103" @PLACE(386, -553) => @ORIENT("R0");
//   #"I1516" @SET-SYMBOL %symbol_10;
//   #"I1516" @PLACE(-32, -488) => @ORIENT("MY");
//   #"I1261" @PLACE(72, -98) => @ORIENT("R0");
//   #"I800" @PLACE(24, -63) => @ORIENT("R0");
//   #"I948" @PLACE(266, -273) => @ORIENT("R0");
//   #"I1429" @PLACE(362, -728) => @ORIENT("R0");
//   #"I907" @PLACE(290, -203) => @ORIENT("R0");
//   #"I893" @PLACE(134, -203) => @ORIENT("R0");
//   #"I943" @PLACE(386, -273) => @ORIENT("R0");
//   #"M168" @SET-SYMBOL %symbol_4;
//   #"M168" @PLACE(212, 11) => @ORIENT("R270");
//   #"I1628" @SET-SYMBOL %symbol_3;
//   #"I1628" @PLACE(258, -764) => @ORIENT("R90");
//   #"I1324" @PLACE(290, -308) => @ORIENT("R0");
//   #"I932" @PLACE(158, -273) => @ORIENT("R0");
//   #"I1602" @SET-SYMBOL %symbol_7;
//   #"I1602" @PLACE(409, 67) => @ORIENT("MY");
//   #"M151" @SET-SYMBOL %symbol_4;
//   #"M151" @PLACE(212, -724) => @ORIENT("R270");
//   #"M169" @SET-SYMBOL %symbol_4;
//   #"M169" @PLACE(212, -129) => @ORIENT("R270");
//   #"I1463" @SET-SYMBOL %symbol_1;
//   #"I1463" @PLACE(-30, -94) => @ORIENT("MY");
//   #"I1134" @PLACE(110, -623) => @ORIENT("R0");
//   #"I1402" @PLACE(110, -658) => @ORIENT("R0");
//   #"I919" @PLACE(0, -273) => @ORIENT("R0");
//   #"I1315" @PLACE(0, -308) => @ORIENT("R0");
//   #"I985" @PLACE(338, -343) => @ORIENT("R0");
//   #"I1148" @PLACE(266, -623) => @ORIENT("R0");
//   #"I1483" @SET-SYMBOL %symbol_0;
//   #"I1483" @PLACE(-63, -206) => @ORIENT("MY");
//   #"I1507" @SET-SYMBOL %symbol_0;
//   #"I1507" @PLACE(-63, -416) => @ORIENT("MY");
//   %symbol_15 = @DEFINE-SYMBOL(box=[1, 3, 3, 6]) {
//     @LINE {(2, 3) (2, 4)};
//     @LINE {(1, 5) (3, 5)};
//     @LINE {(2, 6) (2, 5)};
//     @LINE {(1, 4) (3, 4)};
//     ? @TEXT("${name}", size=0.4, halign="end", valign="top", key="name") => @PLACE(3, 6);
//     ? @TEXT("${model}", size=0.4, halign="end", valign="baseline", key="model") => @PLACE(3, 3);
//     (2, 6) @PIN(terminal=1);
//     (2.9, 6) @TEXT("VDD", size=0.4, halign="start", valign="middle");
//     (2, 3) @PIN(terminal=2);
//     (2.9, 3) @TEXT("VSS", size=0.4, halign="start", valign="middle")
//   };
//   #"I1642" @SET-SYMBOL %symbol_15;
//   #"I1642" @PLACE(-88, 31) => @ORIENT("R0");
//   #"I1332" @PLACE(0, -378) => @ORIENT("R0");
//   #"I1577" @PLACE(158, 77) => @ORIENT("R0");
//   #"M31" @SET-SYMBOL %symbol_5;
//   #"M31" @PLACE(100, -318) => @ORIENT("R90");
//   #"M50" @SET-SYMBOL %symbol_5;
//   #"M50" @PLACE(208, -563) => @ORIENT("R90");
//   #"I1529" @SET-SYMBOL %symbol_0;
//   #"I1529" @PLACE(-63, -661) => @ORIENT("MY");
//   #"I1552" @SET-SYMBOL %symbol_1;
//   #"I1552" @PLACE(-30, 81) => @ORIENT("MY");
//   #"I1432" @SET-SYMBOL %symbol_10;
//   #"I1432" @PLACE(-32, -33) => @ORIENT("MY");
//   #"I1286" @PLACE(182, -168) => @ORIENT("R0");
//   #"I1050" @PLACE(218, -483) => @ORIENT("R0");
//   #"I1028" @PLACE(266, -413) => @ORIENT("R0");
//   #"M142" @SET-SYMBOL %symbol_4;
//   #"M142" @PLACE(104, -444) => @ORIENT("R270");
//   #"I1528" @SET-SYMBOL %symbol_1;
//   #"I1528" @PLACE(-30, -619) => @ORIENT("MY");
//   #"M132" @SET-SYMBOL %symbol_4;
//   #"M132" @PLACE(104, -94) => @ORIENT("R270");
//   #"I988" @PLACE(266, -343) => @ORIENT("R0");
//   #"I781" @PLACE(110, -28) => @ORIENT("R0");
//   #"I1301" @PLACE(134, -238) => @ORIENT("R0");
//   #"I1189" @SET-SYMBOL %symbol_3;
//   #"I1189" @PLACE(5, -764) => @ORIENT("R90");
//   #"M140" @SET-SYMBOL %symbol_4;
//   #"M140" @PLACE(104, -374) => @ORIENT("R270");
//   #"I1502" @SET-SYMBOL %symbol_9;
//   #"I1502" @PLACE(8, -446) => @ORIENT("MY");
//   #"I799" @PLACE(0, -63) => @ORIENT("R0");
//   #"I921" @PLACE(48, -273) => @ORIENT("R0");
//   #"I1630" @SET-SYMBOL %symbol_3;
//   #"I1630" @PLACE(306, -764) => @ORIENT("R90");
//   #"M130" @SET-SYMBOL %symbol_4;
//   #"M130" @PLACE(104, -24) => @ORIENT("R270");
//   #"I1503" @SET-SYMBOL %symbol_1;
//   #"I1503" @PLACE(-30, -444) => @ORIENT("MY");
//   #"I1183" @PLACE(386, -693) => @ORIENT("R0");
//   #"I1172" @PLACE(158, -693) => @ORIENT("R0");
//   #"I973" @PLACE(134, -343) => @ORIENT("R0");
//   #"M170" @SET-SYMBOL %symbol_4;
//   #"M170" @PLACE(212, -94) => @ORIENT("R270");
//   #"I1051" @PLACE(182, -483) => @ORIENT("R0");
//   #"I1534" @SET-SYMBOL %symbol_9;
//   #"I1534" @PLACE(8, -726) => @ORIENT("MY");
//   #"I1132" @PLACE(158, -623) => @ORIENT("R0");
//   #"I1456" @SET-SYMBOL %symbol_7;
//   #"I1456" @PLACE(207, -781) => @ORIENT("R90");
//   #"M39" @SET-SYMBOL %symbol_5;
//   #"M39" @PLACE(100, -598) => @ORIENT("R90");
//   #"I1039" @PLACE(0, -483) => @ORIENT("R0");
//   #"I866" @PLACE(314, -133) => @ORIENT("R0");
//   #"I1147" @PLACE(290, -623) => @ORIENT("R0");
//   #"I1554" @PLACE(24, 77) => @ORIENT("R0");
//   #"I768" @SET-SYMBOL %symbol_7;
//   #"I768" @PLACE(409, -3) => @ORIENT("MY");
//   #"I972" @PLACE(158, -343) => @ORIENT("R0");
//   #"M71" @SET-SYMBOL %symbol_8;
//   #"M71" @PLACE(-14, -232) => @ORIENT("MY");
//   #"M90" @SET-SYMBOL %symbol_5;
//   #"M90" @PLACE(100, 32) => @ORIENT("R90");
//   #"I723" @PLACE(362, 7) => @ORIENT("R0");
//   #"I1349" @PLACE(0, -448) => @ORIENT("R0");
//   #"I1296" @PLACE(48, -238) => @ORIENT("R0");
//   #"I1215" @SET-SYMBOL %symbol_3;
//   #"I1215" @PLACE(391, -764) => @ORIENT("R90");
//   #"M91" @SET-SYMBOL %symbol_5;
//   #"M91" @PLACE(100, 67) => @ORIENT("R90");
//   #"I1468" @SET-SYMBOL %symbol_10;
//   #"I1468" @PLACE(-32, -68) => @ORIENT("MY");
//   #"M72" @SET-SYMBOL %symbol_8;
//   #"M72" @PLACE(-10, -197) => @ORIENT("R0");
//   #"I1462" @SET-SYMBOL %symbol_9;
//   #"I1462" @PLACE(8, -96) => @ORIENT("MY");
//   #"I1358" @PLACE(290, -448) => @ORIENT("R0");
//   #"I882" @PLACE(72, -203) => @ORIENT("R0");
//   #"M77" @SET-SYMBOL %symbol_8;
//   #"M77" @PLACE(-14, -442) => @ORIENT("MY");
//   #"I974" @PLACE(110, -343) => @ORIENT("R0");
//   #"I1386" @PLACE(134, -588) => @ORIENT("R0");
//   #"I962" @PLACE(72, -343) => @ORIENT("R0");
//   #"I811" @PLACE(182, -63) => @ORIENT("R0");
//   #"M158" @SET-SYMBOL %symbol_4;
//   #"M158" @PLACE(212, -514) => @ORIENT("R270");
//   #"I1471" @SET-SYMBOL %symbol_1;
//   #"I1471" @PLACE(-30, -164) => @ORIENT("MY");
//   #"I1571" @PLACE(134, 42) => @ORIENT("R0");
//   #"I1637" @SET-SYMBOL %symbol_7;
//   #"I1637" @PLACE(411, -771) => @ORIENT("MY");
//   #"I769" @SET-SYMBOL %symbol_1;
//   #"I769" @PLACE(-30, -24) => @ORIENT("MY");
//   #"I827" @PLACE(290, -63) => @ORIENT("R0");
//   #"I1363" @PLACE(72, -518) => @ORIENT("R0");
//   #"I891" @PLACE(182, -203) => @ORIENT("R0");
//   #"I1414" @PLACE(72, -728) => @ORIENT("R0");
//   #"I1068" @PLACE(266, -483) => @ORIENT("R0");
//   #"I1311" @PLACE(386, -238) => @ORIENT("R0");
//   #"I1327" @PLACE(362, -308) => @ORIENT("R0");
//   #"I903" @PLACE(386, -203) => @ORIENT("R0");
//   #"I1430" @PLACE(386, -728) => @ORIENT("R0");
//   #"I1346" @PLACE(72, -448) => @ORIENT("R0");
//   #"I1108" @PLACE(266, -553) => @ORIENT("R0");
//   #"I1347" @PLACE(48, -448) => @ORIENT("R0");
//   #"I779" @PLACE(158, -28) => @ORIENT("R0");
//   %bundle_4 = {#"I1641_8" #"I1641_7" #"I1641_6" #"I1641_5" #"I1641_4" #"I1641_3" #"I1641_2" #"I1641_1"} @BUNDLE;
//   %symbol_16 = @DEFINE-SYMBOL(box=[1, 3, 3, 6]) {
//     @LINE {(2, 3) (2, 4)};
//     @LINE {(1, 5) (3, 5)};
//     @LINE {(2, 6) (2, 5)};
//     @LINE {(1, 4) (3, 4)};
//     ? @TEXT("${name}", size=0.4, halign="end", valign="top", key="name") => @PLACE(3, 6);
//     ? @TEXT("${model}", size=0.4, halign="end", valign="baseline", key="model") => @PLACE(3, 3);
//     (2, 6) @PIN(terminal=1);
//     (2.9, 6) @TEXT("VDD", size=0.4, halign="start", valign="middle");
//     (2, 3) @PIN(terminal=2);
//     (2.9, 3) @TEXT("VSS", size=0.4, halign="start", valign="middle")
//   };
//   %bundle_4 @SET-SYMBOL %symbol_16;
//   %bundle_4 @PLACE(-92, 31) => @ORIENT("R0");
//   %bundle_4 @TEXT("I1641<8:1>", key="name");
//   #"M81" @SET-SYMBOL %symbol_8;
//   #"M81" @PLACE(-14, -582) => @ORIENT("MY");
//   #"I1142" @SET-SYMBOL %symbol_7;
//   #"I1142" @PLACE(409, -633) => @ORIENT("MY");
//   #"I1524" @SET-SYMBOL %symbol_10;
//   #"I1524" @PLACE(-32, -558) => @ORIENT("MY");
//   #"I1263" @PLACE(24, -98) => @ORIENT("R0");
//   #"I1540" @SET-SYMBOL %symbol_10;
//   #"I1540" @PLACE(-32, -698) => @ORIENT("MY");
//   #"I1492" @SET-SYMBOL %symbol_10;
//   #"I1492" @PLACE(-32, -278) => @ORIENT("MY");
//   #"I1370" @PLACE(158, -518) => @ORIENT("R0");
//   #"I1600" @PLACE(314, 42) => @ORIENT("R0");
//   #"I1623" @SET-SYMBOL %symbol_3;
//   #"I1623" @PLACE(88, -764) => @ORIENT("R90");
//   #"M24" @SET-SYMBOL %symbol_5;
//   #"M24" @PLACE(100, -73) => @ORIENT("R90");
//   #"M56" @SET-SYMBOL %symbol_5;
//   #"M56" @PLACE(208, -353) => @ORIENT("R90");
//   #"I1270" @PLACE(218, -98) => @ORIENT("R0");
//   #"I1299" @PLACE(242, -238) => @ORIENT("R0");
//   #"M46" @SET-SYMBOL %symbol_5;
//   #"M46" @PLACE(208, -668) => @ORIENT("R90");
//   #"I920" @PLACE(24, -273) => @ORIENT("R0");
//   #"I1415" @PLACE(48, -728) => @ORIENT("R0");
//   #"I1365" @PLACE(24, -518) => @ORIENT("R0");
//   #"I1107" @PLACE(290, -553) => @ORIENT("R0");
//   #"I1293" @PLACE(362, -168) => @ORIENT("R0");
//   #"I1348" @PLACE(24, -448) => @ORIENT("R0");
//   #"I1373" @SET-SYMBOL %symbol_7;
//   #"I1373" @PLACE(409, -528) => @ORIENT("MY");
//   #"M35" @SET-SYMBOL %symbol_5;
//   #"M35" @PLACE(100, -458) => @ORIENT("R90");
//   #"M38" @SET-SYMBOL %symbol_5;
//   #"M38" @PLACE(100, -563) => @ORIENT("R90");
//   #"I1546" @PLACE(24, 42) => @ORIENT("R0");
//   #"I1310" @PLACE(362, -238) => @ORIENT("R0");
//   #"I1160" @PLACE(24, -693) => @ORIENT("R0");
//   #"M44" @SET-SYMBOL %symbol_4;
//   #"M44" @PLACE(104, 11) => @ORIENT("R270");
//   #"I1223" @SET-SYMBOL %symbol_0;
//   #"I1223" @PLACE(408, -759) => @ORIENT("MY");
//   #"I1504" @SET-SYMBOL %symbol_1;
//   #"I1504" @PLACE(-30, -409) => @ORIENT("MY");
//   #"I1510" @SET-SYMBOL %symbol_9;
//   #"I1510" @PLACE(8, -516) => @ORIENT("MY");
//   #"I1322" @SET-SYMBOL %symbol_7;
//   #"I1322" @PLACE(409, -318) => @ORIENT("MY");
//   #"I1041" @PLACE(48, -483) => @ORIENT("R0");
//   #"I1465" @SET-SYMBOL %symbol_0;
//   #"I1465" @PLACE(-63, -101) => @ORIENT("MY");
//   #"I1422" @PLACE(182, -728) => @ORIENT("R0");
//   #"I1403" @PLACE(134, -658) => @ORIENT("R0");
//   #"I849" @PLACE(242, -133) => @ORIENT("R0");
//   #"M79" @SET-SYMBOL %symbol_8;
//   #"M79" @PLACE(-14, -512) => @ORIENT("MY");
//   #"I813" @PLACE(134, -63) => @ORIENT("R0");
//   #"I1474" @SET-SYMBOL %symbol_10;
//   #"I1474" @PLACE(-32, -173) => @ORIENT("MY");
//   #"I1469" @SET-SYMBOL %symbol_9;
//   #"I1469" @PLACE(-32, -61) => @ORIENT("R0");
//   #"I1302" @PLACE(158, -238) => @ORIENT("R0");
//   #"M70" @SET-SYMBOL %symbol_8;
//   #"M70" @PLACE(-10, -127) => @ORIENT("R0");
//   #"I1093" @PLACE(134, -553) => @ORIENT("R0");
//   #"I865" @PLACE(338, -133) => @ORIENT("R0");
//   %marker_24 = (272, 92);
//   $FIGURE @ATTACH %marker_24 => @SET-SYMBOL $NO_CONNECT_SYMBOL => @ORIENT("R180");
//   %marker_56 = (342, 92);
//   $FIGURE @ATTACH %marker_56 => @SET-SYMBOL $NO_CONNECT_SYMBOL => @ORIENT("R180");
//   %marker_76 = (6, 92);
//   $FIGURE @ATTACH %marker_76 => @SET-SYMBOL $NO_CONNECT_SYMBOL => @ORIENT("R180");
//   %marker_82 = (368, 92);
//   $FIGURE @ATTACH %marker_82 => @SET-SYMBOL $NO_CONNECT_SYMBOL => @ORIENT("R180");
//   %marker_102 = (162, 92);
//   $FIGURE @ATTACH %marker_102 => @SET-SYMBOL $NO_CONNECT_SYMBOL => @ORIENT("R180");
//   %marker_106 = (4, 92);
//   $FIGURE @ATTACH %marker_106 => @SET-SYMBOL $NO_CONNECT_SYMBOL => @ORIENT("R180");
//   %marker_111 = (164, 92);
//   $FIGURE @ATTACH %marker_111 => @SET-SYMBOL $NO_CONNECT_SYMBOL => @ORIENT("R180");
//   %marker_127 = (344, 92);
//   $FIGURE @ATTACH %marker_127 => @SET-SYMBOL $NO_CONNECT_SYMBOL => @ORIENT("R180");
//   %marker_142 = (246, 92);
//   $FIGURE @ATTACH %marker_142 => @SET-SYMBOL $NO_CONNECT_SYMBOL => @ORIENT("R180");
//   %marker_156 = (186, 92);
//   $FIGURE @ATTACH %marker_156 => @SET-SYMBOL $NO_CONNECT_SYMBOL => @ORIENT("R180");
//   %marker_551 = (224, 92);
//   $FIGURE @ATTACH %marker_551 => @SET-SYMBOL $NO_CONNECT_SYMBOL => @ORIENT("R180");
//   %marker_564 = (212, 92);
//   $FIGURE @ATTACH %marker_564 => @SET-SYMBOL $NO_CONNECT_SYMBOL => @ORIENT("R180");
//   %marker_605 = (114, 92);
//   $FIGURE @ATTACH %marker_605 => @SET-SYMBOL $NO_CONNECT_SYMBOL => @ORIENT("R180");
//   %marker_711 = (52, 92);
//   $FIGURE @ATTACH %marker_711 => @SET-SYMBOL $NO_CONNECT_SYMBOL => @ORIENT("R180");
//   %marker_718 = (138, 92);
//   $FIGURE @ATTACH %marker_718 => @SET-SYMBOL $NO_CONNECT_SYMBOL => @ORIENT("R180");
//   %marker_721 = (248, 92);
//   $FIGURE @ATTACH %marker_721 => @SET-SYMBOL $NO_CONNECT_SYMBOL => @ORIENT("R180");
//   %marker_757 = (100, 92);
//   $FIGURE @ATTACH %marker_757 => @SET-SYMBOL $NO_CONNECT_SYMBOL => @ORIENT("R180");
//   %marker_763 = (140, 92);
//   $FIGURE @ATTACH %marker_763 => @SET-SYMBOL $NO_CONNECT_SYMBOL => @ORIENT("R180");
//   %marker_789 = (294, 92);
//   $FIGURE @ATTACH %marker_789 => @SET-SYMBOL $NO_CONNECT_SYMBOL => @ORIENT("R180");
//   %marker_819 = (296, 92);
//   $FIGURE @ATTACH %marker_819 => @SET-SYMBOL $NO_CONNECT_SYMBOL => @ORIENT("R180");
//   %marker_824 = (208, 92);
//   $FIGURE @ATTACH %marker_824 => @SET-SYMBOL $NO_CONNECT_SYMBOL => @ORIENT("R180");
//   %marker_846 = (366, 92);
//   $FIGURE @ATTACH %marker_846 => @SET-SYMBOL $NO_CONNECT_SYMBOL => @ORIENT("R180");
//   %marker_885 = (392, 92);
//   $FIGURE @ATTACH %marker_885 => @SET-SYMBOL $NO_CONNECT_SYMBOL => @ORIENT("R180");
//   %marker_903 = (104, 92);
//   $FIGURE @ATTACH %marker_903 => @SET-SYMBOL $NO_CONNECT_SYMBOL => @ORIENT("R180");
//   %marker_915 = (116, 92);
//   $FIGURE @ATTACH %marker_915 => @SET-SYMBOL $NO_CONNECT_SYMBOL => @ORIENT("R180");
//   %marker_921 = (76, 92);
//   $FIGURE @ATTACH %marker_921 => @SET-SYMBOL $NO_CONNECT_SYMBOL => @ORIENT("R180");
//   %marker_943 = (30, 92);
//   $FIGURE @ATTACH %marker_943 => @SET-SYMBOL $NO_CONNECT_SYMBOL => @ORIENT("R180");
//   %marker_945 = (390, 92);
//   $FIGURE @ATTACH %marker_945 => @SET-SYMBOL $NO_CONNECT_SYMBOL => @ORIENT("R180");
//   %marker_948 = (78, 92);
//   $FIGURE @ATTACH %marker_948 => @SET-SYMBOL $NO_CONNECT_SYMBOL => @ORIENT("R180");
//   %marker_977 = (188, 92);
//   $FIGURE @ATTACH %marker_977 => @SET-SYMBOL $NO_CONNECT_SYMBOL => @ORIENT("R180");
//   %marker_984 = (318, 92);
//   $FIGURE @ATTACH %marker_984 => @SET-SYMBOL $NO_CONNECT_SYMBOL => @ORIENT("R180");
//   %marker_1000 = (222, 92);
//   $FIGURE @ATTACH %marker_1000 => @SET-SYMBOL $NO_CONNECT_SYMBOL => @ORIENT("R180");
//   %marker_1005 = (54, 92);
//   $FIGURE @ATTACH %marker_1005 => @SET-SYMBOL $NO_CONNECT_SYMBOL => @ORIENT("R180");
//   %marker_1045 = (320, 92);
//   $FIGURE @ATTACH %marker_1045 => @SET-SYMBOL $NO_CONNECT_SYMBOL => @ORIENT("R180");
//   %marker_1151 = (28, 92);
//   $FIGURE @ATTACH %marker_1151 => @SET-SYMBOL $NO_CONNECT_SYMBOL => @ORIENT("R180");
//   %marker_1159 = (270, 92);
//   $FIGURE @ATTACH %marker_1159 => @SET-SYMBOL $NO_CONNECT_SYMBOL => @ORIENT("R180");
//   %input_port_symbol = @DEFINE-SYMBOL(box=[-2, -1, 0, 1]) {
//       @LINE(fill="linecolor", linestyle="none") {(-2, -0.9) (-2, 0.9) (-0.9, 0.9) (0, 0) (-0.9, -0.9) (-2, -0.9)};
//       (0, 0) @PIN(terminal="p", direction="right");
//       ? @TEXT("${p}", key="netname", halign="middle") => @PLACE(-1, 1.6)
//     };
//   %port_0 = $IO_PORT @ATTACH &"SDI" => @PLACE(-101, 61) => @ORIENT("R0");
//   %port_0 @SET-SYMBOL %input_port_symbol;
//   %port_0 @TEXT("SDI", key="netname");
//   %output_port_symbol = @DEFINE-SYMBOL(box=[0, -1, 2, 1]) {
//       @LINE(fill="linecolor", linestyle="none") {(0, -0.9) (0, 0.9) (1.1, 0.9) (2, 0) (1.1, -0.9) (0, -0.9)};
//       (0, 0) @PIN(terminal="p", direction="left");
//       ? @TEXT("${p}", key="netname", halign="middle") => @PLACE(1, 1.6)
//     };
//   %port_1 = $IO_PORT @ATTACH &"SCKO" => @PLACE(-103, 49) => @ORIENT("R0");
//   %port_1 @SET-SYMBOL %output_port_symbol;
//   %port_1 @TEXT("SCKO", key="netname");
//   %bus_port_type_2 = @DEFINE(roles=[["p", "net"], ["p1", "net"], ["p2", "net"], ["p3", "net"], ["p4", "net"], ["p5", "net"], ["p6", "net"], ["p7", "net"], ["p8", "net"], ["p9", "net"], ["p10", "net"], ["p11", "net"], ["p12", "net"], ["p13", "net"], ["p14", "net"], ["p15", "net"]]) {};
//   %bus_port_type_2_symbol = @DEFINE-SYMBOL {(0, 0) @PIN(terminal=["p", "p1", "p2", "p3", "p4", "p5", "p6", "p7", "p8", "p9", "p10", "p11", "p12", "p13", "p14", "p15"])};
//   {&"FRAME_0" &"FRAME_1" &"FRAME_2" &"FRAME_3" &"FRAME_4" &"FRAME_5" &"FRAME_6" &"FRAME_7" &"FRAME_8" &"FRAME_9" &"FRAME_10" &"FRAME_11" &"FRAME_12" &"FRAME_13" &"FRAME_14" &"FRAME_15"} @REMOVE-FROM $PORT_FILL_SET;
//   %port_2 = %bus_port_type_2 @ATTACH &"FRAME_0" &"FRAME_1" &"FRAME_2" &"FRAME_3" &"FRAME_4" &"FRAME_5" &"FRAME_6" &"FRAME_7" &"FRAME_8" &"FRAME_9" &"FRAME_10" &"FRAME_11" &"FRAME_12" &"FRAME_13" &"FRAME_14" &"FRAME_15" => @PLACE(-101, 73) => @ORIENT("R0");
//   %port_2 @SET-SYMBOL %bus_port_type_2_symbol;
//   %port_2_marker = $IO_PORT @ATTACH &"FRAME_0" => @PLACE(-101, 73) => @ORIENT("R0");
//   %port_2_marker @SET-SYMBOL %input_port_symbol;
//   %port_2_marker @TEXT("FRAME<0:15>", key="netname");
//   %port_3 = $IO_PORT @ATTACH &"VDD" => @PLACE(-101, 77) => @ORIENT("R0");
//   %port_4 = $IO_PORT @ATTACH &"SDO" => @PLACE(-103, 53) => @ORIENT("R0");
//   %port_4 @SET-SYMBOL %output_port_symbol;
//   %port_4 @TEXT("SDO", key="netname");
//   %port_5 = $IO_PORT @ATTACH &"SCKI" => @PLACE(-101, 57) => @ORIENT("R0");
//   %port_5 @SET-SYMBOL %input_port_symbol;
//   %port_5 @TEXT("SCKI", key="netname");
//   %bus_port_type_6 = @DEFINE(roles=[["p", "net"], ["p1", "net"], ["p2", "net"], ["p3", "net"], ["p4", "net"], ["p5", "net"], ["p6", "net"], ["p7", "net"], ["p8", "net"], ["p9", "net"], ["p10", "net"], ["p11", "net"], ["p12", "net"], ["p13", "net"], ["p14", "net"], ["p15", "net"], ["p16", "net"], ["p17", "net"], ["p18", "net"], ["p19", "net"], ["p20", "net"], ["p21", "net"], ["p22", "net"], ["p23", "net"]]) {};
//   %bus_port_type_6_symbol = @DEFINE-SYMBOL {(0, 0) @PIN(terminal=["p", "p1", "p2", "p3", "p4", "p5", "p6", "p7", "p8", "p9", "p10", "p11", "p12", "p13", "p14", "p15", "p16", "p17", "p18", "p19", "p20", "p21", "p22", "p23"])};
//   {&"OUT_23" &"OUT_22" &"OUT_21" &"OUT_20" &"OUT_19" &"OUT_18" &"OUT_17" &"OUT_16" &"OUT_15" &"OUT_14" &"OUT_13" &"OUT_12" &"OUT_11" &"OUT_10" &"OUT_9" &"OUT_8" &"OUT_7" &"OUT_6" &"OUT_5" &"OUT_4" &"OUT_3" &"OUT_2" &"OUT_1" &"OUT_0"} @REMOVE-FROM $PORT_FILL_SET;
//   %port_6 = %bus_port_type_6 @ATTACH &"OUT_23" &"OUT_22" &"OUT_21" &"OUT_20" &"OUT_19" &"OUT_18" &"OUT_17" &"OUT_16" &"OUT_15" &"OUT_14" &"OUT_13" &"OUT_12" &"OUT_11" &"OUT_10" &"OUT_9" &"OUT_8" &"OUT_7" &"OUT_6" &"OUT_5" &"OUT_4" &"OUT_3" &"OUT_2" &"OUT_1" &"OUT_0" => @PLACE(-103, 65) => @ORIENT("R0");
//   %port_6 @SET-SYMBOL %bus_port_type_6_symbol;
//   %port_6_marker = $IO_PORT @ATTACH &"OUT_23" => @PLACE(-103, 65) => @ORIENT("R0");
//   %port_6_marker @SET-SYMBOL %output_port_symbol;
//   %port_6_marker @TEXT("OUT<23:0>", key="netname");
//   %port_7 = $IO_PORT @ATTACH &"GND" => @PLACE(-101, 81) => @ORIENT("R0");
//   %port_8 = $IO_PORT @ATTACH &"RST" => @PLACE(-101, 45) => @ORIENT("R0");
//   %port_8 @SET-SYMBOL %input_port_symbol;
//   %port_8 @TEXT("RST", key="netname");
//   %bus_port_type_9 = @DEFINE(roles=[["p", "net"], ["p1", "net"], ["p2", "net"], ["p3", "net"], ["p4", "net"], ["p5", "net"], ["p6", "net"], ["p7", "net"], ["p8", "net"], ["p9", "net"], ["p10", "net"], ["p11", "net"], ["p12", "net"], ["p13", "net"], ["p14", "net"], ["p15", "net"], ["p16", "net"]]) {};
//   %bus_port_type_9_symbol = @DEFINE-SYMBOL {(0, 0) @PIN(terminal=["p", "p1", "p2", "p3", "p4", "p5", "p6", "p7", "p8", "p9", "p10", "p11", "p12", "p13", "p14", "p15", "p16"])};
//   {&"REPET_1" &"REPET_2" &"REPET_3" &"REPET_4" &"REPET_5" &"REPET_6" &"REPET_7" &"REPET_8" &"REPET_9" &"REPET_10" &"REPET_11" &"REPET_12" &"REPET_13" &"REPET_14" &"REPET_15" &"REPET_16" &"REPET_17"} @REMOVE-FROM $PORT_FILL_SET;
//   %port_9 = %bus_port_type_9 @ATTACH &"REPET_1" &"REPET_2" &"REPET_3" &"REPET_4" &"REPET_5" &"REPET_6" &"REPET_7" &"REPET_8" &"REPET_9" &"REPET_10" &"REPET_11" &"REPET_12" &"REPET_13" &"REPET_14" &"REPET_15" &"REPET_16" &"REPET_17" => @PLACE(-101, 69) => @ORIENT("R0");
//   %port_9 @SET-SYMBOL %bus_port_type_9_symbol;
//   %port_9_marker = $IO_PORT @ATTACH &"REPET_1" => @PLACE(-101, 69) => @ORIENT("R0");
//   %port_9_marker @SET-SYMBOL %input_port_symbol;
//   %port_9_marker @TEXT("REPET<1:17>", key="netname");
//   %wire_0 = &"net582" @WIRE(mode="straight") {#"I1551":1 #"I1552":2};
//   %wire_1 = &"net581" @WIRE(mode="straight") {#"I1542":1 #"I1543":3};
//   %wire_2 = &"net580" @WIRE(mode="straight") {#"I1550":1 #"I1551":3};
//   %wire_3 = &"net577" @WIRE(mode="straight") {#"I1543":1 #"I1544":2};
//   %p0 = (36, 86);
//   %wire_4 = &"net576" @WIRE(mode="straight") {#"I1554":6 %p0};
//   %p1 = (34, 86);
//   %wire_5 = &"net576" @WIRE(mode="straight") {%p1 %p0};
//   %wire_6 = &"net576" @WIRE(mode="straight") {#"I1554":3 %p1};
//   %p2 = (14, 86);
//   %wire_7 = &"net576" @WIRE(mode="straight") {%p2 %p1};
//   %wire_8 = &"net576" @WIRE(mode="straight") {#"I1553":7 %p2};
//   %p3 = (34, 51);
//   %wire_9 = &"net575" @WIRE(mode="straight") {#"I1546":3 %p3};
//   %p4 = (14, 53);
//   %wire_10 = &"net575" @WIRE(mode="straight") {%p3 %p4};
//   %wire_11 = &"net575" @WIRE(mode="straight") {#"I1545":7 %p4};
//   %p5 = (-4, 53);
//   %wire_12 = &"net575" @WIRE(mode="straight") {%p5 %p4};
//   %wire_13 = &"net575" @WIRE(mode="straight") {#"I1549":1 %p5};
//   %wire_14 = &"net573" @WIRE(mode="straight") {#"M176":2 %marker_903};
//   %wire_15 = &"net573" @WIRE(mode="straight") {#"M174":2 #"M176":2};
//   %wire_16 = &"net573" @WIRE(mode="straight") {#"M44":2 #"M174":2};
//   %wire_17 = &"net573" @WIRE(mode="straight") {#"M138":2 #"M137":2};
//   %wire_18 = &"net573" @WIRE(mode="straight") {#"M142":2 #"M141":2};
//   %wire_19 = &"net573" @WIRE(mode="straight") {#"M146":2 #"M145":2};
//   %wire_20 = &"net573" @WIRE(mode="straight") {#"M150":2 #"M149":2};
//   %wire_21 = &"net573" @WIRE(mode="straight") {#"M135":2 #"M134":2};
//   %wire_22 = &"net573" @WIRE(mode="straight") {#"M133":2 #"M132":2};
//   %wire_23 = &"net573" @WIRE(mode="straight") {#"M131":2 #"M130":2};
//   %wire_24 = &"net573" @WIRE(mode="straight") {#"M137":2 #"M136":2};
//   %wire_25 = &"net573" @WIRE(mode="straight") {#"M139":2 #"M138":2};
//   %wire_26 = &"net573" @WIRE(mode="straight") {#"M141":2 #"M140":2};
//   %wire_27 = &"net573" @WIRE(mode="straight") {#"M143":2 #"M142":2};
//   %wire_28 = &"net573" @WIRE(mode="straight") {#"M136":2 #"M135":2};
//   %wire_29 = &"net573" @WIRE(mode="straight") {#"M149":2 #"M148":2};
//   %wire_30 = &"net573" @WIRE(mode="straight") {#"M144":2 #"M143":2};
//   %wire_31 = &"net573" @WIRE(mode="straight") {#"M148":2 #"M147":2};
//   %wire_32 = &"net573" @WIRE(mode="straight") {#"M140":2 #"M139":2};
//   %wire_33 = &"net573" @WIRE(mode="straight") {#"M145":2 #"M144":2};
//   %wire_34 = &"net573" @WIRE(mode="straight") {#"I1454":2 #"M150":2};
//   %wire_35 = &"net573" @WIRE(mode="straight") {#"M134":2 #"M133":2};
//   %wire_36 = &"net573" @WIRE(mode="straight") {#"M132":2 #"M131":2};
//   %wire_37 = &"net573" @WIRE(mode="straight") {#"M147":2 #"M146":2};
//   %wire_38 = &"net573" @WIRE(mode="straight") {#"M130":2 #"M44":2};
//   %wire_39 = &"net571" @WIRE(mode="straight") {#"M91":2 %marker_757};
//   %wire_40 = &"net571" @WIRE(mode="straight") {#"M90":2 #"M91":2};
//   %wire_41 = &"net571" @WIRE(mode="straight") {#"M22":2 #"M90":2};
//   %wire_42 = &"net571" @WIRE(mode="straight") {#"M23":2 #"M22":2};
//   %wire_43 = &"net571" @WIRE(mode="straight") {#"M24":2 #"M23":2};
//   %wire_44 = &"net571" @WIRE(mode="straight") {#"M25":2 #"M24":2};
//   %wire_45 = &"net571" @WIRE(mode="straight") {#"M26":2 #"M25":2};
//   %wire_46 = &"net571" @WIRE(mode="straight") {#"M27":2 #"M26":2};
//   %wire_47 = &"net571" @WIRE(mode="straight") {#"M28":2 #"M27":2};
//   %wire_48 = &"net571" @WIRE(mode="straight") {#"M29":2 #"M28":2};
//   %wire_49 = &"net571" @WIRE(mode="straight") {#"M30":2 #"M29":2};
//   %wire_50 = &"net571" @WIRE(mode="straight") {#"M31":2 #"M30":2};
//   %wire_51 = &"net571" @WIRE(mode="straight") {#"M32":2 #"M31":2};
//   %wire_52 = &"net571" @WIRE(mode="straight") {#"M33":2 #"M32":2};
//   %wire_53 = &"net571" @WIRE(mode="straight") {#"M34":2 #"M33":2};
//   %wire_54 = &"net571" @WIRE(mode="straight") {#"M35":2 #"M34":2};
//   %wire_55 = &"net571" @WIRE(mode="straight") {#"M36":2 #"M35":2};
//   %p6 = (104, -780);
//   %wire_56 = &"net571" @WIRE(mode="straight") {#"I1221":2 %p6};
//   %wire_57 = &"net571" @WIRE(mode="straight") {#"M37":2 #"M36":2};
//   %wire_58 = &"net571" @WIRE(mode="straight") {#"M39":2 #"M38":2};
//   %wire_59 = &"net571" @WIRE(mode="straight") {#"M41":2 #"M40":2};
//   %wire_60 = &"net571" @WIRE(mode="straight") {#"M43":2 #"M42":2};
//   %wire_61 = &"net571" @WIRE(mode="straight") {#"M38":2 #"M37":2};
//   %wire_62 = &"net571" @WIRE(mode="straight") {#"M40":2 #"M39":2};
//   %wire_63 = &"net571" @WIRE(mode="straight") {#"M42":2 #"M41":2};
//   %p7 = (100, -780);
//   %wire_64 = &"net571" @WIRE(mode="straight") {%p7 %p6};
//   %wire_65 = &"net571" @WIRE(mode="straight") {%p6 #"I1454":1};
//   %wire_66 = &"net571" @WIRE(mode="straight") {%p7 #"M43":2};
//   %p8 = (84, 86);
//   %wire_67 = &"net570" @WIRE(mode="straight") {#"I1556":6 %p8};
//   %p9 = (82, 86);
//   %wire_68 = &"net570" @WIRE(mode="straight") {%p9 %p8};
//   %wire_69 = &"net570" @WIRE(mode="straight") {#"I1556":3 %p9};
//   %p10 = (62, 86);
//   %wire_70 = &"net570" @WIRE(mode="straight") {%p10 %p9};
//   %wire_71 = &"net570" @WIRE(mode="straight") {#"I1555":7 %p10};
//   %p11 = (82, 51);
//   %wire_72 = &"net569" @WIRE(mode="straight") {#"I1548":3 %p11};
//   %p12 = (62, 53);
//   %wire_73 = &"net569" @WIRE(mode="straight") {%p11 %p12};
//   %wire_74 = &"net569" @WIRE(mode="straight") {#"I1547":7 %p12};
//   %p13 = (36, 51);
//   %wire_75 = &"net569" @WIRE(mode="straight") {%p13 %p12};
//   %wire_76 = &"net569" @WIRE(mode="straight") {#"I1546":6 %p13};
//   %p14 = (58, 51);
//   %wire_77 = &"net566" @WIRE(mode="straight") {#"I1547":3 %p14};
//   %p15 = (38, 53);
//   %wire_78 = &"net566" @WIRE(mode="straight") {%p14 %p15};
//   %wire_79 = &"net566" @WIRE(mode="straight") {#"I1546":7 %p15};
//   %p16 = (12, 51);
//   %wire_80 = &"net566" @WIRE(mode="straight") {%p16 %p15};
//   %wire_81 = &"net566" @WIRE(mode="straight") {#"I1545":6 %p16};
//   %p17 = (60, 86);
//   %wire_82 = &"net565" @WIRE(mode="straight") {#"I1555":6 %p17};
//   %p18 = (58, 86);
//   %wire_83 = &"net565" @WIRE(mode="straight") {%p18 %p17};
//   %wire_84 = &"net565" @WIRE(mode="straight") {#"I1555":3 %p18};
//   %p19 = (38, 86);
//   %wire_85 = &"net565" @WIRE(mode="straight") {%p19 %p18};
//   %wire_86 = &"net565" @WIRE(mode="straight") {#"I1554":7 %p19};
//   %p20 = (97, 77);
//   %wire_87 = &"net561" @WIRE(mode="straight") {%p20 #"M176":3};
//   %p21 = (97, 74);
//   %wire_88 = &"net561" @WIRE(mode="straight") {#"M91":3 %p21};
//   %wire_89 = &"net561" @WIRE(mode="straight") {%p21 %p20};
//   %wire_90 = &"net561" @WIRE(mode="straight") {#"I1556":4 %p21};
//   %wire_91 = &"net561" @WIRE(mode="straight") {#"I1555":4 #"I1556":4};
//   %wire_92 = &"net561" @WIRE(mode="straight") {#"I1554":4 #"I1555":4};
//   %wire_93 = &"net561" @WIRE(mode="straight") {#"I1553":4 #"I1554":4};
//   %p22 = (-6, 74);
//   %wire_94 = &"net561" @WIRE(mode="straight") {%p22 #"I1553":4};
//   %wire_95 = &"net561" @WIRE(mode="straight") {%p22 #"M88":1};
//   %wire_96 = &"net561" @WIRE(mode="straight") {#"I1552":1 %p22};
//   %p23 = (-26, 72);
//   %wire_97 = &"net561" @WIRE(mode="straight") {%p23 #"I1552":1};
//   %wire_98 = &"net561" @WIRE(mode="straight") {#"I1551":2 %p23};
//   %p24 = (97, 42);
//   %wire_99 = &"net559" @WIRE(mode="straight") {%p24 #"M174":3};
//   %p25 = (97, 39);
//   %wire_100 = &"net559" @WIRE(mode="straight") {%p25 %p24};
//   %wire_101 = &"net559" @WIRE(mode="straight") {#"M90":3 %p25};
//   %wire_102 = &"net559" @WIRE(mode="straight") {#"I1548":4 %p25};
//   %wire_103 = &"net559" @WIRE(mode="straight") {#"I1547":4 #"I1548":4};
//   %wire_104 = &"net559" @WIRE(mode="straight") {#"I1546":4 #"I1547":4};
//   %wire_105 = &"net559" @WIRE(mode="straight") {#"I1545":4 #"I1546":4};
//   %p26 = (-18, 39);
//   %wire_106 = &"net559" @WIRE(mode="straight") {%p26 #"I1545":4};
//   %wire_107 = &"net559" @WIRE(mode="straight") {%p26 #"M87":1};
//   %wire_108 = &"net559" @WIRE(mode="straight") {#"I1544":1 %p26};
//   %p27 = (-26, 37);
//   %wire_109 = &"net559" @WIRE(mode="straight") {%p27 #"I1544":1};
//   %wire_110 = &"net559" @WIRE(mode="straight") {#"I1543":2 %p27};
//   %p28 = (146, 86);
//   %wire_111 = &"net558" @WIRE(mode="straight") {#"I1576":6 %p28};
//   %p29 = (144, 86);
//   %wire_112 = &"net558" @WIRE(mode="straight") {%p29 %p28};
//   %wire_113 = &"net558" @WIRE(mode="straight") {#"I1576":3 %p29};
//   %p30 = (124, 86);
//   %wire_114 = &"net558" @WIRE(mode="straight") {%p30 %p29};
//   %wire_115 = &"net558" @WIRE(mode="straight") {#"I1575":7 %p30};
//   %p31 = (144, 51);
//   %wire_116 = &"net557" @WIRE(mode="straight") {#"I1571":3 %p31};
//   %p32 = (124, 53);
//   %wire_117 = &"net557" @WIRE(mode="straight") {%p31 %p32};
//   %wire_118 = &"net557" @WIRE(mode="straight") {#"I1572":7 %p32};
//   %p33 = (84, 51);
//   %wire_119 = &"net557" @WIRE(mode="straight") {%p32 %p33};
//   %wire_120 = &"net557" @WIRE(mode="straight") {#"I1548":6 %p33};
//   %p34 = (120, 51);
//   %wire_121 = &"net555" @WIRE(mode="straight") {#"I1572":3 %p34};
//   %p35 = (86, 53);
//   %wire_122 = &"net555" @WIRE(mode="straight") {%p34 %p35};
//   %wire_123 = &"net555" @WIRE(mode="straight") {#"I1548":7 %p35};
//   %p36 = (60, 51);
//   %wire_124 = &"net555" @WIRE(mode="straight") {%p36 %p35};
//   %wire_125 = &"net555" @WIRE(mode="straight") {#"I1547":6 %p36};
//   %p37 = (122, 86);
//   %wire_126 = &"net553" @WIRE(mode="straight") {#"I1575":6 %p37};
//   %p38 = (120, 86);
//   %wire_127 = &"net553" @WIRE(mode="straight") {%p38 %p37};
//   %wire_128 = &"net553" @WIRE(mode="straight") {#"I1575":3 %p38};
//   %p39 = (86, 86);
//   %wire_129 = &"net553" @WIRE(mode="straight") {%p39 %p38};
//   %wire_130 = &"net553" @WIRE(mode="straight") {#"I1556":7 %p39};
//   %wire_131 = &"net552" @WIRE(mode="straight") {#"M175":2 %marker_564};
//   %wire_132 = &"net552" @WIRE(mode="straight") {#"M173":2 #"M175":2};
//   %wire_133 = &"net552" @WIRE(mode="straight") {#"M171":2 #"M172":2};
//   %wire_134 = &"net552" @WIRE(mode="straight") {#"M172":2 #"M168":2};
//   %wire_135 = &"net552" @WIRE(mode="straight") {#"M170":2 #"M171":2};
//   %wire_136 = &"net552" @WIRE(mode="straight") {#"M169":2 #"M170":2};
//   %wire_137 = &"net552" @WIRE(mode="straight") {#"M167":2 #"M162":2};
//   %wire_138 = &"net552" @WIRE(mode="straight") {#"M162":2 #"M169":2};
//   %wire_139 = &"net552" @WIRE(mode="straight") {#"M166":2 #"M167":2};
//   %wire_140 = &"net552" @WIRE(mode="straight") {#"M165":2 #"M166":2};
//   %wire_141 = &"net552" @WIRE(mode="straight") {#"M164":2 #"M165":2};
//   %wire_142 = &"net552" @WIRE(mode="straight") {#"M155":2 #"M163":2};
//   %wire_143 = &"net552" @WIRE(mode="straight") {#"M163":2 #"M164":2};
//   %wire_144 = &"net552" @WIRE(mode="straight") {#"M161":2 #"M155":2};
//   %wire_145 = &"net552" @WIRE(mode="straight") {#"M160":2 #"M161":2};
//   %wire_146 = &"net552" @WIRE(mode="straight") {#"M159":2 #"M160":2};
//   %wire_147 = &"net552" @WIRE(mode="straight") {#"M168":2 #"M173":2};
//   %wire_148 = &"net552" @WIRE(mode="straight") {#"I1455":2 #"M151":2};
//   %wire_149 = &"net552" @WIRE(mode="straight") {#"M158":2 #"M159":2};
//   %wire_150 = &"net552" @WIRE(mode="straight") {#"M153":2 #"M154":2};
//   %wire_151 = &"net552" @WIRE(mode="straight") {#"M152":2 #"M153":2};
//   %wire_152 = &"net552" @WIRE(mode="straight") {#"M157":2 #"M158":2};
//   %wire_153 = &"net552" @WIRE(mode="straight") {#"M151":2 #"M152":2};
//   %wire_154 = &"net552" @WIRE(mode="straight") {#"M156":2 #"M157":2};
//   %wire_155 = &"net552" @WIRE(mode="straight") {#"M154":2 #"M156":2};
//   %wire_156 = &"net550" @WIRE(mode="straight") {#"M92":2 %marker_824};
//   %wire_157 = &"net550" @WIRE(mode="straight") {#"M89":2 #"M92":2};
//   %wire_158 = &"net550" @WIRE(mode="straight") {#"M66":2 #"M89":2};
//   %wire_159 = &"net550" @WIRE(mode="straight") {#"M65":2 #"M66":2};
//   %wire_160 = &"net550" @WIRE(mode="straight") {#"M62":2 #"M63":2};
//   %wire_161 = &"net550" @WIRE(mode="straight") {#"M63":2 #"M64":2};
//   %wire_162 = &"net550" @WIRE(mode="straight") {#"M64":2 #"M65":2};
//   %wire_163 = &"net550" @WIRE(mode="straight") {#"M60":2 #"M61":2};
//   %wire_164 = &"net550" @WIRE(mode="straight") {#"M61":2 #"M62":2};
//   %wire_165 = &"net550" @WIRE(mode="straight") {#"M57":2 #"M58":2};
//   %wire_166 = &"net550" @WIRE(mode="straight") {#"M58":2 #"M59":2};
//   %wire_167 = &"net550" @WIRE(mode="straight") {#"M59":2 #"M60":2};
//   %wire_168 = &"net550" @WIRE(mode="straight") {#"M55":2 #"M56":2};
//   %wire_169 = &"net550" @WIRE(mode="straight") {#"M56":2 #"M57":2};
//   %wire_170 = &"net550" @WIRE(mode="straight") {#"M52":2 #"M53":2};
//   %wire_171 = &"net550" @WIRE(mode="straight") {#"M53":2 #"M54":2};
//   %wire_172 = &"net550" @WIRE(mode="straight") {#"M54":2 #"M55":2};
//   %p40 = (212, -780);
//   %wire_173 = &"net550" @WIRE(mode="straight") {#"I1456":2 %p40};
//   %wire_174 = &"net550" @WIRE(mode="straight") {%p40 #"I1455":1};
//   %p41 = (208, -780);
//   %wire_175 = &"net550" @WIRE(mode="straight") {%p41 %p40};
//   %wire_176 = &"net550" @WIRE(mode="straight") {%p41 #"M49":2};
//   %wire_177 = &"net550" @WIRE(mode="straight") {#"M45":2 #"M46":2};
//   %wire_178 = &"net550" @WIRE(mode="straight") {#"M46":2 #"M47":2};
//   %wire_179 = &"net550" @WIRE(mode="straight") {#"M47":2 #"M48":2};
//   %wire_180 = &"net550" @WIRE(mode="straight") {#"M48":2 #"M50":2};
//   %wire_181 = &"net550" @WIRE(mode="straight") {#"M50":2 #"M51":2};
//   %wire_182 = &"net550" @WIRE(mode="straight") {#"M51":2 #"M52":2};
//   %wire_183 = &"net550" @WIRE(mode="straight") {#"M49":2 #"M45":2};
//   %p42 = (205, 42);
//   %wire_184 = &"net549" @WIRE(mode="straight") {%p42 #"M173":3};
//   %p43 = (205, 39);
//   %wire_185 = &"net549" @WIRE(mode="straight") {%p43 %p42};
//   %wire_186 = &"net549" @WIRE(mode="straight") {#"M89":3 %p43};
//   %wire_187 = &"net549" @WIRE(mode="straight") {#"I1569":4 %p43};
//   %wire_188 = &"net549" @WIRE(mode="straight") {#"I1570":4 #"I1569":4};
//   %wire_189 = &"net549" @WIRE(mode="straight") {#"I1571":4 #"I1570":4};
//   %wire_190 = &"net549" @WIRE(mode="straight") {#"I1572":4 #"I1571":4};
//   %p44 = (107, 39);
//   %wire_191 = &"net549" @WIRE(mode="straight") {%p44 #"I1572":4};
//   %wire_192 = &"net549" @WIRE(mode="straight") {%p44 #"M174":1};
//   %p45 = (107, 36);
//   %wire_193 = &"net549" @WIRE(mode="straight") {%p45 %p44};
//   %wire_194 = &"net549" @WIRE(mode="straight") {#"M90":1 %p45};
//   %p46 = (205, 77);
//   %wire_195 = &"net546" @WIRE(mode="straight") {%p46 #"M175":3};
//   %p47 = (205, 74);
//   %wire_196 = &"net546" @WIRE(mode="straight") {%p47 %p46};
//   %wire_197 = &"net546" @WIRE(mode="straight") {#"M92":3 %p47};
//   %wire_198 = &"net546" @WIRE(mode="straight") {#"I1578":4 %p47};
//   %wire_199 = &"net546" @WIRE(mode="straight") {#"I1577":4 #"I1578":4};
//   %wire_200 = &"net546" @WIRE(mode="straight") {#"I1576":4 #"I1577":4};
//   %wire_201 = &"net546" @WIRE(mode="straight") {#"I1575":4 #"I1576":4};
//   %p48 = (107, 74);
//   %wire_202 = &"net546" @WIRE(mode="straight") {%p48 #"I1575":4};
//   %wire_203 = &"net546" @WIRE(mode="straight") {%p48 #"M176":1};
//   %p49 = (107, 71);
//   %wire_204 = &"net546" @WIRE(mode="straight") {%p49 %p48};
//   %wire_205 = &"net546" @WIRE(mode="straight") {#"M91":1 %p49};
//   %p50 = (194, 86);
//   %wire_206 = &"net545" @WIRE(mode="straight") {#"I1578":6 %p50};
//   %p51 = (192, 86);
//   %wire_207 = &"net545" @WIRE(mode="straight") {%p51 %p50};
//   %wire_208 = &"net545" @WIRE(mode="straight") {#"I1578":3 %p51};
//   %p52 = (172, 86);
//   %wire_209 = &"net545" @WIRE(mode="straight") {%p52 %p51};
//   %wire_210 = &"net545" @WIRE(mode="straight") {#"I1577":7 %p52};
//   %p53 = (192, 51);
//   %wire_211 = &"net544" @WIRE(mode="straight") {#"I1569":3 %p53};
//   %p54 = (172, 53);
//   %wire_212 = &"net544" @WIRE(mode="straight") {%p53 %p54};
//   %wire_213 = &"net544" @WIRE(mode="straight") {#"I1570":7 %p54};
//   %p55 = (146, 51);
//   %wire_214 = &"net544" @WIRE(mode="straight") {%p55 %p54};
//   %wire_215 = &"net544" @WIRE(mode="straight") {#"I1571":6 %p55};
//   %p56 = (168, 51);
//   %wire_216 = &"net543" @WIRE(mode="straight") {#"I1570":3 %p56};
//   %p57 = (148, 53);
//   %wire_217 = &"net543" @WIRE(mode="straight") {%p56 %p57};
//   %wire_218 = &"net543" @WIRE(mode="straight") {#"I1571":7 %p57};
//   %p58 = (122, 51);
//   %wire_219 = &"net543" @WIRE(mode="straight") {%p58 %p57};
//   %wire_220 = &"net543" @WIRE(mode="straight") {#"I1572":6 %p58};
//   %p59 = (170, 86);
//   %wire_221 = &"net542" @WIRE(mode="straight") {#"I1577":6 %p59};
//   %p60 = (168, 86);
//   %wire_222 = &"net542" @WIRE(mode="straight") {%p60 %p59};
//   %wire_223 = &"net542" @WIRE(mode="straight") {#"I1577":3 %p60};
//   %p61 = (148, 86);
//   %wire_224 = &"net542" @WIRE(mode="straight") {%p61 %p60};
//   %wire_225 = &"net542" @WIRE(mode="straight") {#"I1576":7 %p61};
//   %p62 = (278, 86);
//   %wire_226 = &"net541" @WIRE(mode="straight") {#"I1573":6 %p62};
//   %p63 = (276, 86);
//   %wire_227 = &"net541" @WIRE(mode="straight") {%p63 %p62};
//   %wire_228 = &"net541" @WIRE(mode="straight") {#"I1573":3 %p63};
//   %p64 = (256, 86);
//   %wire_229 = &"net541" @WIRE(mode="straight") {%p64 %p63};
//   %wire_230 = &"net541" @WIRE(mode="straight") {#"I1579":7 %p64};
//   %p65 = (254, 86);
//   %wire_231 = &"net540" @WIRE(mode="straight") {#"I1579":6 %p65};
//   %p66 = (252, 86);
//   %wire_232 = &"net540" @WIRE(mode="straight") {%p66 %p65};
//   %wire_233 = &"net540" @WIRE(mode="straight") {#"I1579":3 %p66};
//   %p67 = (232, 86);
//   %wire_234 = &"net540" @WIRE(mode="straight") {%p67 %p66};
//   %wire_235 = &"net540" @WIRE(mode="straight") {#"I1574":7 %p67};
//   %p68 = (252, 51);
//   %wire_236 = &"net537" @WIRE(mode="straight") {#"I1567":3 %p68};
//   %p69 = (232, 53);
//   %wire_237 = &"net537" @WIRE(mode="straight") {%p68 %p69};
//   %wire_238 = &"net537" @WIRE(mode="straight") {#"I1568":7 %p69};
//   %p70 = (194, 51);
//   %wire_239 = &"net537" @WIRE(mode="straight") {%p70 %p69};
//   %wire_240 = &"net537" @WIRE(mode="straight") {#"I1569":6 %p70};
//   %p71 = (276, 51);
//   %wire_241 = &"net536" @WIRE(mode="straight") {#"I1566":3 %p71};
//   %p72 = (256, 53);
//   %wire_242 = &"net536" @WIRE(mode="straight") {%p71 %p72};
//   %wire_243 = &"net536" @WIRE(mode="straight") {#"I1567":7 %p72};
//   %p73 = (230, 51);
//   %wire_244 = &"net536" @WIRE(mode="straight") {%p73 %p72};
//   %wire_245 = &"net536" @WIRE(mode="straight") {#"I1568":6 %p73};
//   %p74 = (230, 86);
//   %wire_246 = &"net531" @WIRE(mode="straight") {#"I1574":6 %p74};
//   %p75 = (228, 86);
//   %wire_247 = &"net531" @WIRE(mode="straight") {%p75 %p74};
//   %wire_248 = &"net531" @WIRE(mode="straight") {#"I1574":3 %p75};
//   %p76 = (196, 86);
//   %wire_249 = &"net531" @WIRE(mode="straight") {%p76 %p75};
//   %wire_250 = &"net531" @WIRE(mode="straight") {#"I1578":7 %p76};
//   %p77 = (228, 51);
//   %wire_251 = &"net530" @WIRE(mode="straight") {#"I1568":3 %p77};
//   %p78 = (196, 53);
//   %wire_252 = &"net530" @WIRE(mode="straight") {%p77 %p78};
//   %wire_253 = &"net530" @WIRE(mode="straight") {#"I1569":7 %p78};
//   %p79 = (170, 51);
//   %wire_254 = &"net530" @WIRE(mode="straight") {%p79 %p78};
//   %wire_255 = &"net530" @WIRE(mode="straight") {#"I1570":6 %p79};
//   %p80 = (350, 86);
//   %wire_256 = &"net529" @WIRE(mode="straight") {#"I1605":6 %p80};
//   %p81 = (348, 86);
//   %wire_257 = &"net529" @WIRE(mode="straight") {%p81 %p80};
//   %wire_258 = &"net529" @WIRE(mode="straight") {#"I1605":3 %p81};
//   %p82 = (328, 86);
//   %wire_259 = &"net529" @WIRE(mode="straight") {%p82 %p81};
//   %wire_260 = &"net529" @WIRE(mode="straight") {#"I1604":7 %p82};
//   %p83 = (326, 86);
//   %wire_261 = &"net528" @WIRE(mode="straight") {#"I1604":6 %p83};
//   %p84 = (324, 86);
//   %wire_262 = &"net528" @WIRE(mode="straight") {%p84 %p83};
//   %wire_263 = &"net528" @WIRE(mode="straight") {#"I1604":3 %p84};
//   %p85 = (304, 86);
//   %wire_264 = &"net528" @WIRE(mode="straight") {%p85 %p84};
//   %wire_265 = &"net528" @WIRE(mode="straight") {#"I1603":7 %p85};
//   %p86 = (324, 51);
//   %wire_266 = &"net527" @WIRE(mode="straight") {#"I1600":3 %p86};
//   %p87 = (304, 53);
//   %wire_267 = &"net527" @WIRE(mode="straight") {%p86 %p87};
//   %wire_268 = &"net527" @WIRE(mode="straight") {#"I1601":7 %p87};
//   %p88 = (278, 51);
//   %wire_269 = &"net527" @WIRE(mode="straight") {%p88 %p87};
//   %wire_270 = &"net527" @WIRE(mode="straight") {#"I1566":6 %p88};
//   %p89 = (348, 51);
//   %wire_271 = &"net526" @WIRE(mode="straight") {#"I1599":3 %p89};
//   %p90 = (328, 53);
//   %wire_272 = &"net526" @WIRE(mode="straight") {%p89 %p90};
//   %wire_273 = &"net526" @WIRE(mode="straight") {#"I1600":7 %p90};
//   %p91 = (302, 51);
//   %wire_274 = &"net526" @WIRE(mode="straight") {%p91 %p90};
//   %wire_275 = &"net526" @WIRE(mode="straight") {#"I1601":6 %p91};
//   %p92 = (302, 86);
//   %wire_276 = &"net525" @WIRE(mode="straight") {#"I1603":6 %p92};
//   %p93 = (300, 86);
//   %wire_277 = &"net525" @WIRE(mode="straight") {%p93 %p92};
//   %wire_278 = &"net525" @WIRE(mode="straight") {#"I1603":3 %p93};
//   %p94 = (280, 86);
//   %wire_279 = &"net525" @WIRE(mode="straight") {%p94 %p93};
//   %wire_280 = &"net525" @WIRE(mode="straight") {#"I1573":7 %p94};
//   %p95 = (300, 51);
//   %wire_281 = &"net524" @WIRE(mode="straight") {#"I1601":3 %p95};
//   %p96 = (280, 53);
//   %wire_282 = &"net524" @WIRE(mode="straight") {%p95 %p96};
//   %wire_283 = &"net524" @WIRE(mode="straight") {#"I1566":7 %p96};
//   %p97 = (254, 51);
//   %wire_284 = &"net524" @WIRE(mode="straight") {%p97 %p96};
//   %wire_285 = &"net524" @WIRE(mode="straight") {#"I1567":6 %p97};
//   %p98 = (398, 86);
//   %wire_286 = &"net523" @WIRE(mode="straight") {#"I1607":6 %p98};
//   %p99 = (396, 86);
//   %wire_287 = &"net523" @WIRE(mode="straight") {%p99 %p98};
//   %wire_288 = &"net523" @WIRE(mode="straight") {#"I1607":3 %p99};
//   %p100 = (376, 86);
//   %wire_289 = &"net523" @WIRE(mode="straight") {%p100 %p99};
//   %wire_290 = &"net523" @WIRE(mode="straight") {#"I1606":7 %p100};
//   %p101 = (396, 51);
//   %wire_291 = &"net522" @WIRE(mode="straight") {#"I1597":3 %p101};
//   %p102 = (376, 53);
//   %wire_292 = &"net522" @WIRE(mode="straight") {%p101 %p102};
//   %wire_293 = &"net522" @WIRE(mode="straight") {#"I1598":7 %p102};
//   %p103 = (350, 51);
//   %wire_294 = &"net522" @WIRE(mode="straight") {%p103 %p102};
//   %wire_295 = &"net522" @WIRE(mode="straight") {#"I1599":6 %p103};
//   %p104 = (400, 53);
//   %wire_296 = &"net521" @WIRE(mode="straight") {#"I1597":7 %p104};
//   %p105 = (374, 51);
//   %wire_297 = &"net521" @WIRE(mode="straight") {%p105 %p104};
//   %wire_298 = &"net521" @WIRE(mode="straight") {#"I1598":6 %p105};
//   %p106 = (372, 51);
//   %wire_299 = &"net520" @WIRE(mode="straight") {#"I1598":3 %p106};
//   %p107 = (352, 53);
//   %wire_300 = &"net520" @WIRE(mode="straight") {%p106 %p107};
//   %wire_301 = &"net520" @WIRE(mode="straight") {#"I1599":7 %p107};
//   %p108 = (326, 51);
//   %wire_302 = &"net520" @WIRE(mode="straight") {%p108 %p107};
//   %wire_303 = &"net520" @WIRE(mode="straight") {#"I1600":6 %p108};
//   %p109 = (394, 90);
//   %wire_304 = &"net519" @WIRE(mode="straight") {#"I1607":9 %p109};
//   %p110 = (370, 90);
//   %wire_305 = &"net519" @WIRE(mode="straight") {%p110 %p109};
//   %wire_306 = &"net519" @WIRE(mode="straight") {#"I1606":9 %p110};
//   %p111 = (346, 90);
//   %wire_307 = &"net519" @WIRE(mode="straight") {%p111 %p110};
//   %wire_308 = &"net519" @WIRE(mode="straight") {#"I1605":9 %p111};
//   %p112 = (322, 90);
//   %wire_309 = &"net519" @WIRE(mode="straight") {%p112 %p111};
//   %wire_310 = &"net519" @WIRE(mode="straight") {#"I1604":9 %p112};
//   %p113 = (298, 90);
//   %wire_311 = &"net519" @WIRE(mode="straight") {%p113 %p112};
//   %wire_312 = &"net519" @WIRE(mode="straight") {#"I1603":9 %p113};
//   %p114 = (274, 90);
//   %wire_313 = &"net519" @WIRE(mode="straight") {%p114 %p113};
//   %wire_314 = &"net519" @WIRE(mode="straight") {#"I1573":9 %p114};
//   %p115 = (250, 90);
//   %wire_315 = &"net519" @WIRE(mode="straight") {%p115 %p114};
//   %wire_316 = &"net519" @WIRE(mode="straight") {#"I1579":9 %p115};
//   %p116 = (226, 90);
//   %wire_317 = &"net519" @WIRE(mode="straight") {%p116 %p115};
//   %wire_318 = &"net519" @WIRE(mode="straight") {#"I1574":9 %p116};
//   %p117 = (190, 90);
//   %wire_319 = &"net519" @WIRE(mode="straight") {%p117 %p116};
//   %wire_320 = &"net519" @WIRE(mode="straight") {#"I1578":9 %p117};
//   %p118 = (166, 90);
//   %wire_321 = &"net519" @WIRE(mode="straight") {%p118 %p117};
//   %wire_322 = &"net519" @WIRE(mode="straight") {#"I1577":9 %p118};
//   %p119 = (142, 90);
//   %wire_323 = &"net519" @WIRE(mode="straight") {%p119 %p118};
//   %wire_324 = &"net519" @WIRE(mode="straight") {#"I1576":9 %p119};
//   %p120 = (118, 90);
//   %wire_325 = &"net519" @WIRE(mode="straight") {%p120 %p119};
//   %wire_326 = &"net519" @WIRE(mode="straight") {#"I1575":9 %p120};
//   %p121 = (80, 90);
//   %wire_327 = &"net519" @WIRE(mode="straight") {%p121 %p120};
//   %wire_328 = &"net519" @WIRE(mode="straight") {#"I1556":9 %p121};
//   %p122 = (56, 90);
//   %wire_329 = &"net519" @WIRE(mode="straight") {%p122 %p121};
//   %wire_330 = &"net519" @WIRE(mode="straight") {#"I1555":9 %p122};
//   %p123 = (32, 90);
//   %wire_331 = &"net519" @WIRE(mode="straight") {%p123 %p122};
//   %wire_332 = &"net519" @WIRE(mode="straight") {#"I1554":9 %p123};
//   %p124 = (10, 90);
//   %wire_333 = &"net519" @WIRE(mode="straight") {%p124 %p123};
//   %wire_334 = &"net519" @WIRE(mode="straight") {#"I1553":3 %p124};
//   %p125 = (8, 90);
//   %wire_335 = &"net519" @WIRE(mode="straight") {%p125 %p124};
//   %wire_336 = &"net519" @WIRE(mode="straight") {#"I1553":9 %p125};
//   %p126 = (394, 55);
//   %wire_337 = &"net512" @WIRE(mode="straight") {#"I1597":9 %p126};
//   %p127 = (370, 55);
//   %wire_338 = &"net512" @WIRE(mode="straight") {%p127 %p126};
//   %wire_339 = &"net512" @WIRE(mode="straight") {#"I1598":9 %p127};
//   %p128 = (346, 55);
//   %wire_340 = &"net512" @WIRE(mode="straight") {%p128 %p127};
//   %wire_341 = &"net512" @WIRE(mode="straight") {#"I1599":9 %p128};
//   %p129 = (322, 55);
//   %wire_342 = &"net512" @WIRE(mode="straight") {%p129 %p128};
//   %wire_343 = &"net512" @WIRE(mode="straight") {#"I1600":9 %p129};
//   %p130 = (298, 55);
//   %wire_344 = &"net512" @WIRE(mode="straight") {%p130 %p129};
//   %wire_345 = &"net512" @WIRE(mode="straight") {#"I1601":9 %p130};
//   %p131 = (274, 55);
//   %wire_346 = &"net512" @WIRE(mode="straight") {%p131 %p130};
//   %wire_347 = &"net512" @WIRE(mode="straight") {#"I1566":9 %p131};
//   %p132 = (250, 55);
//   %wire_348 = &"net512" @WIRE(mode="straight") {%p132 %p131};
//   %wire_349 = &"net512" @WIRE(mode="straight") {#"I1567":9 %p132};
//   %p133 = (226, 55);
//   %wire_350 = &"net512" @WIRE(mode="straight") {%p133 %p132};
//   %wire_351 = &"net512" @WIRE(mode="straight") {#"I1568":9 %p133};
//   %p134 = (190, 55);
//   %wire_352 = &"net512" @WIRE(mode="straight") {%p134 %p133};
//   %wire_353 = &"net512" @WIRE(mode="straight") {#"I1569":9 %p134};
//   %p135 = (166, 55);
//   %wire_354 = &"net512" @WIRE(mode="straight") {%p135 %p134};
//   %wire_355 = &"net512" @WIRE(mode="straight") {#"I1570":9 %p135};
//   %p136 = (142, 55);
//   %wire_356 = &"net512" @WIRE(mode="straight") {%p136 %p135};
//   %wire_357 = &"net512" @WIRE(mode="straight") {#"I1571":9 %p136};
//   %p137 = (118, 55);
//   %wire_358 = &"net512" @WIRE(mode="straight") {%p137 %p136};
//   %wire_359 = &"net512" @WIRE(mode="straight") {#"I1572":9 %p137};
//   %p138 = (80, 55);
//   %wire_360 = &"net512" @WIRE(mode="straight") {%p138 %p137};
//   %wire_361 = &"net512" @WIRE(mode="straight") {#"I1548":9 %p138};
//   %p139 = (56, 55);
//   %wire_362 = &"net512" @WIRE(mode="straight") {%p139 %p138};
//   %wire_363 = &"net512" @WIRE(mode="straight") {#"I1547":9 %p139};
//   %p140 = (32, 55);
//   %wire_364 = &"net512" @WIRE(mode="straight") {%p140 %p139};
//   %wire_365 = &"net512" @WIRE(mode="straight") {#"I1546":9 %p140};
//   %p141 = (10, 55);
//   %wire_366 = &"net512" @WIRE(mode="straight") {%p141 %p140};
//   %wire_367 = &"net512" @WIRE(mode="straight") {#"I1545":3 %p141};
//   %p142 = (8, 55);
//   %wire_368 = &"net512" @WIRE(mode="straight") {%p142 %p141};
//   %wire_369 = &"net512" @WIRE(mode="straight") {#"I1545":9 %p142};
//   %wire_370 = &"net511" @WIRE(mode="straight") {#"I1606":4 #"I1607":4};
//   %wire_371 = &"net511" @WIRE(mode="straight") {#"I1605":4 #"I1606":4};
//   %wire_372 = &"net511" @WIRE(mode="straight") {#"I1604":4 #"I1605":4};
//   %wire_373 = &"net511" @WIRE(mode="straight") {#"I1603":4 #"I1604":4};
//   %wire_374 = &"net511" @WIRE(mode="straight") {#"I1573":4 #"I1603":4};
//   %wire_375 = &"net511" @WIRE(mode="straight") {#"I1579":4 #"I1573":4};
//   %wire_376 = &"net511" @WIRE(mode="straight") {#"I1574":4 #"I1579":4};
//   %p143 = (215, 74);
//   %wire_377 = &"net511" @WIRE(mode="straight") {%p143 #"I1574":4};
//   %p144 = (215, 71);
//   %wire_378 = &"net511" @WIRE(mode="straight") {%p144 %p143};
//   %wire_379 = &"net511" @WIRE(mode="straight") {%p143 #"M175":1};
//   %wire_380 = &"net511" @WIRE(mode="straight") {#"M92":1 %p144};
//   %wire_381 = &"net510" @WIRE(mode="straight") {#"I1598":4 #"I1597":4};
//   %wire_382 = &"net510" @WIRE(mode="straight") {#"I1599":4 #"I1598":4};
//   %wire_383 = &"net510" @WIRE(mode="straight") {#"I1600":4 #"I1599":4};
//   %wire_384 = &"net510" @WIRE(mode="straight") {#"I1601":4 #"I1600":4};
//   %wire_385 = &"net510" @WIRE(mode="straight") {#"I1566":4 #"I1601":4};
//   %wire_386 = &"net510" @WIRE(mode="straight") {#"I1567":4 #"I1566":4};
//   %wire_387 = &"net510" @WIRE(mode="straight") {#"I1568":4 #"I1567":4};
//   %p145 = (215, 39);
//   %wire_388 = &"net510" @WIRE(mode="straight") {%p145 #"I1568":4};
//   %wire_389 = &"net510" @WIRE(mode="straight") {%p145 #"M173":1};
//   %p146 = (215, 36);
//   %wire_390 = &"net510" @WIRE(mode="straight") {%p146 %p145};
//   %wire_391 = &"net510" @WIRE(mode="straight") {#"M89":1 %p146};
//   %p147 = (374, 86);
//   %wire_392 = &"net509" @WIRE(mode="straight") {#"I1606":6 %p147};
//   %p148 = (372, 86);
//   %wire_393 = &"net509" @WIRE(mode="straight") {%p148 %p147};
//   %wire_394 = &"net509" @WIRE(mode="straight") {#"I1606":3 %p148};
//   %p149 = (352, 86);
//   %wire_395 = &"net509" @WIRE(mode="straight") {%p149 %p148};
//   %wire_396 = &"net509" @WIRE(mode="straight") {#"I1605":7 %p149};
//   %p150 = (400, 27);
//   %wire_397 = &"net508" @WIRE(mode="straight") {%p150 #"I1596":2};
//   %wire_398 = &"net508" @WIRE(mode="straight") {%p150 #"I1597":5};
//   %p151 = (376, 27);
//   %wire_399 = &"net508" @WIRE(mode="straight") {%p151 %p150};
//   %wire_400 = &"net508" @WIRE(mode="straight") {%p151 #"I1598":5};
//   %p152 = (352, 27);
//   %wire_401 = &"net508" @WIRE(mode="straight") {%p152 %p151};
//   %wire_402 = &"net508" @WIRE(mode="straight") {%p152 #"I1599":5};
//   %p153 = (328, 27);
//   %wire_403 = &"net508" @WIRE(mode="straight") {%p153 %p152};
//   %wire_404 = &"net508" @WIRE(mode="straight") {%p153 #"I1600":5};
//   %p154 = (304, 27);
//   %wire_405 = &"net508" @WIRE(mode="straight") {%p154 %p153};
//   %wire_406 = &"net508" @WIRE(mode="straight") {%p154 #"I1601":5};
//   %p155 = (280, 27);
//   %wire_407 = &"net508" @WIRE(mode="straight") {%p155 %p154};
//   %wire_408 = &"net508" @WIRE(mode="straight") {%p155 #"I1566":5};
//   %p156 = (256, 27);
//   %wire_409 = &"net508" @WIRE(mode="straight") {%p156 %p155};
//   %wire_410 = &"net508" @WIRE(mode="straight") {%p156 #"I1567":5};
//   %p157 = (232, 27);
//   %wire_411 = &"net508" @WIRE(mode="straight") {%p157 %p156};
//   %wire_412 = &"net508" @WIRE(mode="straight") {%p157 #"I1568":5};
//   %p158 = (196, 27);
//   %wire_413 = &"net508" @WIRE(mode="straight") {%p158 %p157};
//   %wire_414 = &"net508" @WIRE(mode="straight") {%p158 #"I1569":5};
//   %p159 = (172, 27);
//   %wire_415 = &"net508" @WIRE(mode="straight") {%p159 %p158};
//   %wire_416 = &"net508" @WIRE(mode="straight") {%p159 #"I1570":5};
//   %p160 = (148, 27);
//   %wire_417 = &"net508" @WIRE(mode="straight") {%p160 %p159};
//   %wire_418 = &"net508" @WIRE(mode="straight") {%p160 #"I1571":5};
//   %p161 = (124, 27);
//   %wire_419 = &"net508" @WIRE(mode="straight") {%p161 %p160};
//   %wire_420 = &"net508" @WIRE(mode="straight") {%p161 #"I1572":5};
//   %p162 = (86, 27);
//   %wire_421 = &"net508" @WIRE(mode="straight") {%p162 %p161};
//   %wire_422 = &"net508" @WIRE(mode="straight") {%p162 #"I1548":5};
//   %p163 = (62, 27);
//   %wire_423 = &"net508" @WIRE(mode="straight") {%p163 %p162};
//   %wire_424 = &"net508" @WIRE(mode="straight") {%p163 #"I1547":5};
//   %p164 = (38, 27);
//   %wire_425 = &"net508" @WIRE(mode="straight") {%p164 %p163};
//   %wire_426 = &"net508" @WIRE(mode="straight") {%p164 #"I1546":5};
//   %p165 = (14, 27);
//   %wire_427 = &"net508" @WIRE(mode="straight") {%p165 %p164};
//   %wire_428 = &"net508" @WIRE(mode="straight") {%p165 #"I1545":5};
//   %p166 = (-4, 27);
//   %wire_429 = &"net508" @WIRE(mode="straight") {%p166 %p165};
//   %wire_430 = &"net508" @WIRE(mode="straight") {%p166 #"I1549":2};
//   %p167 = (400, 62);
//   %wire_431 = &"net460" @WIRE(mode="straight") {%p167 #"I1602":2};
//   %wire_432 = &"net460" @WIRE(mode="straight") {%p167 #"I1607":5};
//   %p168 = (376, 62);
//   %wire_433 = &"net460" @WIRE(mode="straight") {%p168 %p167};
//   %wire_434 = &"net460" @WIRE(mode="straight") {%p168 #"I1606":5};
//   %p169 = (352, 62);
//   %wire_435 = &"net460" @WIRE(mode="straight") {%p169 %p168};
//   %wire_436 = &"net460" @WIRE(mode="straight") {%p169 #"I1605":5};
//   %p170 = (328, 62);
//   %wire_437 = &"net460" @WIRE(mode="straight") {%p170 %p169};
//   %wire_438 = &"net460" @WIRE(mode="straight") {%p170 #"I1604":5};
//   %p171 = (304, 62);
//   %wire_439 = &"net460" @WIRE(mode="straight") {%p171 %p170};
//   %wire_440 = &"net460" @WIRE(mode="straight") {%p171 #"I1603":5};
//   %p172 = (280, 62);
//   %wire_441 = &"net460" @WIRE(mode="straight") {%p172 %p171};
//   %wire_442 = &"net460" @WIRE(mode="straight") {%p172 #"I1573":5};
//   %p173 = (256, 62);
//   %wire_443 = &"net460" @WIRE(mode="straight") {%p173 %p172};
//   %wire_444 = &"net460" @WIRE(mode="straight") {%p173 #"I1579":5};
//   %p174 = (232, 62);
//   %wire_445 = &"net460" @WIRE(mode="straight") {%p174 %p173};
//   %wire_446 = &"net460" @WIRE(mode="straight") {%p174 #"I1574":5};
//   %p175 = (196, 62);
//   %wire_447 = &"net460" @WIRE(mode="straight") {%p175 %p174};
//   %wire_448 = &"net460" @WIRE(mode="straight") {%p175 #"I1578":5};
//   %p176 = (172, 62);
//   %wire_449 = &"net460" @WIRE(mode="straight") {%p176 %p175};
//   %wire_450 = &"net460" @WIRE(mode="straight") {%p176 #"I1577":5};
//   %p177 = (148, 62);
//   %wire_451 = &"net460" @WIRE(mode="straight") {%p177 %p176};
//   %wire_452 = &"net460" @WIRE(mode="straight") {%p177 #"I1576":5};
//   %p178 = (124, 62);
//   %wire_453 = &"net460" @WIRE(mode="straight") {%p178 %p177};
//   %wire_454 = &"net460" @WIRE(mode="straight") {%p178 #"I1575":5};
//   %p179 = (86, 62);
//   %wire_455 = &"net460" @WIRE(mode="straight") {%p179 %p178};
//   %wire_456 = &"net460" @WIRE(mode="straight") {%p179 #"I1556":5};
//   %p180 = (62, 62);
//   %wire_457 = &"net460" @WIRE(mode="straight") {%p180 %p179};
//   %wire_458 = &"net460" @WIRE(mode="straight") {%p180 #"I1555":5};
//   %p181 = (38, 62);
//   %wire_459 = &"net460" @WIRE(mode="straight") {%p181 %p180};
//   %wire_460 = &"net460" @WIRE(mode="straight") {%p181 #"I1554":5};
//   %p182 = (14, 62);
//   %wire_461 = &"net460" @WIRE(mode="straight") {%p182 %p181};
//   %wire_462 = &"net460" @WIRE(mode="straight") {%p182 #"I1553":5};
//   %p183 = (-20, 62);
//   %wire_463 = &"net460" @WIRE(mode="straight") {%p183 %p182};
//   %wire_464 = &"net460" @WIRE(mode="straight") {%p183 #"I1557":2};
//   %p184 = (400, 86);
//   %wire_465 = &"net337" @WIRE(mode="straight") {%p184 #"I1608":1};
//   %wire_466 = &"net337" @WIRE(mode="straight") {#"I1607":7 %p184};
//   %p185 = (447, -776);
//   %wire_467 = &"RST" @WIRE(mode="straight") {#"I1637":1 %p185};
//   %wire_467 @TEXT("RST", size=1, halign="middle", valign="baseline") => @PLACE(444, -775.3);
//   %p186 = (480, -743);
//   %wire_468 = &"SCKI" @WIRE(mode="straight") {#"I130":1 %p186};
//   %wire_468 @TEXT("SCKI", size=1, halign="middle", valign="baseline") => @PLACE(477, -742.3);
//   %wire_469 = &"net371" @WIRE(mode="straight") {#"I108":1 #"I130":2};
//   %p187 = (444, -759);
//   %p188 = (444, -743);
//   %wire_470 = &"net116" @WIRE(mode="straight") {%p187 %p188};
//   %wire_471 = &"net116" @WIRE(mode="straight") {#"I1224":1 %p188};
//   %wire_472 = &"net116" @WIRE(mode="straight") {%p187 #"I109":1};
//   %wire_473 = &"net116" @WIRE(mode="straight") {%p188 #"I108":2};
//   %p189 = (29, -760);
//   %p190 = (53, -760);
//   %wire_474 = &"net69" @WIRE(mode="straight") {%p189 %p190};
//   %p191 = (77, -760);
//   %wire_475 = &"net69" @WIRE(mode="straight") {%p190 %p191};
//   %p192 = (115, -760);
//   %wire_476 = &"net69" @WIRE(mode="straight") {%p191 %p192};
//   %p193 = (187, -760);
//   %p194 = (223, -760);
//   %wire_477 = &"net69" @WIRE(mode="straight") {%p193 %p194};
//   %p195 = (367, -760);
//   %wire_478 = &"net69" @WIRE(mode="straight") {%p195 #"I1220":2};
//   %p196 = (391, -760);
//   %wire_479 = &"net69" @WIRE(mode="straight") {%p196 #"I1215":2};
//   %wire_480 = &"net69" @WIRE(mode="straight") {%p196 #"I1223":2};
//   %p197 = (319, -760);
//   %wire_481 = &"net69" @WIRE(mode="straight") {%p197 #"I1213":2};
//   %p198 = (343, -760);
//   %wire_482 = &"net69" @WIRE(mode="straight") {%p198 #"I1218":2};
//   %p199 = (247, -760);
//   %wire_483 = &"net69" @WIRE(mode="straight") {%p199 #"I1207":2};
//   %wire_484 = &"net69" @WIRE(mode="straight") {%p194 #"I1212":2};
//   %p200 = (295, -760);
//   %wire_485 = &"net69" @WIRE(mode="straight") {%p200 #"I1210":2};
//   %p201 = (271, -760);
//   %wire_486 = &"net69" @WIRE(mode="straight") {%p201 #"I1205":2};
//   %p202 = (163, -760);
//   %wire_487 = &"net69" @WIRE(mode="straight") {%p202 #"I1204":2};
//   %wire_488 = &"net69" @WIRE(mode="straight") {%p193 #"I1199":2};
//   %p203 = (5, -760);
//   %wire_489 = &"net69" @WIRE(mode="straight") {%p203 #"I1189":2};
//   %wire_490 = &"net69" @WIRE(mode="straight") {%p191 #"I1195":2};
//   %wire_491 = &"net69" @WIRE(mode="straight") {%p198 %p195};
//   %wire_492 = &"net69" @WIRE(mode="straight") {%p197 %p198};
//   %wire_493 = &"net69" @WIRE(mode="straight") {%p190 #"I1193":2};
//   %wire_494 = &"net69" @WIRE(mode="straight") {%p200 %p197};
//   %wire_495 = &"net69" @WIRE(mode="straight") {%p201 %p200};
//   %wire_496 = &"net69" @WIRE(mode="straight") {%p189 #"I1191":2};
//   %wire_497 = &"net69" @WIRE(mode="straight") {%p199 %p201};
//   %wire_498 = &"net69" @WIRE(mode="straight") {%p192 #"I1197":2};
//   %wire_499 = &"net69" @WIRE(mode="straight") {%p195 %p196};
//   %p204 = (139, -760);
//   %wire_500 = &"net69" @WIRE(mode="straight") {%p204 #"I1202":2};
//   %wire_501 = &"net69" @WIRE(mode="straight") {%p203 %p189};
//   %wire_502 = &"net69" @WIRE(mode="straight") {%p202 %p193};
//   %wire_503 = &"net69" @WIRE(mode="straight") {%p204 %p202};
//   %wire_504 = &"net69" @WIRE(mode="straight") {%p194 %p199};
//   %wire_505 = &"net69" @WIRE(mode="straight") {%p192 %p204};
//   %p205 = (463, -759);
//   %wire_506 = &"SCKO" @WIRE(mode="straight") {#"I109":2 %p205};
//   %wire_506 @TEXT("SCKO", size=1, halign="middle", valign="baseline") => @PLACE(461, -758.3);
//   %p206 = (12, 83);
//   %wire_507 = &"net2422" @WIRE(mode="straight") {#"I1553":6 %p206};
//   %wire_508 = &"net2422" @WIRE(mode="straight") {#"M88":2 %p206};
//   %wire_509 = &"net2422" @WIRE(mode="straight") {#"I1557":3 #"M88":2};
//   %wire_510 = &"net2411" @WIRE(mode="straight") {#"I1549":3 #"M87":2};
//   %p207 = (-23, 48);
//   %wire_511 = &"net2411" @WIRE(mode="straight") {%p207 #"M87":2};
//   %p208 = (-23, 85);
//   %wire_512 = &"net2411" @WIRE(mode="straight") {%p208 #"I1557":1};
//   %wire_513 = &"net2411" @WIRE(mode="straight") {%p207 %p208};
//   %p209 = (-68, 38);
//   %wire_514 = &"OUT_22" @WIRE(mode="straight") {%p209 #"I1542":2};
//   %wire_514 @TEXT("OUT\_22", size=1, halign="middle", valign="baseline") => @PLACE(-65, 38.7);
//   %p210 = (-68, 73);
//   %wire_515 = &"OUT_23" @WIRE(mode="straight") {%p210 #"I1550":2};
//   %wire_515 @TEXT("OUT\_23", size=1, halign="middle", valign="baseline") => @PLACE(-65, 73.7);
//   %p211 = (252, 16);
//   %p212 = (254, 16);
//   %wire_516 = &"net1" @WIRE(mode="straight") {%p211 %p212};
//   %wire_517 = &"net1" @WIRE(mode="straight") {#"I613":6 %p212};
//   %p213 = (232, 16);
//   %wire_518 = &"net1" @WIRE(mode="straight") {%p213 %p211};
//   %wire_519 = &"net1" @WIRE(mode="straight") {#"I591":7 %p213};
//   %wire_520 = &"net1" @WIRE(mode="straight") {#"I613":3 %p211};
//   %p214 = (215, 4);
//   %wire_521 = &"net4" @WIRE(mode="straight") {%p214 #"I591":4};
//   %wire_522 = &"net4" @WIRE(mode="straight") {%p214 #"M168":1};
//   %p215 = (215, 1);
//   %wire_523 = &"net4" @WIRE(mode="straight") {%p215 %p214};
//   %wire_524 = &"net4" @WIRE(mode="straight") {#"M66":1 %p215};
//   %wire_525 = &"net4" @WIRE(mode="straight") {#"I635":4 #"I657":4};
//   %wire_526 = &"net4" @WIRE(mode="straight") {#"I701":4 #"I723":4};
//   %wire_527 = &"net4" @WIRE(mode="straight") {#"I613":4 #"I635":4};
//   %wire_528 = &"net4" @WIRE(mode="straight") {#"I723":4 #"I745":4};
//   %wire_529 = &"net4" @WIRE(mode="straight") {#"I679":4 #"I701":4};
//   %wire_530 = &"net4" @WIRE(mode="straight") {#"I591":4 #"I613":4};
//   %wire_531 = &"net4" @WIRE(mode="straight") {#"I657":4 #"I679":4};
//   %p216 = (14, -8);
//   %p217 = (38, -8);
//   %wire_532 = &"net9" @WIRE(mode="straight") {%p216 %p217};
//   %p218 = (196, -8);
//   %p219 = (232, -8);
//   %wire_533 = &"net9" @WIRE(mode="straight") {%p218 %p219};
//   %p220 = (-20, -8);
//   %wire_534 = &"net9" @WIRE(mode="straight") {%p220 %p216};
//   %wire_535 = &"net9" @WIRE(mode="straight") {%p220 #"I1460":2};
//   %p221 = (148, -8);
//   %p222 = (172, -8);
//   %wire_536 = &"net9" @WIRE(mode="straight") {%p221 %p222};
//   %p223 = (256, -8);
//   %wire_537 = &"net9" @WIRE(mode="straight") {%p223 #"I613":5};
//   %wire_538 = &"net9" @WIRE(mode="straight") {%p219 #"I591":5};
//   %p224 = (328, -8);
//   %p225 = (352, -8);
//   %wire_539 = &"net9" @WIRE(mode="straight") {%p224 %p225};
//   %p226 = (86, -8);
//   %p227 = (124, -8);
//   %wire_540 = &"net9" @WIRE(mode="straight") {%p226 %p227};
//   %wire_541 = &"net9" @WIRE(mode="straight") {%p221 #"I525":5};
//   %wire_542 = &"net9" @WIRE(mode="straight") {%p227 #"I503":5};
//   %wire_543 = &"net9" @WIRE(mode="straight") {%p226 #"I481":5};
//   %p228 = (304, -8);
//   %wire_544 = &"net9" @WIRE(mode="straight") {%p228 #"I657":5};
//   %p229 = (280, -8);
//   %wire_545 = &"net9" @WIRE(mode="straight") {%p229 #"I635":5};
//   %wire_546 = &"net9" @WIRE(mode="straight") {%p225 #"I701":5};
//   %wire_547 = &"net9" @WIRE(mode="straight") {%p224 #"I679":5};
//   %wire_548 = &"net9" @WIRE(mode="straight") {%p227 %p221};
//   %wire_549 = &"net9" @WIRE(mode="straight") {%p222 %p218};
//   %wire_550 = &"net9" @WIRE(mode="straight") {%p216 #"I415":5};
//   %p230 = (400, -8);
//   %wire_551 = &"net9" @WIRE(mode="straight") {%p230 #"I745":5};
//   %p231 = (376, -8);
//   %wire_552 = &"net9" @WIRE(mode="straight") {%p231 #"I723":5};
//   %wire_553 = &"net9" @WIRE(mode="straight") {%p222 #"I547":5};
//   %wire_554 = &"net9" @WIRE(mode="straight") {%p218 #"I569":5};
//   %wire_555 = &"net9" @WIRE(mode="straight") {%p230 #"I768":2};
//   %wire_556 = &"net9" @WIRE(mode="straight") {%p231 %p230};
//   %wire_557 = &"net9" @WIRE(mode="straight") {%p225 %p231};
//   %wire_558 = &"net9" @WIRE(mode="straight") {%p228 %p224};
//   %wire_559 = &"net9" @WIRE(mode="straight") {%p229 %p228};
//   %wire_560 = &"net9" @WIRE(mode="straight") {%p223 %p229};
//   %wire_561 = &"net9" @WIRE(mode="straight") {%p219 %p223};
//   %p232 = (62, -8);
//   %wire_562 = &"net9" @WIRE(mode="straight") {%p232 #"I459":5};
//   %wire_563 = &"net9" @WIRE(mode="straight") {%p232 %p226};
//   %wire_564 = &"net9" @WIRE(mode="straight") {%p217 %p232};
//   %wire_565 = &"net9" @WIRE(mode="straight") {%p217 #"I437":5};
//   %p233 = (276, 16);
//   %wire_566 = &"net11" @WIRE(mode="straight") {#"I635":3 %p233};
//   %p234 = (278, 16);
//   %wire_567 = &"net11" @WIRE(mode="straight") {%p233 %p234};
//   %wire_568 = &"net11" @WIRE(mode="straight") {#"I635":6 %p234};
//   %p235 = (256, 16);
//   %wire_569 = &"net11" @WIRE(mode="straight") {%p235 %p233};
//   %wire_570 = &"net11" @WIRE(mode="straight") {#"I613":7 %p235};
//   %wire_571 = &"net12" @WIRE(mode="straight") {#"I1579":10 %marker_721};
//   %wire_572 = &"net12" @WIRE(mode="straight") {#"I1567":10 #"I1579":10};
//   %p236 = (248, -748);
//   %wire_573 = &"net12" @WIRE(mode="straight") {%p236 #"I1628":3};
//   %wire_574 = &"net12" @WIRE(mode="straight") {%p236 #"I1418":10};
//   %wire_575 = &"net12" @WIRE(mode="straight") {#"I1169":10 #"I1401":10};
//   %wire_576 = &"net12" @WIRE(mode="straight") {#"I849":10 #"I1265":10};
//   %wire_577 = &"net12" @WIRE(mode="straight") {#"I1384":10 #"I1089":10};
//   %wire_578 = &"net12" @WIRE(mode="straight") {#"I613":10 #"I1567":10};
//   %wire_579 = &"net12" @WIRE(mode="straight") {#"I1089":10 #"I1367":10};
//   %wire_580 = &"net12" @WIRE(mode="straight") {#"I1299":10 #"I889":10};
//   %wire_581 = &"net12" @WIRE(mode="straight") {#"I1316":10 #"I929":10};
//   %wire_582 = &"net12" @WIRE(mode="straight") {#"I1265":10 #"I809":10};
//   %wire_583 = &"net12" @WIRE(mode="straight") {#"I1049":10 #"I1350":10};
//   %wire_584 = &"net12" @WIRE(mode="straight") {#"I809":10 #"I776":10};
//   %wire_585 = &"net12" @WIRE(mode="straight") {#"I1367":10 #"I1049":10};
//   %wire_586 = &"net12" @WIRE(mode="straight") {#"I776":10 #"I613":10};
//   %wire_587 = &"net12" @WIRE(mode="straight") {#"I1333":10 #"I969":10};
//   %wire_588 = &"net12" @WIRE(mode="straight") {#"I1401":10 #"I1129":10};
//   %wire_589 = &"net12" @WIRE(mode="straight") {#"I1129":10 #"I1384":10};
//   %wire_590 = &"net12" @WIRE(mode="straight") {#"I929":10 #"I1299":10};
//   %wire_591 = &"net12" @WIRE(mode="straight") {#"I1009":10 #"I1333":10};
//   %wire_592 = &"net12" @WIRE(mode="straight") {#"I889":10 #"I1282":10};
//   %wire_593 = &"net12" @WIRE(mode="straight") {#"I969":10 #"I1316":10};
//   %wire_594 = &"net12" @WIRE(mode="straight") {#"I1350":10 #"I1009":10};
//   %wire_595 = &"net12" @WIRE(mode="straight") {#"I1282":10 #"I849":10};
//   %wire_596 = &"net12" @WIRE(mode="straight") {#"I1418":10 #"I1169":10};
//   %p237 = (32, 20);
//   %wire_597 = &"net13" @WIRE(mode="straight") {#"I437":9 %p237};
//   %p238 = (56, 20);
//   %wire_598 = &"net13" @WIRE(mode="straight") {%p237 %p238};
//   %wire_599 = &"net13" @WIRE(mode="straight") {#"I459":9 %p238};
//   %p239 = (322, 20);
//   %p240 = (346, 20);
//   %wire_600 = &"net13" @WIRE(mode="straight") {%p239 %p240};
//   %p241 = (370, 20);
//   %wire_601 = &"net13" @WIRE(mode="straight") {%p240 %p241};
//   %p242 = (142, 20);
//   %p243 = (166, 20);
//   %wire_602 = &"net13" @WIRE(mode="straight") {%p242 %p243};
//   %p244 = (8, 20);
//   %wire_603 = &"net13" @WIRE(mode="straight") {#"I415":9 %p244};
//   %wire_604 = &"net13" @WIRE(mode="straight") {#"I679":9 %p239};
//   %p245 = (298, 20);
//   %wire_605 = &"net13" @WIRE(mode="straight") {#"I657":9 %p245};
//   %wire_606 = &"net13" @WIRE(mode="straight") {#"I723":9 %p241};
//   %wire_607 = &"net13" @WIRE(mode="straight") {#"I701":9 %p240};
//   %p246 = (250, 20);
//   %wire_608 = &"net13" @WIRE(mode="straight") {#"I613":9 %p246};
//   %p247 = (274, 20);
//   %wire_609 = &"net13" @WIRE(mode="straight") {#"I635":9 %p247};
//   %wire_610 = &"net13" @WIRE(mode="straight") {%p246 %p247};
//   %wire_611 = &"net13" @WIRE(mode="straight") {%p245 %p239};
//   %p248 = (80, 20);
//   %wire_612 = &"net13" @WIRE(mode="straight") {%p238 %p248};
//   %wire_613 = &"net13" @WIRE(mode="straight") {#"I481":9 %p248};
//   %wire_614 = &"net13" @WIRE(mode="straight") {%p247 %p245};
//   %p249 = (118, 20);
//   %wire_615 = &"net13" @WIRE(mode="straight") {%p248 %p249};
//   %wire_616 = &"net13" @WIRE(mode="straight") {#"I503":9 %p249};
//   %p250 = (226, 20);
//   %wire_617 = &"net13" @WIRE(mode="straight") {%p250 %p246};
//   %p251 = (10, 20);
//   %wire_618 = &"net13" @WIRE(mode="straight") {%p251 %p237};
//   %p252 = (394, 20);
//   %wire_619 = &"net13" @WIRE(mode="straight") {#"I745":9 %p252};
//   %wire_620 = &"net13" @WIRE(mode="straight") {%p241 %p252};
//   %p253 = (190, 20);
//   %wire_621 = &"net13" @WIRE(mode="straight") {%p253 %p250};
//   %wire_622 = &"net13" @WIRE(mode="straight") {#"I591":9 %p250};
//   %wire_623 = &"net13" @WIRE(mode="straight") {%p243 %p253};
//   %wire_624 = &"net13" @WIRE(mode="straight") {#"I569":9 %p253};
//   %wire_625 = &"net13" @WIRE(mode="straight") {%p249 %p242};
//   %wire_626 = &"net13" @WIRE(mode="straight") {%p244 %p251};
//   %wire_627 = &"net13" @WIRE(mode="straight") {#"I415":3 %p251};
//   %wire_628 = &"net13" @WIRE(mode="straight") {#"I525":9 %p242};
//   %wire_629 = &"net13" @WIRE(mode="straight") {#"I547":9 %p243};
//   %p254 = (205, 4);
//   %wire_630 = &"net14" @WIRE(mode="straight") {#"M66":3 %p254};
//   %p255 = (205, 7);
//   %wire_631 = &"net14" @WIRE(mode="straight") {%p255 #"M168":3};
//   %wire_632 = &"net14" @WIRE(mode="straight") {%p254 %p255};
//   %p256 = (107, 1);
//   %p257 = (107, 4);
//   %wire_633 = &"net14" @WIRE(mode="straight") {%p256 %p257};
//   %wire_634 = &"net14" @WIRE(mode="straight") {%p257 #"I503":4};
//   %wire_635 = &"net14" @WIRE(mode="straight") {#"I569":4 %p254};
//   %wire_636 = &"net14" @WIRE(mode="straight") {%p257 #"M44":1};
//   %wire_637 = &"net14" @WIRE(mode="straight") {#"M22":1 %p256};
//   %wire_638 = &"net14" @WIRE(mode="straight") {#"I503":4 #"I525":4};
//   %wire_639 = &"net14" @WIRE(mode="straight") {#"I547":4 #"I569":4};
//   %wire_640 = &"net14" @WIRE(mode="straight") {#"I525":4 #"I547":4};
//   %p258 = (-26, 2);
//   %wire_641 = &"net15" @WIRE(mode="straight") {#"I411":2 %p258};
//   %p259 = (97, 7);
//   %wire_642 = &"net15" @WIRE(mode="straight") {%p259 #"M44":3};
//   %p260 = (97, 4);
//   %wire_643 = &"net15" @WIRE(mode="straight") {%p260 %p259};
//   %wire_644 = &"net15" @WIRE(mode="straight") {%p258 #"I412":1};
//   %p261 = (-6, 4);
//   %wire_645 = &"net15" @WIRE(mode="straight") {%p261 #"I415":4};
//   %wire_646 = &"net15" @WIRE(mode="straight") {%p261 #"M0":1};
//   %wire_647 = &"net15" @WIRE(mode="straight") {#"I412":1 %p261};
//   %wire_648 = &"net15" @WIRE(mode="straight") {#"I415":4 #"I437":4};
//   %wire_649 = &"net15" @WIRE(mode="straight") {#"M22":3 %p260};
//   %wire_650 = &"net15" @WIRE(mode="straight") {#"I437":4 #"I459":4};
//   %wire_651 = &"net15" @WIRE(mode="straight") {#"I459":4 #"I481":4};
//   %wire_652 = &"net15" @WIRE(mode="straight") {#"I481":4 %p260};
//   %p262 = (148, 16);
//   %wire_653 = &"net16" @WIRE(mode="straight") {#"I525":7 %p262};
//   %p263 = (168, 16);
//   %wire_654 = &"net16" @WIRE(mode="straight") {#"I547":3 %p263};
//   %p264 = (170, 16);
//   %wire_655 = &"net16" @WIRE(mode="straight") {#"I547":6 %p264};
//   %wire_656 = &"net16" @WIRE(mode="straight") {%p262 %p263};
//   %wire_657 = &"net16" @WIRE(mode="straight") {%p263 %p264};
//   %wire_658 = &"net18" @WIRE(mode="straight") {#"I1577":1 %marker_102};
//   %wire_659 = &"net18" @WIRE(mode="straight") {#"I1570":1 #"I1577":1};
//   %wire_660 = &"net18" @WIRE(mode="straight") {#"I1319":1 #"I932":1};
//   %wire_661 = &"net18" @WIRE(mode="straight") {#"I1204":3 #"I1421":1};
//   %wire_662 = &"net18" @WIRE(mode="straight") {#"I1172":1 #"I1404":1};
//   %wire_663 = &"net18" @WIRE(mode="straight") {#"I1387":1 #"I1092":1};
//   %wire_664 = &"net18" @WIRE(mode="straight") {#"I812":1 #"I779":1};
//   %wire_665 = &"net18" @WIRE(mode="straight") {#"I1336":1 #"I972":1};
//   %wire_666 = &"net18" @WIRE(mode="straight") {#"I1285":1 #"I852":1};
//   %wire_667 = &"net18" @WIRE(mode="straight") {#"I547":1 #"I1570":1};
//   %wire_668 = &"net18" @WIRE(mode="straight") {#"I972":1 #"I1319":1};
//   %wire_669 = &"net18" @WIRE(mode="straight") {#"I1353":1 #"I1012":1};
//   %wire_670 = &"net18" @WIRE(mode="straight") {#"I1012":1 #"I1336":1};
//   %wire_671 = &"net18" @WIRE(mode="straight") {#"I892":1 #"I1285":1};
//   %wire_672 = &"net18" @WIRE(mode="straight") {#"I1370":1 #"I1052":1};
//   %wire_673 = &"net18" @WIRE(mode="straight") {#"I1302":1 #"I892":1};
//   %wire_674 = &"net18" @WIRE(mode="straight") {#"I1268":1 #"I812":1};
//   %wire_675 = &"net18" @WIRE(mode="straight") {#"I932":1 #"I1302":1};
//   %wire_676 = &"net18" @WIRE(mode="straight") {#"I779":1 #"I547":1};
//   %wire_677 = &"net18" @WIRE(mode="straight") {#"I1092":1 #"I1370":1};
//   %wire_678 = &"net18" @WIRE(mode="straight") {#"I1132":1 #"I1387":1};
//   %wire_679 = &"net18" @WIRE(mode="straight") {#"I1404":1 #"I1132":1};
//   %wire_680 = &"net18" @WIRE(mode="straight") {#"I1052":1 #"I1353":1};
//   %wire_681 = &"net18" @WIRE(mode="straight") {#"I1421":1 #"I1172":1};
//   %wire_682 = &"net18" @WIRE(mode="straight") {#"I852":1 #"I1268":1};
//   %p265 = (172, 16);
//   %wire_683 = &"net23" @WIRE(mode="straight") {#"I547":7 %p265};
//   %p266 = (192, 16);
//   %wire_684 = &"net23" @WIRE(mode="straight") {%p265 %p266};
//   %p267 = (194, 16);
//   %wire_685 = &"net23" @WIRE(mode="straight") {#"I569":6 %p267};
//   %wire_686 = &"net23" @WIRE(mode="straight") {%p266 %p267};
//   %wire_687 = &"net23" @WIRE(mode="straight") {#"I569":3 %p266};
//   %wire_688 = &"net24" @WIRE(mode="straight") {#"I1577":10 %marker_111};
//   %wire_689 = &"net24" @WIRE(mode="straight") {#"I1570":10 #"I1577":10};
//   %p268 = (164, -748);
//   %wire_690 = &"net24" @WIRE(mode="straight") {%p268 #"I1635":3};
//   %wire_691 = &"net24" @WIRE(mode="straight") {%p268 #"I1421":10};
//   %wire_692 = &"net24" @WIRE(mode="straight") {#"I1172":10 #"I1404":10};
//   %wire_693 = &"net24" @WIRE(mode="straight") {#"I1387":10 #"I1092":10};
//   %wire_694 = &"net24" @WIRE(mode="straight") {#"I812":10 #"I779":10};
//   %wire_695 = &"net24" @WIRE(mode="straight") {#"I892":10 #"I1285":10};
//   %wire_696 = &"net24" @WIRE(mode="straight") {#"I1370":10 #"I1052":10};
//   %wire_697 = &"net24" @WIRE(mode="straight") {#"I1319":10 #"I932":10};
//   %wire_698 = &"net24" @WIRE(mode="straight") {#"I1404":10 #"I1132":10};
//   %wire_699 = &"net24" @WIRE(mode="straight") {#"I1353":10 #"I1012":10};
//   %wire_700 = &"net24" @WIRE(mode="straight") {#"I1285":10 #"I852":10};
//   %wire_701 = &"net24" @WIRE(mode="straight") {#"I972":10 #"I1319":10};
//   %wire_702 = &"net24" @WIRE(mode="straight") {#"I1052":10 #"I1353":10};
//   %wire_703 = &"net24" @WIRE(mode="straight") {#"I547":10 #"I1570":10};
//   %wire_704 = &"net24" @WIRE(mode="straight") {#"I1268":10 #"I812":10};
//   %wire_705 = &"net24" @WIRE(mode="straight") {#"I779":10 #"I547":10};
//   %wire_706 = &"net24" @WIRE(mode="straight") {#"I852":10 #"I1268":10};
//   %wire_707 = &"net24" @WIRE(mode="straight") {#"I1132":10 #"I1387":10};
//   %wire_708 = &"net24" @WIRE(mode="straight") {#"I1012":10 #"I1336":10};
//   %wire_709 = &"net24" @WIRE(mode="straight") {#"I1302":10 #"I892":10};
//   %wire_710 = &"net24" @WIRE(mode="straight") {#"I1092":10 #"I1370":10};
//   %wire_711 = &"net24" @WIRE(mode="straight") {#"I932":10 #"I1302":10};
//   %wire_712 = &"net24" @WIRE(mode="straight") {#"I1421":10 #"I1172":10};
//   %wire_713 = &"net24" @WIRE(mode="straight") {#"I1336":10 #"I972":10};
//   %p269 = (350, -19);
//   %p270 = (376, -17);
//   %wire_714 = &"net66" @WIRE(mode="straight") {%p269 %p270};
//   %wire_715 = &"net66" @WIRE(mode="straight") {#"I785":6 %p269};
//   %p271 = (396, -19);
//   %wire_716 = &"net66" @WIRE(mode="straight") {#"I783":3 %p271};
//   %wire_717 = &"net66" @WIRE(mode="straight") {#"I784":7 %p270};
//   %wire_718 = &"net66" @WIRE(mode="straight") {%p271 %p270};
//   %wire_719 = &"net28" @WIRE(mode="straight") {#"I569":1 #"I1569":1};
//   %wire_720 = &"net28" @WIRE(mode="straight") {#"I1578":1 %marker_156};
//   %wire_721 = &"net28" @WIRE(mode="straight") {#"I1569":1 #"I1578":1};
//   %wire_722 = &"net28" @WIRE(mode="straight") {#"I1199":3 #"I1422":1};
//   %wire_723 = &"net28" @WIRE(mode="straight") {#"I1171":1 #"I1405":1};
//   %wire_724 = &"net28" @WIRE(mode="straight") {#"I1286":1 #"I851":1};
//   %wire_725 = &"net28" @WIRE(mode="straight") {#"I891":1 #"I1286":1};
//   %wire_726 = &"net28" @WIRE(mode="straight") {#"I1011":1 #"I1337":1};
//   %wire_727 = &"net28" @WIRE(mode="straight") {#"I811":1 #"I778":1};
//   %wire_728 = &"net28" @WIRE(mode="straight") {#"I1354":1 #"I1011":1};
//   %wire_729 = &"net28" @WIRE(mode="straight") {#"I1405":1 #"I1131":1};
//   %wire_730 = &"net28" @WIRE(mode="straight") {#"I1371":1 #"I1051":1};
//   %wire_731 = &"net28" @WIRE(mode="straight") {#"I1422":1 #"I1171":1};
//   %wire_732 = &"net28" @WIRE(mode="straight") {#"I1269":1 #"I811":1};
//   %wire_733 = &"net28" @WIRE(mode="straight") {#"I778":1 #"I569":1};
//   %wire_734 = &"net28" @WIRE(mode="straight") {#"I1303":1 #"I891":1};
//   %wire_735 = &"net28" @WIRE(mode="straight") {#"I971":1 #"I1320":1};
//   %wire_736 = &"net28" @WIRE(mode="straight") {#"I1388":1 #"I1091":1};
//   %wire_737 = &"net28" @WIRE(mode="straight") {#"I1320":1 #"I931":1};
//   %wire_738 = &"net28" @WIRE(mode="straight") {#"I1131":1 #"I1388":1};
//   %wire_739 = &"net28" @WIRE(mode="straight") {#"I1051":1 #"I1354":1};
//   %wire_740 = &"net28" @WIRE(mode="straight") {#"I1337":1 #"I971":1};
//   %wire_741 = &"net28" @WIRE(mode="straight") {#"I1091":1 #"I1371":1};
//   %wire_742 = &"net28" @WIRE(mode="straight") {#"I931":1 #"I1303":1};
//   %wire_743 = &"net28" @WIRE(mode="straight") {#"I851":1 #"I1269":1};
//   %p272 = (228, 16);
//   %p273 = (230, 16);
//   %wire_744 = &"net33" @WIRE(mode="straight") {%p272 %p273};
//   %wire_745 = &"net33" @WIRE(mode="straight") {#"I591":6 %p273};
//   %p274 = (196, 16);
//   %wire_746 = &"net33" @WIRE(mode="straight") {#"I569":7 %p274};
//   %wire_747 = &"net33" @WIRE(mode="straight") {%p274 %p272};
//   %wire_748 = &"net33" @WIRE(mode="straight") {#"I591":3 %p272};
//   %wire_749 = &"net34" @WIRE(mode="straight") {#"I569":10 #"I1569":10};
//   %wire_750 = &"net34" @WIRE(mode="straight") {#"I1578":10 %marker_977};
//   %wire_751 = &"net34" @WIRE(mode="straight") {#"I1569":10 #"I1578":10};
//   %p275 = (188, -748);
//   %wire_752 = &"net34" @WIRE(mode="straight") {%p275 #"I1626":3};
//   %wire_753 = &"net34" @WIRE(mode="straight") {%p275 #"I1422":10};
//   %wire_754 = &"net34" @WIRE(mode="straight") {#"I1171":10 #"I1405":10};
//   %wire_755 = &"net34" @WIRE(mode="straight") {#"I1337":10 #"I971":10};
//   %wire_756 = &"net34" @WIRE(mode="straight") {#"I971":10 #"I1320":10};
//   %wire_757 = &"net34" @WIRE(mode="straight") {#"I778":10 #"I569":10};
//   %wire_758 = &"net34" @WIRE(mode="straight") {#"I891":10 #"I1286":10};
//   %wire_759 = &"net34" @WIRE(mode="straight") {#"I1388":10 #"I1091":10};
//   %wire_760 = &"net34" @WIRE(mode="straight") {#"I1354":10 #"I1011":10};
//   %wire_761 = &"net34" @WIRE(mode="straight") {#"I1371":10 #"I1051":10};
//   %wire_762 = &"net34" @WIRE(mode="straight") {#"I1011":10 #"I1337":10};
//   %wire_763 = &"net34" @WIRE(mode="straight") {#"I1303":10 #"I891":10};
//   %wire_764 = &"net34" @WIRE(mode="straight") {#"I1051":10 #"I1354":10};
//   %wire_765 = &"net34" @WIRE(mode="straight") {#"I811":10 #"I778":10};
//   %wire_766 = &"net34" @WIRE(mode="straight") {#"I1405":10 #"I1131":10};
//   %wire_767 = &"net34" @WIRE(mode="straight") {#"I1286":10 #"I851":10};
//   %wire_768 = &"net34" @WIRE(mode="straight") {#"I1320":10 #"I931":10};
//   %wire_769 = &"net34" @WIRE(mode="straight") {#"I1131":10 #"I1388":10};
//   %wire_770 = &"net34" @WIRE(mode="straight") {#"I931":10 #"I1303":10};
//   %wire_771 = &"net34" @WIRE(mode="straight") {#"I1269":10 #"I811":10};
//   %wire_772 = &"net34" @WIRE(mode="straight") {#"I851":10 #"I1269":10};
//   %wire_773 = &"net34" @WIRE(mode="straight") {#"I1091":10 #"I1371":10};
//   %wire_774 = &"net34" @WIRE(mode="straight") {#"I1422":10 #"I1171":10};
//   %p276 = (304, 16);
//   %p277 = (324, 16);
//   %wire_775 = &"net36" @WIRE(mode="straight") {%p276 %p277};
//   %p278 = (326, 16);
//   %wire_776 = &"net36" @WIRE(mode="straight") {%p277 %p278};
//   %wire_777 = &"net36" @WIRE(mode="straight") {#"I657":7 %p276};
//   %wire_778 = &"net36" @WIRE(mode="straight") {#"I679":3 %p277};
//   %wire_779 = &"net36" @WIRE(mode="straight") {#"I679":6 %p278};
//   %wire_780 = &"net38" @WIRE(mode="straight") {#"I679":1 #"I1600":1};
//   %wire_781 = &"net38" @WIRE(mode="straight") {#"I1604":1 %marker_984};
//   %wire_782 = &"net38" @WIRE(mode="straight") {#"I1600":1 #"I1604":1};
//   %wire_783 = &"net38" @WIRE(mode="straight") {#"I1213":3 #"I1427":1};
//   %wire_784 = &"net38" @WIRE(mode="straight") {#"I1186":1 #"I1410":1};
//   %wire_785 = &"net38" @WIRE(mode="straight") {#"I1146":1 #"I1393":1};
//   %wire_786 = &"net38" @WIRE(mode="straight") {#"I1308":1 #"I906":1};
//   %wire_787 = &"net38" @WIRE(mode="straight") {#"I946":1 #"I1308":1};
//   %wire_788 = &"net38" @WIRE(mode="straight") {#"I826":1 #"I786":1};
//   %wire_789 = &"net38" @WIRE(mode="straight") {#"I1026":1 #"I1342":1};
//   %wire_790 = &"net38" @WIRE(mode="straight") {#"I1291":1 #"I866":1};
//   %wire_791 = &"net38" @WIRE(mode="straight") {#"I786":1 #"I679":1};
//   %wire_792 = &"net38" @WIRE(mode="straight") {#"I1359":1 #"I1026":1};
//   %wire_793 = &"net38" @WIRE(mode="straight") {#"I986":1 #"I1325":1};
//   %wire_794 = &"net38" @WIRE(mode="straight") {#"I1393":1 #"I1106":1};
//   %wire_795 = &"net38" @WIRE(mode="straight") {#"I1325":1 #"I946":1};
//   %wire_796 = &"net38" @WIRE(mode="straight") {#"I866":1 #"I1274":1};
//   %wire_797 = &"net38" @WIRE(mode="straight") {#"I1066":1 #"I1359":1};
//   %wire_798 = &"net38" @WIRE(mode="straight") {#"I1342":1 #"I986":1};
//   %wire_799 = &"net38" @WIRE(mode="straight") {#"I1410":1 #"I1146":1};
//   %wire_800 = &"net38" @WIRE(mode="straight") {#"I906":1 #"I1291":1};
//   %wire_801 = &"net38" @WIRE(mode="straight") {#"I1376":1 #"I1066":1};
//   %wire_802 = &"net38" @WIRE(mode="straight") {#"I1274":1 #"I826":1};
//   %wire_803 = &"net38" @WIRE(mode="straight") {#"I1427":1 #"I1186":1};
//   %wire_804 = &"net38" @WIRE(mode="straight") {#"I1106":1 #"I1376":1};
//   %p279 = (348, 16);
//   %p280 = (350, 16);
//   %wire_805 = &"net43" @WIRE(mode="straight") {%p279 %p280};
//   %wire_806 = &"net43" @WIRE(mode="straight") {#"I701":3 %p279};
//   %p281 = (328, 16);
//   %wire_807 = &"net43" @WIRE(mode="straight") {%p281 %p279};
//   %wire_808 = &"net43" @WIRE(mode="straight") {#"I679":7 %p281};
//   %wire_809 = &"net43" @WIRE(mode="straight") {#"I701":6 %p280};
//   %wire_810 = &"net44" @WIRE(mode="straight") {#"I679":10 #"I1600":10};
//   %wire_811 = &"net44" @WIRE(mode="straight") {#"I1604":10 %marker_1045};
//   %wire_812 = &"net44" @WIRE(mode="straight") {#"I1600":10 #"I1604":10};
//   %p282 = (320, -748);
//   %wire_813 = &"net44" @WIRE(mode="straight") {%p282 #"I1631":3};
//   %wire_814 = &"net44" @WIRE(mode="straight") {%p282 #"I1427":10};
//   %wire_815 = &"net44" @WIRE(mode="straight") {#"I1186":10 #"I1410":10};
//   %wire_816 = &"net44" @WIRE(mode="straight") {#"I1146":10 #"I1393":10};
//   %wire_817 = &"net44" @WIRE(mode="straight") {#"I866":10 #"I1274":10};
//   %wire_818 = &"net44" @WIRE(mode="straight") {#"I906":10 #"I1291":10};
//   %wire_819 = &"net44" @WIRE(mode="straight") {#"I1308":10 #"I906":10};
//   %wire_820 = &"net44" @WIRE(mode="straight") {#"I1291":10 #"I866":10};
//   %wire_821 = &"net44" @WIRE(mode="straight") {#"I1342":10 #"I986":10};
//   %wire_822 = &"net44" @WIRE(mode="straight") {#"I1066":10 #"I1359":10};
//   %wire_823 = &"net44" @WIRE(mode="straight") {#"I1106":10 #"I1376":10};
//   %wire_824 = &"net44" @WIRE(mode="straight") {#"I1410":10 #"I1146":10};
//   %wire_825 = &"net44" @WIRE(mode="straight") {#"I1393":10 #"I1106":10};
//   %wire_826 = &"net44" @WIRE(mode="straight") {#"I1359":10 #"I1026":10};
//   %wire_827 = &"net44" @WIRE(mode="straight") {#"I786":10 #"I679":10};
//   %wire_828 = &"net44" @WIRE(mode="straight") {#"I826":10 #"I786":10};
//   %wire_829 = &"net44" @WIRE(mode="straight") {#"I1427":10 #"I1186":10};
//   %wire_830 = &"net44" @WIRE(mode="straight") {#"I946":10 #"I1308":10};
//   %wire_831 = &"net44" @WIRE(mode="straight") {#"I986":10 #"I1325":10};
//   %wire_832 = &"net44" @WIRE(mode="straight") {#"I1376":10 #"I1066":10};
//   %wire_833 = &"net44" @WIRE(mode="straight") {#"I1274":10 #"I826":10};
//   %wire_834 = &"net44" @WIRE(mode="straight") {#"I1325":10 #"I946":10};
//   %wire_835 = &"net44" @WIRE(mode="straight") {#"I1026":10 #"I1342":10};
//   %p283 = (148, -17);
//   %wire_836 = &"net35" @WIRE(mode="straight") {#"I780":7 %p283};
//   %p284 = (168, -19);
//   %wire_837 = &"net35" @WIRE(mode="straight") {%p284 %p283};
//   %wire_838 = &"net35" @WIRE(mode="straight") {#"I779":3 %p284};
//   %p285 = (122, -19);
//   %wire_839 = &"net35" @WIRE(mode="straight") {%p285 %p283};
//   %wire_840 = &"net35" @WIRE(mode="straight") {#"I781":6 %p285};
//   %wire_841 = &"net48" @WIRE(mode="straight") {#"I701":1 #"I1599":1};
//   %wire_842 = &"net48" @WIRE(mode="straight") {#"I1605":1 %marker_56};
//   %wire_843 = &"net48" @WIRE(mode="straight") {#"I1599":1 #"I1605":1};
//   %wire_844 = &"net48" @WIRE(mode="straight") {#"I1218":3 #"I1428":1};
//   %wire_845 = &"net48" @WIRE(mode="straight") {#"I1185":1 #"I1411":1};
//   %wire_846 = &"net48" @WIRE(mode="straight") {#"I1145":1 #"I1394":1};
//   %wire_847 = &"net48" @WIRE(mode="straight") {#"I905":1 #"I1292":1};
//   %wire_848 = &"net48" @WIRE(mode="straight") {#"I785":1 #"I701":1};
//   %wire_849 = &"net48" @WIRE(mode="straight") {#"I1411":1 #"I1145":1};
//   %wire_850 = &"net48" @WIRE(mode="straight") {#"I985":1 #"I1326":1};
//   %wire_851 = &"net48" @WIRE(mode="straight") {#"I1360":1 #"I1025":1};
//   %wire_852 = &"net48" @WIRE(mode="straight") {#"I1105":1 #"I1377":1};
//   %wire_853 = &"net48" @WIRE(mode="straight") {#"I1309":1 #"I905":1};
//   %wire_854 = &"net48" @WIRE(mode="straight") {#"I1065":1 #"I1360":1};
//   %wire_855 = &"net48" @WIRE(mode="straight") {#"I1394":1 #"I1105":1};
//   %wire_856 = &"net48" @WIRE(mode="straight") {#"I1343":1 #"I985":1};
//   %wire_857 = &"net48" @WIRE(mode="straight") {#"I1326":1 #"I945":1};
//   %wire_858 = &"net48" @WIRE(mode="straight") {#"I1025":1 #"I1343":1};
//   %wire_859 = &"net48" @WIRE(mode="straight") {#"I825":1 #"I785":1};
//   %wire_860 = &"net48" @WIRE(mode="straight") {#"I1428":1 #"I1185":1};
//   %wire_861 = &"net48" @WIRE(mode="straight") {#"I1377":1 #"I1065":1};
//   %wire_862 = &"net48" @WIRE(mode="straight") {#"I945":1 #"I1309":1};
//   %wire_863 = &"net48" @WIRE(mode="straight") {#"I865":1 #"I1275":1};
//   %wire_864 = &"net48" @WIRE(mode="straight") {#"I1292":1 #"I865":1};
//   %wire_865 = &"net48" @WIRE(mode="straight") {#"I1275":1 #"I825":1};
//   %p286 = (372, 16);
//   %wire_866 = &"net53" @WIRE(mode="straight") {#"I723":3 %p286};
//   %p287 = (374, 16);
//   %wire_867 = &"net53" @WIRE(mode="straight") {%p286 %p287};
//   %wire_868 = &"net53" @WIRE(mode="straight") {#"I723":6 %p287};
//   %p288 = (352, 16);
//   %wire_869 = &"net53" @WIRE(mode="straight") {#"I701":7 %p288};
//   %wire_870 = &"net53" @WIRE(mode="straight") {%p288 %p286};
//   %wire_871 = &"net54" @WIRE(mode="straight") {#"I701":10 #"I1599":10};
//   %wire_872 = &"net54" @WIRE(mode="straight") {#"I1605":10 %marker_127};
//   %wire_873 = &"net54" @WIRE(mode="straight") {#"I1599":10 #"I1605":10};
//   %p289 = (344, -748);
//   %wire_874 = &"net54" @WIRE(mode="straight") {%p289 #"I1632":3};
//   %wire_875 = &"net54" @WIRE(mode="straight") {#"I1275":10 #"I825":10};
//   %wire_876 = &"net54" @WIRE(mode="straight") {%p289 #"I1428":10};
//   %wire_877 = &"net54" @WIRE(mode="straight") {#"I1185":10 #"I1411":10};
//   %wire_878 = &"net54" @WIRE(mode="straight") {#"I1145":10 #"I1394":10};
//   %wire_879 = &"net54" @WIRE(mode="straight") {#"I1360":10 #"I1025":10};
//   %wire_880 = &"net54" @WIRE(mode="straight") {#"I1025":10 #"I1343":10};
//   %wire_881 = &"net54" @WIRE(mode="straight") {#"I1065":10 #"I1360":10};
//   %wire_882 = &"net54" @WIRE(mode="straight") {#"I1326":10 #"I945":10};
//   %wire_883 = &"net54" @WIRE(mode="straight") {#"I785":10 #"I701":10};
//   %wire_884 = &"net54" @WIRE(mode="straight") {#"I985":10 #"I1326":10};
//   %wire_885 = &"net54" @WIRE(mode="straight") {#"I1309":10 #"I905":10};
//   %wire_886 = &"net54" @WIRE(mode="straight") {#"I1377":10 #"I1065":10};
//   %wire_887 = &"net54" @WIRE(mode="straight") {#"I825":10 #"I785":10};
//   %wire_888 = &"net54" @WIRE(mode="straight") {#"I1411":10 #"I1145":10};
//   %wire_889 = &"net54" @WIRE(mode="straight") {#"I865":10 #"I1275":10};
//   %wire_890 = &"net54" @WIRE(mode="straight") {#"I1394":10 #"I1105":10};
//   %wire_891 = &"net54" @WIRE(mode="straight") {#"I1343":10 #"I985":10};
//   %wire_892 = &"net54" @WIRE(mode="straight") {#"I905":10 #"I1292":10};
//   %wire_893 = &"net54" @WIRE(mode="straight") {#"I945":10 #"I1309":10};
//   %wire_894 = &"net54" @WIRE(mode="straight") {#"I1105":10 #"I1377":10};
//   %wire_895 = &"net54" @WIRE(mode="straight") {#"I1292":10 #"I865":10};
//   %wire_896 = &"net54" @WIRE(mode="straight") {#"I1428":10 #"I1185":10};
//   %wire_897 = &"net58" @WIRE(mode="straight") {#"I723":1 #"I1598":1};
//   %wire_898 = &"net58" @WIRE(mode="straight") {#"I1606":1 %marker_846};
//   %wire_899 = &"net58" @WIRE(mode="straight") {#"I1598":1 #"I1606":1};
//   %wire_900 = &"net58" @WIRE(mode="straight") {#"I1220":3 #"I1429":1};
//   %wire_901 = &"net58" @WIRE(mode="straight") {#"I1184":1 #"I1412":1};
//   %wire_902 = &"net58" @WIRE(mode="straight") {#"I1144":1 #"I1395":1};
//   %wire_903 = &"net58" @WIRE(mode="straight") {#"I1378":1 #"I1064":1};
//   %wire_904 = &"net58" @WIRE(mode="straight") {#"I1395":1 #"I1104":1};
//   %wire_905 = &"net58" @WIRE(mode="straight") {#"I824":1 #"I784":1};
//   %wire_906 = &"net58" @WIRE(mode="straight") {#"I944":1 #"I1310":1};
//   %wire_907 = &"net58" @WIRE(mode="straight") {#"I1104":1 #"I1378":1};
//   %wire_908 = &"net58" @WIRE(mode="straight") {#"I1344":1 #"I984":1};
//   %wire_909 = &"net58" @WIRE(mode="straight") {#"I1293":1 #"I864":1};
//   %wire_910 = &"net58" @WIRE(mode="straight") {#"I904":1 #"I1293":1};
//   %wire_911 = &"net58" @WIRE(mode="straight") {#"I864":1 #"I1276":1};
//   %wire_912 = &"net58" @WIRE(mode="straight") {#"I1024":1 #"I1344":1};
//   %wire_913 = &"net58" @WIRE(mode="straight") {#"I1361":1 #"I1024":1};
//   %wire_914 = &"net58" @WIRE(mode="straight") {#"I1064":1 #"I1361":1};
//   %wire_915 = &"net58" @WIRE(mode="straight") {#"I1429":1 #"I1184":1};
//   %wire_916 = &"net58" @WIRE(mode="straight") {#"I784":1 #"I723":1};
//   %wire_917 = &"net58" @WIRE(mode="straight") {#"I1327":1 #"I944":1};
//   %wire_918 = &"net58" @WIRE(mode="straight") {#"I1310":1 #"I904":1};
//   %wire_919 = &"net58" @WIRE(mode="straight") {#"I1412":1 #"I1144":1};
//   %wire_920 = &"net58" @WIRE(mode="straight") {#"I1276":1 #"I824":1};
//   %wire_921 = &"net58" @WIRE(mode="straight") {#"I984":1 #"I1327":1};
//   %p290 = (12, -197);
//   %wire_922 = &"net2157" @WIRE(mode="straight") {#"I879":6 %p290};
//   %wire_923 = &"net2157" @WIRE(mode="straight") {#"I1485":3 #"M72":2};
//   %wire_924 = &"net2157" @WIRE(mode="straight") {#"M72":2 %p290};
//   %p291 = (376, 16);
//   %wire_925 = &"net63" @WIRE(mode="straight") {#"I723":7 %p291};
//   %p292 = (398, 16);
//   %wire_926 = &"net63" @WIRE(mode="straight") {#"I745":6 %p292};
//   %p293 = (396, 16);
//   %wire_927 = &"net63" @WIRE(mode="straight") {%p291 %p293};
//   %wire_928 = &"net63" @WIRE(mode="straight") {#"I745":3 %p293};
//   %wire_929 = &"net63" @WIRE(mode="straight") {%p293 %p292};
//   %wire_930 = &"net64" @WIRE(mode="straight") {#"I723":10 #"I1598":10};
//   %wire_931 = &"net64" @WIRE(mode="straight") {#"I1606":10 %marker_82};
//   %wire_932 = &"net64" @WIRE(mode="straight") {#"I1598":10 #"I1606":10};
//   %wire_933 = &"net64" @WIRE(mode="straight") {#"I1429":10 #"I1184":10};
//   %p294 = (368, -748);
//   %wire_934 = &"net64" @WIRE(mode="straight") {%p294 #"I1633":3};
//   %wire_935 = &"net64" @WIRE(mode="straight") {%p294 #"I1429":10};
//   %wire_936 = &"net64" @WIRE(mode="straight") {#"I1184":10 #"I1412":10};
//   %wire_937 = &"net64" @WIRE(mode="straight") {#"I1144":10 #"I1395":10};
//   %wire_938 = &"net64" @WIRE(mode="straight") {#"I1378":10 #"I1064":10};
//   %wire_939 = &"net64" @WIRE(mode="straight") {#"I1395":10 #"I1104":10};
//   %wire_940 = &"net64" @WIRE(mode="straight") {#"I824":10 #"I784":10};
//   %wire_941 = &"net64" @WIRE(mode="straight") {#"I1064":10 #"I1361":10};
//   %wire_942 = &"net64" @WIRE(mode="straight") {#"I904":10 #"I1293":10};
//   %wire_943 = &"net64" @WIRE(mode="straight") {#"I984":10 #"I1327":10};
//   %wire_944 = &"net64" @WIRE(mode="straight") {#"I784":10 #"I723":10};
//   %wire_945 = &"net64" @WIRE(mode="straight") {#"I1327":10 #"I944":10};
//   %wire_946 = &"net64" @WIRE(mode="straight") {#"I864":10 #"I1276":10};
//   %wire_947 = &"net64" @WIRE(mode="straight") {#"I1310":10 #"I904":10};
//   %wire_948 = &"net64" @WIRE(mode="straight") {#"I944":10 #"I1310":10};
//   %wire_949 = &"net64" @WIRE(mode="straight") {#"I1344":10 #"I984":10};
//   %wire_950 = &"net64" @WIRE(mode="straight") {#"I1361":10 #"I1024":10};
//   %wire_951 = &"net64" @WIRE(mode="straight") {#"I1293":10 #"I864":10};
//   %wire_952 = &"net64" @WIRE(mode="straight") {#"I1412":10 #"I1144":10};
//   %wire_953 = &"net64" @WIRE(mode="straight") {#"I1104":10 #"I1378":10};
//   %wire_954 = &"net64" @WIRE(mode="straight") {#"I1276":10 #"I824":10};
//   %wire_955 = &"net64" @WIRE(mode="straight") {#"I1024":10 #"I1344":10};
//   %p295 = (215, -31);
//   %wire_956 = &"net31" @WIRE(mode="straight") {%p295 #"I777":4};
//   %p296 = (215, -34);
//   %wire_957 = &"net31" @WIRE(mode="straight") {%p296 %p295};
//   %wire_958 = &"net31" @WIRE(mode="straight") {%p295 #"M172":1};
//   %wire_959 = &"net31" @WIRE(mode="straight") {#"M65":1 %p296};
//   %wire_960 = &"net31" @WIRE(mode="straight") {#"I785":4 #"I784":4};
//   %wire_961 = &"net31" @WIRE(mode="straight") {#"I787":4 #"I786":4};
//   %wire_962 = &"net31" @WIRE(mode="straight") {#"I777":4 #"I776":4};
//   %wire_963 = &"net31" @WIRE(mode="straight") {#"I788":4 #"I787":4};
//   %wire_964 = &"net31" @WIRE(mode="straight") {#"I786":4 #"I785":4};
//   %wire_965 = &"net31" @WIRE(mode="straight") {#"I784":4 #"I783":4};
//   %wire_966 = &"net31" @WIRE(mode="straight") {#"I776":4 #"I788":4};
//   %wire_967 = &"net68" @WIRE(mode="straight") {#"I745":1 #"I1597":1};
//   %wire_968 = &"net68" @WIRE(mode="straight") {#"I1607":1 %marker_945};
//   %wire_969 = &"net68" @WIRE(mode="straight") {#"I1597":1 #"I1607":1};
//   %wire_970 = &"net68" @WIRE(mode="straight") {#"I1215":3 #"I1430":1};
//   %wire_971 = &"net68" @WIRE(mode="straight") {#"I1277":1 #"I823":1};
//   %wire_972 = &"net68" @WIRE(mode="straight") {#"I1183":1 #"I1413":1};
//   %wire_973 = &"net68" @WIRE(mode="straight") {#"I1143":1 #"I1396":1};
//   %wire_974 = &"net68" @WIRE(mode="straight") {#"I1379":1 #"I1063":1};
//   %wire_975 = &"net68" @WIRE(mode="straight") {#"I1103":1 #"I1379":1};
//   %wire_976 = &"net68" @WIRE(mode="straight") {#"I783":1 #"I745":1};
//   %wire_977 = &"net68" @WIRE(mode="straight") {#"I1345":1 #"I983":1};
//   %wire_978 = &"net68" @WIRE(mode="straight") {#"I1023":1 #"I1345":1};
//   %wire_979 = &"net68" @WIRE(mode="straight") {#"I903":1 #"I1294":1};
//   %wire_980 = &"net68" @WIRE(mode="straight") {#"I943":1 #"I1311":1};
//   %wire_981 = &"net68" @WIRE(mode="straight") {#"I1396":1 #"I1103":1};
//   %wire_982 = &"net68" @WIRE(mode="straight") {#"I823":1 #"I783":1};
//   %wire_983 = &"net68" @WIRE(mode="straight") {#"I1362":1 #"I1023":1};
//   %wire_984 = &"net68" @WIRE(mode="straight") {#"I1311":1 #"I903":1};
//   %wire_985 = &"net68" @WIRE(mode="straight") {#"I1328":1 #"I943":1};
//   %wire_986 = &"net68" @WIRE(mode="straight") {#"I1063":1 #"I1362":1};
//   %wire_987 = &"net68" @WIRE(mode="straight") {#"I863":1 #"I1277":1};
//   %wire_988 = &"net68" @WIRE(mode="straight") {#"I1294":1 #"I863":1};
//   %wire_989 = &"net68" @WIRE(mode="straight") {#"I1413":1 #"I1143":1};
//   %wire_990 = &"net68" @WIRE(mode="straight") {#"I1430":1 #"I1183":1};
//   %wire_991 = &"net68" @WIRE(mode="straight") {#"I983":1 #"I1328":1};
//   %p297 = (400, 20);
//   %wire_992 = &"net73" @WIRE(mode="straight") {#"I745":7 %p297};
//   %p298 = (398, 20);
//   %wire_993 = &"net73" @WIRE(mode="straight") {%p298 #"I1597":6};
//   %wire_994 = &"net73" @WIRE(mode="straight") {%p298 %p297};
//   %wire_995 = &"net74" @WIRE(mode="straight") {#"I745":10 #"I1597":10};
//   %wire_996 = &"net74" @WIRE(mode="straight") {#"I1607":10 %marker_885};
//   %wire_997 = &"net74" @WIRE(mode="straight") {#"I1597":10 #"I1607":10};
//   %p299 = (392, -748);
//   %wire_998 = &"net74" @WIRE(mode="straight") {%p299 #"I1634":3};
//   %wire_999 = &"net74" @WIRE(mode="straight") {%p299 #"I1430":10};
//   %wire_1000 = &"net74" @WIRE(mode="straight") {#"I1183":10 #"I1413":10};
//   %wire_1001 = &"net74" @WIRE(mode="straight") {#"I1143":10 #"I1396":10};
//   %wire_1002 = &"net74" @WIRE(mode="straight") {#"I1379":10 #"I1063":10};
//   %wire_1003 = &"net74" @WIRE(mode="straight") {#"I1345":10 #"I983":10};
//   %wire_1004 = &"net74" @WIRE(mode="straight") {#"I903":10 #"I1294":10};
//   %wire_1005 = &"net74" @WIRE(mode="straight") {#"I943":10 #"I1311":10};
//   %wire_1006 = &"net74" @WIRE(mode="straight") {#"I1396":10 #"I1103":10};
//   %wire_1007 = &"net74" @WIRE(mode="straight") {#"I823":10 #"I783":10};
//   %wire_1008 = &"net74" @WIRE(mode="straight") {#"I783":10 #"I745":10};
//   %wire_1009 = &"net74" @WIRE(mode="straight") {#"I863":10 #"I1277":10};
//   %wire_1010 = &"net74" @WIRE(mode="straight") {#"I1362":10 #"I1023":10};
//   %wire_1011 = &"net74" @WIRE(mode="straight") {#"I1311":10 #"I903":10};
//   %wire_1012 = &"net74" @WIRE(mode="straight") {#"I1294":10 #"I863":10};
//   %wire_1013 = &"net74" @WIRE(mode="straight") {#"I1277":10 #"I823":10};
//   %wire_1014 = &"net74" @WIRE(mode="straight") {#"I1430":10 #"I1183":10};
//   %wire_1015 = &"net74" @WIRE(mode="straight") {#"I1023":10 #"I1345":10};
//   %wire_1016 = &"net74" @WIRE(mode="straight") {#"I1413":10 #"I1143":10};
//   %wire_1017 = &"net74" @WIRE(mode="straight") {#"I1103":10 #"I1379":10};
//   %wire_1018 = &"net74" @WIRE(mode="straight") {#"I1328":10 #"I943":10};
//   %wire_1019 = &"net74" @WIRE(mode="straight") {#"I1063":10 #"I1362":10};
//   %wire_1020 = &"net74" @WIRE(mode="straight") {#"I983":10 #"I1328":10};
//   %p300 = (36, -19);
//   %wire_1021 = &"net60" @WIRE(mode="straight") {#"I771":6 %p300};
//   %p301 = (82, -19);
//   %wire_1022 = &"net60" @WIRE(mode="straight") {#"I773":3 %p301};
//   %p302 = (62, -17);
//   %wire_1023 = &"net60" @WIRE(mode="straight") {%p301 %p302};
//   %wire_1024 = &"net60" @WIRE(mode="straight") {#"I772":7 %p302};
//   %wire_1025 = &"net60" @WIRE(mode="straight") {%p300 %p302};
//   %p303 = (38, 16);
//   %wire_1026 = &"net76" @WIRE(mode="straight") {#"I437":7 %p303};
//   %p304 = (58, 16);
//   %wire_1027 = &"net76" @WIRE(mode="straight") {%p303 %p304};
//   %p305 = (60, 16);
//   %wire_1028 = &"net76" @WIRE(mode="straight") {%p304 %p305};
//   %wire_1029 = &"net76" @WIRE(mode="straight") {#"I459":3 %p304};
//   %wire_1030 = &"net76" @WIRE(mode="straight") {#"I459":6 %p305};
//   %wire_1031 = &"net78" @WIRE(mode="straight") {#"I459":1 #"I1547":1};
//   %wire_1032 = &"net78" @WIRE(mode="straight") {#"I1555":1 %marker_711};
//   %wire_1033 = &"net78" @WIRE(mode="straight") {#"I1547":1 #"I1555":1};
//   %wire_1034 = &"net78" @WIRE(mode="straight") {#"I1193":3 #"I1415":1};
//   %wire_1035 = &"net78" @WIRE(mode="straight") {#"I1161":1 #"I1398":1};
//   %wire_1036 = &"net78" @WIRE(mode="straight") {#"I841":1 #"I1262":1};
//   %wire_1037 = &"net78" @WIRE(mode="straight") {#"I1313":1 #"I921":1};
//   %wire_1038 = &"net78" @WIRE(mode="straight") {#"I1262":1 #"I801":1};
//   %wire_1039 = &"net78" @WIRE(mode="straight") {#"I1081":1 #"I1364":1};
//   %wire_1040 = &"net78" @WIRE(mode="straight") {#"I1121":1 #"I1381":1};
//   %wire_1041 = &"net78" @WIRE(mode="straight") {#"I801":1 #"I772":1};
//   %wire_1042 = &"net78" @WIRE(mode="straight") {#"I1364":1 #"I1041":1};
//   %wire_1043 = &"net78" @WIRE(mode="straight") {#"I1415":1 #"I1161":1};
//   %wire_1044 = &"net78" @WIRE(mode="straight") {#"I1398":1 #"I1121":1};
//   %wire_1045 = &"net78" @WIRE(mode="straight") {#"I772":1 #"I459":1};
//   %wire_1046 = &"net78" @WIRE(mode="straight") {#"I1296":1 #"I881":1};
//   %wire_1047 = &"net78" @WIRE(mode="straight") {#"I1279":1 #"I841":1};
//   %wire_1048 = &"net78" @WIRE(mode="straight") {#"I1330":1 #"I961":1};
//   %wire_1049 = &"net78" @WIRE(mode="straight") {#"I881":1 #"I1279":1};
//   %wire_1050 = &"net78" @WIRE(mode="straight") {#"I1041":1 #"I1347":1};
//   %wire_1051 = &"net78" @WIRE(mode="straight") {#"I1001":1 #"I1330":1};
//   %wire_1052 = &"net78" @WIRE(mode="straight") {#"I1381":1 #"I1081":1};
//   %wire_1053 = &"net78" @WIRE(mode="straight") {#"I921":1 #"I1296":1};
//   %wire_1054 = &"net78" @WIRE(mode="straight") {#"I961":1 #"I1313":1};
//   %wire_1055 = &"net78" @WIRE(mode="straight") {#"I1347":1 #"I1001":1};
//   %p306 = (84, 16);
//   %wire_1056 = &"net83" @WIRE(mode="straight") {#"I481":6 %p306};
//   %p307 = (62, 16);
//   %p308 = (82, 16);
//   %wire_1057 = &"net83" @WIRE(mode="straight") {%p307 %p308};
//   %wire_1058 = &"net83" @WIRE(mode="straight") {%p308 %p306};
//   %wire_1059 = &"net83" @WIRE(mode="straight") {#"I481":3 %p308};
//   %wire_1060 = &"net83" @WIRE(mode="straight") {#"I459":7 %p307};
//   %wire_1061 = &"net84" @WIRE(mode="straight") {#"I459":10 #"I1547":10};
//   %wire_1062 = &"net84" @WIRE(mode="straight") {#"I1555":10 %marker_1005};
//   %wire_1063 = &"net84" @WIRE(mode="straight") {#"I1547":10 #"I1555":10};
//   %p309 = (54, -748);
//   %wire_1064 = &"net84" @WIRE(mode="straight") {%p309 #"I1415":10};
//   %wire_1065 = &"net84" @WIRE(mode="straight") {#"I1161":10 #"I1398":10};
//   %wire_1066 = &"net84" @WIRE(mode="straight") {#"I1001":10 #"I1330":10};
//   %wire_1067 = &"net84" @WIRE(mode="straight") {#"I1347":10 #"I1001":10};
//   %wire_1068 = &"net84" @WIRE(mode="straight") {%p309 #"I1622":3};
//   %wire_1069 = &"net84" @WIRE(mode="straight") {#"I1313":10 #"I921":10};
//   %wire_1070 = &"net84" @WIRE(mode="straight") {#"I1041":10 #"I1347":10};
//   %wire_1071 = &"net84" @WIRE(mode="straight") {#"I1262":10 #"I801":10};
//   %wire_1072 = &"net84" @WIRE(mode="straight") {#"I801":10 #"I772":10};
//   %wire_1073 = &"net84" @WIRE(mode="straight") {#"I841":10 #"I1262":10};
//   %wire_1074 = &"net84" @WIRE(mode="straight") {#"I1398":10 #"I1121":10};
//   %wire_1075 = &"net84" @WIRE(mode="straight") {#"I881":10 #"I1279":10};
//   %wire_1076 = &"net84" @WIRE(mode="straight") {#"I772":10 #"I459":10};
//   %wire_1077 = &"net84" @WIRE(mode="straight") {#"I1330":10 #"I961":10};
//   %wire_1078 = &"net84" @WIRE(mode="straight") {#"I1279":10 #"I841":10};
//   %wire_1079 = &"net84" @WIRE(mode="straight") {#"I1081":10 #"I1364":10};
//   %wire_1080 = &"net84" @WIRE(mode="straight") {#"I1121":10 #"I1381":10};
//   %wire_1081 = &"net84" @WIRE(mode="straight") {#"I1364":10 #"I1041":10};
//   %wire_1082 = &"net84" @WIRE(mode="straight") {#"I921":10 #"I1296":10};
//   %wire_1083 = &"net84" @WIRE(mode="straight") {#"I1415":10 #"I1161":10};
//   %wire_1084 = &"net84" @WIRE(mode="straight") {#"I1381":10 #"I1081":10};
//   %wire_1085 = &"net84" @WIRE(mode="straight") {#"I961":10 #"I1313":10};
//   %wire_1086 = &"net84" @WIRE(mode="straight") {#"I1296":10 #"I881":10};
//   %wire_1087 = &"net26" @WIRE(mode="straight") {#"I774":1 #"I1432":3};
//   %wire_1088 = &"net88" @WIRE(mode="straight") {#"I481":1 #"I1548":1};
//   %wire_1089 = &"net88" @WIRE(mode="straight") {#"I1556":1 %marker_921};
//   %wire_1090 = &"net88" @WIRE(mode="straight") {#"I1548":1 #"I1556":1};
//   %wire_1091 = &"net88" @WIRE(mode="straight") {#"I1195":3 #"I1414":1};
//   %wire_1092 = &"net88" @WIRE(mode="straight") {#"I1162":1 #"I1397":1};
//   %wire_1093 = &"net88" @WIRE(mode="straight") {#"I842":1 #"I1261":1};
//   %wire_1094 = &"net88" @WIRE(mode="straight") {#"I1082":1 #"I1363":1};
//   %wire_1095 = &"net88" @WIRE(mode="straight") {#"I1363":1 #"I1042":1};
//   %wire_1096 = &"net88" @WIRE(mode="straight") {#"I1295":1 #"I882":1};
//   %wire_1097 = &"net88" @WIRE(mode="straight") {#"I1380":1 #"I1082":1};
//   %wire_1098 = &"net88" @WIRE(mode="straight") {#"I1329":1 #"I962":1};
//   %wire_1099 = &"net88" @WIRE(mode="straight") {#"I1261":1 #"I802":1};
//   %wire_1100 = &"net88" @WIRE(mode="straight") {#"I1042":1 #"I1346":1};
//   %wire_1101 = &"net88" @WIRE(mode="straight") {#"I1414":1 #"I1162":1};
//   %wire_1102 = &"net88" @WIRE(mode="straight") {#"I882":1 #"I1278":1};
//   %wire_1103 = &"net88" @WIRE(mode="straight") {#"I1397":1 #"I1122":1};
//   %wire_1104 = &"net88" @WIRE(mode="straight") {#"I773":1 #"I481":1};
//   %wire_1105 = &"net88" @WIRE(mode="straight") {#"I1346":1 #"I1002":1};
//   %wire_1106 = &"net88" @WIRE(mode="straight") {#"I1002":1 #"I1329":1};
//   %wire_1107 = &"net88" @WIRE(mode="straight") {#"I922":1 #"I1295":1};
//   %wire_1108 = &"net88" @WIRE(mode="straight") {#"I1122":1 #"I1380":1};
//   %wire_1109 = &"net88" @WIRE(mode="straight") {#"I802":1 #"I773":1};
//   %wire_1110 = &"net88" @WIRE(mode="straight") {#"I1278":1 #"I842":1};
//   %wire_1111 = &"net88" @WIRE(mode="straight") {#"I962":1 #"I1312":1};
//   %wire_1112 = &"net88" @WIRE(mode="straight") {#"I1312":1 #"I922":1};
//   %p310 = (86, 16);
//   %p311 = (120, 16);
//   %wire_1113 = &"net93" @WIRE(mode="straight") {%p310 %p311};
//   %p312 = (122, 16);
//   %wire_1114 = &"net93" @WIRE(mode="straight") {#"I503":6 %p312};
//   %wire_1115 = &"net93" @WIRE(mode="straight") {#"I481":7 %p310};
//   %wire_1116 = &"net93" @WIRE(mode="straight") {#"I503":3 %p311};
//   %wire_1117 = &"net93" @WIRE(mode="straight") {%p311 %p312};
//   %wire_1118 = &"net94" @WIRE(mode="straight") {#"I481":10 #"I1548":10};
//   %wire_1119 = &"net94" @WIRE(mode="straight") {#"I1556":10 %marker_948};
//   %wire_1120 = &"net94" @WIRE(mode="straight") {#"I1548":10 #"I1556":10};
//   %p313 = (78, -748);
//   %wire_1121 = &"net94" @WIRE(mode="straight") {%p313 #"I1414":10};
//   %wire_1122 = &"net94" @WIRE(mode="straight") {#"I1162":10 #"I1397":10};
//   %wire_1123 = &"net94" @WIRE(mode="straight") {%p313 #"I1623":3};
//   %wire_1124 = &"net94" @WIRE(mode="straight") {#"I1082":10 #"I1363":10};
//   %wire_1125 = &"net94" @WIRE(mode="straight") {#"I1397":10 #"I1122":10};
//   %wire_1126 = &"net94" @WIRE(mode="straight") {#"I1380":10 #"I1082":10};
//   %wire_1127 = &"net94" @WIRE(mode="straight") {#"I802":10 #"I773":10};
//   %wire_1128 = &"net94" @WIRE(mode="straight") {#"I882":10 #"I1278":10};
//   %wire_1129 = &"net94" @WIRE(mode="straight") {#"I1414":10 #"I1162":10};
//   %wire_1130 = &"net94" @WIRE(mode="straight") {#"I1002":10 #"I1329":10};
//   %wire_1131 = &"net94" @WIRE(mode="straight") {#"I1295":10 #"I882":10};
//   %wire_1132 = &"net94" @WIRE(mode="straight") {#"I1329":10 #"I962":10};
//   %wire_1133 = &"net94" @WIRE(mode="straight") {#"I1363":10 #"I1042":10};
//   %wire_1134 = &"net94" @WIRE(mode="straight") {#"I1261":10 #"I802":10};
//   %wire_1135 = &"net94" @WIRE(mode="straight") {#"I773":10 #"I481":10};
//   %wire_1136 = &"net94" @WIRE(mode="straight") {#"I1346":10 #"I1002":10};
//   %wire_1137 = &"net94" @WIRE(mode="straight") {#"I1312":10 #"I922":10};
//   %wire_1138 = &"net94" @WIRE(mode="straight") {#"I922":10 #"I1295":10};
//   %wire_1139 = &"net94" @WIRE(mode="straight") {#"I1042":10 #"I1346":10};
//   %wire_1140 = &"net94" @WIRE(mode="straight") {#"I1278":10 #"I842":10};
//   %wire_1141 = &"net94" @WIRE(mode="straight") {#"I842":10 #"I1261":10};
//   %wire_1142 = &"net94" @WIRE(mode="straight") {#"I962":10 #"I1312":10};
//   %wire_1143 = &"net94" @WIRE(mode="straight") {#"I1122":10 #"I1380":10};
//   %p314 = (118, -15);
//   %p315 = (142, -15);
//   %wire_1144 = &"net25" @WIRE(mode="straight") {%p314 %p315};
//   %p316 = (370, -15);
//   %p317 = (394, -15);
//   %wire_1145 = &"net25" @WIRE(mode="straight") {%p316 %p317};
//   %p318 = (32, -15);
//   %wire_1146 = &"net25" @WIRE(mode="straight") {#"I771":9 %p318};
//   %p319 = (346, -15);
//   %wire_1147 = &"net25" @WIRE(mode="straight") {%p319 %p316};
//   %wire_1148 = &"net25" @WIRE(mode="straight") {#"I784":9 %p316};
//   %p320 = (226, -15);
//   %p321 = (250, -15);
//   %wire_1149 = &"net25" @WIRE(mode="straight") {%p320 %p321};
//   %wire_1150 = &"net25" @WIRE(mode="straight") {#"I785":9 %p319};
//   %p322 = (190, -15);
//   %wire_1151 = &"net25" @WIRE(mode="straight") {#"I778":9 %p322};
//   %p323 = (298, -15);
//   %p324 = (322, -15);
//   %wire_1152 = &"net25" @WIRE(mode="straight") {%p323 %p324};
//   %p325 = (274, -15);
//   %wire_1153 = &"net25" @WIRE(mode="straight") {%p321 %p325};
//   %wire_1154 = &"net25" @WIRE(mode="straight") {#"I788":9 %p325};
//   %wire_1155 = &"net25" @WIRE(mode="straight") {#"I780":9 %p315};
//   %p326 = (56, -15);
//   %wire_1156 = &"net25" @WIRE(mode="straight") {%p318 %p326};
//   %p327 = (8, -15);
//   %wire_1157 = &"net25" @WIRE(mode="straight") {#"I770":9 %p327};
//   %wire_1158 = &"net25" @WIRE(mode="straight") {#"I783":9 %p317};
//   %wire_1159 = &"net25" @WIRE(mode="straight") {#"I777":9 %p320};
//   %p328 = (10, -15);
//   %wire_1160 = &"net25" @WIRE(mode="straight") {%p328 %p318};
//   %wire_1161 = &"net25" @WIRE(mode="straight") {#"I776":9 %p321};
//   %wire_1162 = &"net25" @WIRE(mode="straight") {#"I781":9 %p314};
//   %p329 = (80, -15);
//   %wire_1163 = &"net25" @WIRE(mode="straight") {%p329 %p314};
//   %wire_1164 = &"net25" @WIRE(mode="straight") {%p326 %p329};
//   %wire_1165 = &"net25" @WIRE(mode="straight") {#"I772":9 %p326};
//   %wire_1166 = &"net25" @WIRE(mode="straight") {%p327 %p328};
//   %wire_1167 = &"net25" @WIRE(mode="straight") {%p324 %p319};
//   %wire_1168 = &"net25" @WIRE(mode="straight") {#"I786":9 %p324};
//   %p330 = (166, -15);
//   %wire_1169 = &"net25" @WIRE(mode="straight") {%p330 %p322};
//   %wire_1170 = &"net25" @WIRE(mode="straight") {#"I770":3 %p328};
//   %wire_1171 = &"net25" @WIRE(mode="straight") {%p315 %p330};
//   %wire_1172 = &"net25" @WIRE(mode="straight") {#"I779":9 %p330};
//   %wire_1173 = &"net25" @WIRE(mode="straight") {#"I773":9 %p329};
//   %wire_1174 = &"net25" @WIRE(mode="straight") {%p325 %p323};
//   %wire_1175 = &"net25" @WIRE(mode="straight") {#"I787":9 %p323};
//   %wire_1176 = &"net25" @WIRE(mode="straight") {%p322 %p320};
//   %wire_1177 = &"net98" @WIRE(mode="straight") {#"I1575":1 %marker_605};
//   %wire_1178 = &"net98" @WIRE(mode="straight") {#"I1572":1 #"I1575":1};
//   %wire_1179 = &"net98" @WIRE(mode="straight") {#"I1197":3 #"I1419":1};
//   %wire_1180 = &"net98" @WIRE(mode="straight") {#"I1174":1 #"I1402":1};
//   %wire_1181 = &"net98" @WIRE(mode="straight") {#"I1402":1 #"I1134":1};
//   %wire_1182 = &"net98" @WIRE(mode="straight") {#"I974":1 #"I1317":1};
//   %wire_1183 = &"net98" @WIRE(mode="straight") {#"I1317":1 #"I934":1};
//   %wire_1184 = &"net98" @WIRE(mode="straight") {#"I1054":1 #"I1351":1};
//   %wire_1185 = &"net98" @WIRE(mode="straight") {#"I1283":1 #"I854":1};
//   %wire_1186 = &"net98" @WIRE(mode="straight") {#"I1385":1 #"I1094":1};
//   %wire_1187 = &"net98" @WIRE(mode="straight") {#"I1094":1 #"I1368":1};
//   %wire_1188 = &"net98" @WIRE(mode="straight") {#"I854":1 #"I1266":1};
//   %wire_1189 = &"net98" @WIRE(mode="straight") {#"I934":1 #"I1300":1};
//   %wire_1190 = &"net98" @WIRE(mode="straight") {#"I1300":1 #"I894":1};
//   %wire_1191 = &"net98" @WIRE(mode="straight") {#"I814":1 #"I781":1};
//   %wire_1192 = &"net98" @WIRE(mode="straight") {#"I1334":1 #"I974":1};
//   %wire_1193 = &"net98" @WIRE(mode="straight") {#"I503":1 #"I1572":1};
//   %wire_1194 = &"net98" @WIRE(mode="straight") {#"I1014":1 #"I1334":1};
//   %wire_1195 = &"net98" @WIRE(mode="straight") {#"I781":1 #"I503":1};
//   %wire_1196 = &"net98" @WIRE(mode="straight") {#"I894":1 #"I1283":1};
//   %wire_1197 = &"net98" @WIRE(mode="straight") {#"I1351":1 #"I1014":1};
//   %wire_1198 = &"net98" @WIRE(mode="straight") {#"I1266":1 #"I814":1};
//   %wire_1199 = &"net98" @WIRE(mode="straight") {#"I1134":1 #"I1385":1};
//   %wire_1200 = &"net98" @WIRE(mode="straight") {#"I1419":1 #"I1174":1};
//   %wire_1201 = &"net98" @WIRE(mode="straight") {#"I1368":1 #"I1054":1};
//   %p331 = (144, 16);
//   %wire_1202 = &"net103" @WIRE(mode="straight") {#"I525":3 %p331};
//   %p332 = (146, 16);
//   %wire_1203 = &"net103" @WIRE(mode="straight") {%p331 %p332};
//   %p333 = (124, 16);
//   %wire_1204 = &"net103" @WIRE(mode="straight") {%p333 %p331};
//   %wire_1205 = &"net103" @WIRE(mode="straight") {#"I525":6 %p332};
//   %wire_1206 = &"net103" @WIRE(mode="straight") {#"I503":7 %p333};
//   %wire_1207 = &"net104" @WIRE(mode="straight") {#"I1575":10 %marker_915};
//   %wire_1208 = &"net104" @WIRE(mode="straight") {#"I1572":10 #"I1575":10};
//   %p334 = (116, -748);
//   %wire_1209 = &"net104" @WIRE(mode="straight") {%p334 #"I1419":10};
//   %wire_1210 = &"net104" @WIRE(mode="straight") {#"I1174":10 #"I1402":10};
//   %wire_1211 = &"net104" @WIRE(mode="straight") {#"I1351":10 #"I1014":10};
//   %wire_1212 = &"net104" @WIRE(mode="straight") {#"I1402":10 #"I1134":10};
//   %wire_1213 = &"net104" @WIRE(mode="straight") {#"I974":10 #"I1317":10};
//   %wire_1214 = &"net104" @WIRE(mode="straight") {#"I1317":10 #"I934":10};
//   %wire_1215 = &"net104" @WIRE(mode="straight") {%p334 #"I1624":3};
//   %wire_1216 = &"net104" @WIRE(mode="straight") {#"I1334":10 #"I974":10};
//   %wire_1217 = &"net104" @WIRE(mode="straight") {#"I1094":10 #"I1368":10};
//   %wire_1218 = &"net104" @WIRE(mode="straight") {#"I1266":10 #"I814":10};
//   %wire_1219 = &"net104" @WIRE(mode="straight") {#"I934":10 #"I1300":10};
//   %wire_1220 = &"net104" @WIRE(mode="straight") {#"I854":10 #"I1266":10};
//   %wire_1221 = &"net104" @WIRE(mode="straight") {#"I503":10 #"I1572":10};
//   %wire_1222 = &"net104" @WIRE(mode="straight") {#"I1300":10 #"I894":10};
//   %wire_1223 = &"net104" @WIRE(mode="straight") {#"I894":10 #"I1283":10};
//   %wire_1224 = &"net104" @WIRE(mode="straight") {#"I1385":10 #"I1094":10};
//   %wire_1225 = &"net104" @WIRE(mode="straight") {#"I1419":10 #"I1174":10};
//   %wire_1226 = &"net104" @WIRE(mode="straight") {#"I1054":10 #"I1351":10};
//   %wire_1227 = &"net104" @WIRE(mode="straight") {#"I814":10 #"I781":10};
//   %wire_1228 = &"net104" @WIRE(mode="straight") {#"I781":10 #"I503":10};
//   %wire_1229 = &"net104" @WIRE(mode="straight") {#"I1014":10 #"I1334":10};
//   %wire_1230 = &"net104" @WIRE(mode="straight") {#"I1283":10 #"I854":10};
//   %wire_1231 = &"net104" @WIRE(mode="straight") {#"I1134":10 #"I1385":10};
//   %wire_1232 = &"net104" @WIRE(mode="straight") {#"I1368":10 #"I1054":10};
//   %p335 = (12, -477);
//   %wire_1233 = &"net2285" @WIRE(mode="straight") {#"I1039":6 %p335};
//   %wire_1234 = &"net2285" @WIRE(mode="straight") {#"M80":2 %p335};
//   %wire_1235 = &"net2285" @WIRE(mode="straight") {#"I1517":3 #"M80":2};
//   %wire_1236 = &"net108" @WIRE(mode="straight") {#"I1576":1 %marker_718};
//   %wire_1237 = &"net108" @WIRE(mode="straight") {#"I1571":1 #"I1576":1};
//   %wire_1238 = &"net108" @WIRE(mode="straight") {#"I1267":1 #"I813":1};
//   %wire_1239 = &"net108" @WIRE(mode="straight") {#"I1202":3 #"I1420":1};
//   %wire_1240 = &"net108" @WIRE(mode="straight") {#"I1173":1 #"I1403":1};
//   %wire_1241 = &"net108" @WIRE(mode="straight") {#"I1284":1 #"I853":1};
//   %wire_1242 = &"net108" @WIRE(mode="straight") {#"I1093":1 #"I1369":1};
//   %wire_1243 = &"net108" @WIRE(mode="straight") {#"I973":1 #"I1318":1};
//   %wire_1244 = &"net108" @WIRE(mode="straight") {#"I813":1 #"I780":1};
//   %wire_1245 = &"net108" @WIRE(mode="straight") {#"I1053":1 #"I1352":1};
//   %wire_1246 = &"net108" @WIRE(mode="straight") {#"I1013":1 #"I1335":1};
//   %wire_1247 = &"net108" @WIRE(mode="straight") {#"I853":1 #"I1267":1};
//   %wire_1248 = &"net108" @WIRE(mode="straight") {#"I525":1 #"I1571":1};
//   %wire_1249 = &"net108" @WIRE(mode="straight") {#"I1352":1 #"I1013":1};
//   %wire_1250 = &"net108" @WIRE(mode="straight") {#"I1386":1 #"I1093":1};
//   %wire_1251 = &"net108" @WIRE(mode="straight") {#"I1335":1 #"I973":1};
//   %wire_1252 = &"net108" @WIRE(mode="straight") {#"I1403":1 #"I1133":1};
//   %wire_1253 = &"net108" @WIRE(mode="straight") {#"I893":1 #"I1284":1};
//   %wire_1254 = &"net108" @WIRE(mode="straight") {#"I1133":1 #"I1386":1};
//   %wire_1255 = &"net108" @WIRE(mode="straight") {#"I1369":1 #"I1053":1};
//   %wire_1256 = &"net108" @WIRE(mode="straight") {#"I1420":1 #"I1173":1};
//   %wire_1257 = &"net108" @WIRE(mode="straight") {#"I780":1 #"I525":1};
//   %wire_1258 = &"net108" @WIRE(mode="straight") {#"I1318":1 #"I933":1};
//   %wire_1259 = &"net108" @WIRE(mode="straight") {#"I933":1 #"I1301":1};
//   %wire_1260 = &"net108" @WIRE(mode="straight") {#"I1301":1 #"I893":1};
//   %wire_1261 = &"net114" @WIRE(mode="straight") {#"I1576":10 %marker_763};
//   %wire_1262 = &"net114" @WIRE(mode="straight") {#"I1571":10 #"I1576":10};
//   %p336 = (140, -748);
//   %wire_1263 = &"net114" @WIRE(mode="straight") {%p336 #"I1625":3};
//   %wire_1264 = &"net114" @WIRE(mode="straight") {%p336 #"I1420":10};
//   %wire_1265 = &"net114" @WIRE(mode="straight") {#"I1173":10 #"I1403":10};
//   %wire_1266 = &"net114" @WIRE(mode="straight") {#"I1369":10 #"I1053":10};
//   %wire_1267 = &"net114" @WIRE(mode="straight") {#"I1420":10 #"I1173":10};
//   %wire_1268 = &"net114" @WIRE(mode="straight") {#"I973":10 #"I1318":10};
//   %wire_1269 = &"net114" @WIRE(mode="straight") {#"I813":10 #"I780":10};
//   %wire_1270 = &"net114" @WIRE(mode="straight") {#"I1013":10 #"I1335":10};
//   %wire_1271 = &"net114" @WIRE(mode="straight") {#"I853":10 #"I1267":10};
//   %wire_1272 = &"net114" @WIRE(mode="straight") {#"I1284":10 #"I853":10};
//   %wire_1273 = &"net114" @WIRE(mode="straight") {#"I525":10 #"I1571":10};
//   %wire_1274 = &"net114" @WIRE(mode="straight") {#"I1352":10 #"I1013":10};
//   %wire_1275 = &"net114" @WIRE(mode="straight") {#"I1403":10 #"I1133":10};
//   %wire_1276 = &"net114" @WIRE(mode="straight") {#"I1386":10 #"I1093":10};
//   %wire_1277 = &"net114" @WIRE(mode="straight") {#"I1318":10 #"I933":10};
//   %wire_1278 = &"net114" @WIRE(mode="straight") {#"I1267":10 #"I813":10};
//   %wire_1279 = &"net114" @WIRE(mode="straight") {#"I1093":10 #"I1369":10};
//   %wire_1280 = &"net114" @WIRE(mode="straight") {#"I1335":10 #"I973":10};
//   %wire_1281 = &"net114" @WIRE(mode="straight") {#"I1133":10 #"I1386":10};
//   %wire_1282 = &"net114" @WIRE(mode="straight") {#"I780":10 #"I525":10};
//   %wire_1283 = &"net114" @WIRE(mode="straight") {#"I893":10 #"I1284":10};
//   %wire_1284 = &"net114" @WIRE(mode="straight") {#"I1053":10 #"I1352":10};
//   %wire_1285 = &"net114" @WIRE(mode="straight") {#"I933":10 #"I1301":10};
//   %wire_1286 = &"net114" @WIRE(mode="straight") {#"I1301":10 #"I893":10};
//   %p337 = (302, -19);
//   %p338 = (328, -17);
//   %wire_1287 = &"net47" @WIRE(mode="straight") {%p337 %p338};
//   %p339 = (348, -19);
//   %wire_1288 = &"net47" @WIRE(mode="straight") {%p339 %p338};
//   %wire_1289 = &"net47" @WIRE(mode="straight") {#"I787":6 %p337};
//   %wire_1290 = &"net47" @WIRE(mode="straight") {#"I786":7 %p338};
//   %wire_1291 = &"net47" @WIRE(mode="straight") {#"I785":3 %p339};
//   %p340 = (326, -19);
//   %wire_1292 = &"net49" @WIRE(mode="straight") {#"I786":6 %p340};
//   %p341 = (352, -17);
//   %wire_1293 = &"net49" @WIRE(mode="straight") {%p340 %p341};
//   %wire_1294 = &"net49" @WIRE(mode="straight") {#"I785":7 %p341};
//   %p342 = (372, -19);
//   %wire_1295 = &"net49" @WIRE(mode="straight") {#"I784":3 %p342};
//   %wire_1296 = &"net49" @WIRE(mode="straight") {%p342 %p341};
//   %p343 = (304, -17);
//   %wire_1297 = &"net50" @WIRE(mode="straight") {#"I787":7 %p343};
//   %p344 = (278, -19);
//   %wire_1298 = &"net50" @WIRE(mode="straight") {#"I788":6 %p344};
//   %wire_1299 = &"net50" @WIRE(mode="straight") {%p344 %p343};
//   %p345 = (324, -19);
//   %wire_1300 = &"net50" @WIRE(mode="straight") {%p345 %p343};
//   %wire_1301 = &"net50" @WIRE(mode="straight") {#"I786":3 %p345};
//   %p346 = (38, -17);
//   %wire_1302 = &"net56" @WIRE(mode="straight") {#"I771":7 %p346};
//   %p347 = (58, -19);
//   %wire_1303 = &"net56" @WIRE(mode="straight") {#"I772":3 %p347};
//   %wire_1304 = &"net56" @WIRE(mode="straight") {%p347 %p346};
//   %p348 = (12, -19);
//   %wire_1305 = &"net56" @WIRE(mode="straight") {#"I770":6 %p348};
//   %wire_1306 = &"net56" @WIRE(mode="straight") {%p348 %p346};
//   %p349 = (-4, -17);
//   %wire_1307 = &"net126" @WIRE(mode="straight") {#"I1461":1 %p349};
//   %p350 = (14, -17);
//   %wire_1308 = &"net126" @WIRE(mode="straight") {#"I770":7 %p350};
//   %p351 = (34, -19);
//   %wire_1309 = &"net126" @WIRE(mode="straight") {#"I771":3 %p351};
//   %wire_1310 = &"net126" @WIRE(mode="straight") {%p349 %p350};
//   %wire_1311 = &"net126" @WIRE(mode="straight") {%p351 %p350};
//   %p352 = (441, -732);
//   %wire_1312 = &"net10" @WIRE(mode="straight") {#"I1431":2 %p352};
//   %wire_1313 = &"net10" @WIRE(mode="straight") {%p352 #"I1260":2};
//   %p353 = (172, -17);
//   %wire_1314 = &"net30" @WIRE(mode="straight") {#"I779":7 %p353};
//   %p354 = (192, -19);
//   %wire_1315 = &"net30" @WIRE(mode="straight") {#"I778":3 %p354};
//   %wire_1316 = &"net30" @WIRE(mode="straight") {%p354 %p353};
//   %p355 = (146, -19);
//   %wire_1317 = &"net30" @WIRE(mode="straight") {%p355 %p353};
//   %wire_1318 = &"net30" @WIRE(mode="straight") {#"I780":6 %p355};
//   %p356 = (36, 16);
//   %wire_1319 = &"net133" @WIRE(mode="straight") {#"I437":6 %p356};
//   %p357 = (34, 16);
//   %wire_1320 = &"net133" @WIRE(mode="straight") {%p357 %p356};
//   %p358 = (14, 16);
//   %wire_1321 = &"net133" @WIRE(mode="straight") {#"I415":7 %p358};
//   %wire_1322 = &"net133" @WIRE(mode="straight") {%p358 %p357};
//   %wire_1323 = &"net133" @WIRE(mode="straight") {#"I437":3 %p357};
//   %wire_1324 = &"net29" @WIRE(mode="straight") {#"I1432":1 #"I769":2};
//   %p359 = (-4, -43);
//   %p360 = (14, -43);
//   %wire_1325 = &"net21" @WIRE(mode="straight") {%p359 %p360};
//   %p361 = (172, -43);
//   %wire_1326 = &"net21" @WIRE(mode="straight") {%p361 #"I779":5};
//   %p362 = (280, -43);
//   %p363 = (304, -43);
//   %wire_1327 = &"net21" @WIRE(mode="straight") {%p362 %p363};
//   %wire_1328 = &"net21" @WIRE(mode="straight") {%p359 #"I1461":2};
//   %p364 = (256, -43);
//   %wire_1329 = &"net21" @WIRE(mode="straight") {%p364 #"I776":5};
//   %wire_1330 = &"net21" @WIRE(mode="straight") {%p362 #"I788":5};
//   %p365 = (400, -43);
//   %wire_1331 = &"net21" @WIRE(mode="straight") {%p365 #"I783":5};
//   %p366 = (328, -43);
//   %wire_1332 = &"net21" @WIRE(mode="straight") {%p366 #"I786":5};
//   %p367 = (232, -43);
//   %wire_1333 = &"net21" @WIRE(mode="straight") {%p367 %p364};
//   %p368 = (86, -43);
//   %wire_1334 = &"net21" @WIRE(mode="straight") {%p368 #"I773":5};
//   %p369 = (148, -43);
//   %wire_1335 = &"net21" @WIRE(mode="straight") {%p369 #"I780":5};
//   %p370 = (38, -43);
//   %p371 = (62, -43);
//   %wire_1336 = &"net21" @WIRE(mode="straight") {%p370 %p371};
//   %wire_1337 = &"net21" @WIRE(mode="straight") {%p371 #"I772":5};
//   %wire_1338 = &"net21" @WIRE(mode="straight") {%p360 #"I770":5};
//   %wire_1339 = &"net21" @WIRE(mode="straight") {%p365 #"I782":2};
//   %p372 = (352, -43);
//   %wire_1340 = &"net21" @WIRE(mode="straight") {%p366 %p372};
//   %wire_1341 = &"net21" @WIRE(mode="straight") {%p372 #"I785":5};
//   %p373 = (196, -43);
//   %wire_1342 = &"net21" @WIRE(mode="straight") {%p361 %p373};
//   %wire_1343 = &"net21" @WIRE(mode="straight") {%p373 #"I778":5};
//   %wire_1344 = &"net21" @WIRE(mode="straight") {%p363 #"I787":5};
//   %wire_1345 = &"net21" @WIRE(mode="straight") {%p363 %p366};
//   %wire_1346 = &"net21" @WIRE(mode="straight") {%p370 #"I771":5};
//   %wire_1347 = &"net21" @WIRE(mode="straight") {%p367 #"I777":5};
//   %wire_1348 = &"net21" @WIRE(mode="straight") {%p364 %p362};
//   %wire_1349 = &"net21" @WIRE(mode="straight") {%p369 %p361};
//   %wire_1350 = &"net21" @WIRE(mode="straight") {%p360 %p370};
//   %wire_1351 = &"net21" @WIRE(mode="straight") {%p373 %p367};
//   %p374 = (124, -43);
//   %wire_1352 = &"net21" @WIRE(mode="straight") {%p374 #"I781":5};
//   %wire_1353 = &"net21" @WIRE(mode="straight") {%p368 %p374};
//   %wire_1354 = &"net21" @WIRE(mode="straight") {%p374 %p369};
//   %p375 = (376, -43);
//   %wire_1355 = &"net21" @WIRE(mode="straight") {%p375 %p365};
//   %wire_1356 = &"net21" @WIRE(mode="straight") {%p371 %p368};
//   %wire_1357 = &"net21" @WIRE(mode="straight") {%p375 #"I784":5};
//   %wire_1358 = &"net21" @WIRE(mode="straight") {%p372 %p375};
//   %wire_1359 = &"net140" @WIRE(mode="straight") {#"I1554":1 %marker_1151};
//   %wire_1360 = &"net140" @WIRE(mode="straight") {#"I1546":1 #"I1554":1};
//   %wire_1361 = &"net140" @WIRE(mode="straight") {#"I1191":3 #"I1416":1};
//   %wire_1362 = &"net140" @WIRE(mode="straight") {#"I1160":1 #"I1399":1};
//   %wire_1363 = &"net140" @WIRE(mode="straight") {#"I880":1 #"I1280":1};
//   %wire_1364 = &"net140" @WIRE(mode="straight") {#"I840":1 #"I1263":1};
//   %wire_1365 = &"net140" @WIRE(mode="straight") {#"I920":1 #"I1297":1};
//   %wire_1366 = &"net140" @WIRE(mode="straight") {#"I1280":1 #"I840":1};
//   %wire_1367 = &"net140" @WIRE(mode="straight") {#"I1263":1 #"I800":1};
//   %wire_1368 = &"net140" @WIRE(mode="straight") {#"I1348":1 #"I1000":1};
//   %wire_1369 = &"net140" @WIRE(mode="straight") {#"I1314":1 #"I920":1};
//   %wire_1370 = &"net140" @WIRE(mode="straight") {#"I800":1 #"I771":1};
//   %wire_1371 = &"net140" @WIRE(mode="straight") {#"I437":1 #"I1546":1};
//   %wire_1372 = &"net140" @WIRE(mode="straight") {#"I1040":1 #"I1348":1};
//   %wire_1373 = &"net140" @WIRE(mode="straight") {#"I1365":1 #"I1040":1};
//   %wire_1374 = &"net140" @WIRE(mode="straight") {#"I1399":1 #"I1120":1};
//   %wire_1375 = &"net140" @WIRE(mode="straight") {#"I1080":1 #"I1365":1};
//   %wire_1376 = &"net140" @WIRE(mode="straight") {#"I1331":1 #"I960":1};
//   %wire_1377 = &"net140" @WIRE(mode="straight") {#"I1382":1 #"I1080":1};
//   %wire_1378 = &"net140" @WIRE(mode="straight") {#"I1416":1 #"I1160":1};
//   %wire_1379 = &"net140" @WIRE(mode="straight") {#"I771":1 #"I437":1};
//   %wire_1380 = &"net140" @WIRE(mode="straight") {#"I960":1 #"I1314":1};
//   %wire_1381 = &"net140" @WIRE(mode="straight") {#"I1297":1 #"I880":1};
//   %wire_1382 = &"net140" @WIRE(mode="straight") {#"I1120":1 #"I1382":1};
//   %wire_1383 = &"net140" @WIRE(mode="straight") {#"I1000":1 #"I1331":1};
//   %wire_1384 = &"net425" @WIRE(mode="straight") {#"I1492":1 #"I1488":2};
//   %wire_1385 = &"net146" @WIRE(mode="straight") {#"I437":10 #"I1546":10};
//   %wire_1386 = &"net146" @WIRE(mode="straight") {#"I1554":10 %marker_943};
//   %wire_1387 = &"net146" @WIRE(mode="straight") {#"I1546":10 #"I1554":10};
//   %p376 = (30, -748);
//   %wire_1388 = &"net146" @WIRE(mode="straight") {%p376 #"I1416":10};
//   %wire_1389 = &"net146" @WIRE(mode="straight") {#"I1160":10 #"I1399":10};
//   %wire_1390 = &"net146" @WIRE(mode="straight") {#"I1080":10 #"I1365":10};
//   %wire_1391 = &"net146" @WIRE(mode="straight") {#"I1399":10 #"I1120":10};
//   %wire_1392 = &"net146" @WIRE(mode="straight") {#"I1280":10 #"I840":10};
//   %wire_1393 = &"net146" @WIRE(mode="straight") {%p376 #"I1621":3};
//   %wire_1394 = &"net146" @WIRE(mode="straight") {#"I1263":10 #"I800":10};
//   %wire_1395 = &"net146" @WIRE(mode="straight") {#"I1348":10 #"I1000":10};
//   %wire_1396 = &"net146" @WIRE(mode="straight") {#"I1314":10 #"I920":10};
//   %wire_1397 = &"net146" @WIRE(mode="straight") {#"I1382":10 #"I1080":10};
//   %wire_1398 = &"net146" @WIRE(mode="straight") {#"I771":10 #"I437":10};
//   %wire_1399 = &"net146" @WIRE(mode="straight") {#"I920":10 #"I1297":10};
//   %wire_1400 = &"net146" @WIRE(mode="straight") {#"I1120":10 #"I1382":10};
//   %wire_1401 = &"net146" @WIRE(mode="straight") {#"I1000":10 #"I1331":10};
//   %wire_1402 = &"net146" @WIRE(mode="straight") {#"I960":10 #"I1314":10};
//   %wire_1403 = &"net146" @WIRE(mode="straight") {#"I800":10 #"I771":10};
//   %wire_1404 = &"net146" @WIRE(mode="straight") {#"I1040":10 #"I1348":10};
//   %wire_1405 = &"net146" @WIRE(mode="straight") {#"I1365":10 #"I1040":10};
//   %wire_1406 = &"net146" @WIRE(mode="straight") {#"I1297":10 #"I880":10};
//   %wire_1407 = &"net146" @WIRE(mode="straight") {#"I1416":10 #"I1160":10};
//   %wire_1408 = &"net146" @WIRE(mode="straight") {#"I840":10 #"I1263":10};
//   %wire_1409 = &"net146" @WIRE(mode="straight") {#"I880":10 #"I1280":10};
//   %wire_1410 = &"net146" @WIRE(mode="straight") {#"I1331":10 #"I960":10};
//   %p377 = (205, -28);
//   %wire_1411 = &"net39" @WIRE(mode="straight") {%p377 #"M172":3};
//   %wire_1412 = &"net39" @WIRE(mode="straight") {#"I781":4 #"I780":4};
//   %wire_1413 = &"net39" @WIRE(mode="straight") {#"I779":4 #"I778":4};
//   %p378 = (107, -34);
//   %wire_1414 = &"net39" @WIRE(mode="straight") {#"M23":1 %p378};
//   %p379 = (107, -31);
//   %wire_1415 = &"net39" @WIRE(mode="straight") {%p378 %p379};
//   %wire_1416 = &"net39" @WIRE(mode="straight") {#"I780":4 #"I779":4};
//   %wire_1417 = &"net39" @WIRE(mode="straight") {%p379 #"M130":1};
//   %p380 = (205, -31);
//   %wire_1418 = &"net39" @WIRE(mode="straight") {#"M65":3 %p380};
//   %wire_1419 = &"net39" @WIRE(mode="straight") {%p380 %p377};
//   %wire_1420 = &"net39" @WIRE(mode="straight") {%p379 #"I781":4};
//   %wire_1421 = &"net39" @WIRE(mode="straight") {#"I778":4 %p380};
//   %wire_1422 = &"net150" @WIRE(mode="straight") {#"I1574":1 %marker_1000};
//   %wire_1423 = &"net150" @WIRE(mode="straight") {#"I1568":1 #"I1574":1};
//   %wire_1424 = &"net150" @WIRE(mode="straight") {#"I1212":3 #"I1423":1};
//   %wire_1425 = &"net150" @WIRE(mode="straight") {#"I1170":1 #"I1406":1};
//   %wire_1426 = &"net150" @WIRE(mode="straight") {#"I810":1 #"I777":1};
//   %wire_1427 = &"net150" @WIRE(mode="straight") {#"I1304":1 #"I890":1};
//   %wire_1428 = &"net150" @WIRE(mode="straight") {#"I930":1 #"I1304":1};
//   %wire_1429 = &"net150" @WIRE(mode="straight") {#"I1355":1 #"I1010":1};
//   %wire_1430 = &"net150" @WIRE(mode="straight") {#"I1406":1 #"I1130":1};
//   %wire_1431 = &"net150" @WIRE(mode="straight") {#"I1090":1 #"I1372":1};
//   %wire_1432 = &"net150" @WIRE(mode="straight") {#"I1287":1 #"I850":1};
//   %wire_1433 = &"net150" @WIRE(mode="straight") {#"I850":1 #"I1270":1};
//   %wire_1434 = &"net150" @WIRE(mode="straight") {#"I1338":1 #"I970":1};
//   %wire_1435 = &"net150" @WIRE(mode="straight") {#"I1372":1 #"I1050":1};
//   %wire_1436 = &"net150" @WIRE(mode="straight") {#"I1270":1 #"I810":1};
//   %wire_1437 = &"net150" @WIRE(mode="straight") {#"I1423":1 #"I1170":1};
//   %wire_1438 = &"net150" @WIRE(mode="straight") {#"I1050":1 #"I1355":1};
//   %wire_1439 = &"net150" @WIRE(mode="straight") {#"I591":1 #"I1568":1};
//   %wire_1440 = &"net150" @WIRE(mode="straight") {#"I1130":1 #"I1389":1};
//   %wire_1441 = &"net150" @WIRE(mode="straight") {#"I890":1 #"I1287":1};
//   %wire_1442 = &"net150" @WIRE(mode="straight") {#"I1389":1 #"I1090":1};
//   %wire_1443 = &"net150" @WIRE(mode="straight") {#"I970":1 #"I1321":1};
//   %wire_1444 = &"net150" @WIRE(mode="straight") {#"I1010":1 #"I1338":1};
//   %wire_1445 = &"net150" @WIRE(mode="straight") {#"I777":1 #"I591":1};
//   %wire_1446 = &"net150" @WIRE(mode="straight") {#"I1321":1 #"I930":1};
//   %wire_1447 = &"net156" @WIRE(mode="straight") {#"I1574":10 %marker_551};
//   %wire_1448 = &"net156" @WIRE(mode="straight") {#"I1568":10 #"I1574":10};
//   %p381 = (224, -748);
//   %wire_1449 = &"net156" @WIRE(mode="straight") {%p381 #"I1627":3};
//   %wire_1450 = &"net156" @WIRE(mode="straight") {%p381 #"I1423":10};
//   %wire_1451 = &"net156" @WIRE(mode="straight") {#"I1170":10 #"I1406":10};
//   %wire_1452 = &"net156" @WIRE(mode="straight") {#"I1304":10 #"I890":10};
//   %wire_1453 = &"net156" @WIRE(mode="straight") {#"I1338":10 #"I970":10};
//   %wire_1454 = &"net156" @WIRE(mode="straight") {#"I850":10 #"I1270":10};
//   %wire_1455 = &"net156" @WIRE(mode="straight") {#"I1287":10 #"I850":10};
//   %wire_1456 = &"net156" @WIRE(mode="straight") {#"I1372":10 #"I1050":10};
//   %wire_1457 = &"net156" @WIRE(mode="straight") {#"I1423":10 #"I1170":10};
//   %wire_1458 = &"net156" @WIRE(mode="straight") {#"I1406":10 #"I1130":10};
//   %wire_1459 = &"net156" @WIRE(mode="straight") {#"I1355":10 #"I1010":10};
//   %wire_1460 = &"net156" @WIRE(mode="straight") {#"I591":10 #"I1568":10};
//   %wire_1461 = &"net156" @WIRE(mode="straight") {#"I1010":10 #"I1338":10};
//   %wire_1462 = &"net156" @WIRE(mode="straight") {#"I930":10 #"I1304":10};
//   %wire_1463 = &"net156" @WIRE(mode="straight") {#"I1270":10 #"I810":10};
//   %wire_1464 = &"net156" @WIRE(mode="straight") {#"I1389":10 #"I1090":10};
//   %wire_1465 = &"net156" @WIRE(mode="straight") {#"I1090":10 #"I1372":10};
//   %wire_1466 = &"net156" @WIRE(mode="straight") {#"I1130":10 #"I1389":10};
//   %wire_1467 = &"net156" @WIRE(mode="straight") {#"I1321":10 #"I930":10};
//   %wire_1468 = &"net156" @WIRE(mode="straight") {#"I1050":10 #"I1355":10};
//   %wire_1469 = &"net156" @WIRE(mode="straight") {#"I890":10 #"I1287":10};
//   %wire_1470 = &"net156" @WIRE(mode="straight") {#"I810":10 #"I777":10};
//   %wire_1471 = &"net156" @WIRE(mode="straight") {#"I777":10 #"I591":10};
//   %wire_1472 = &"net156" @WIRE(mode="straight") {#"I970":10 #"I1321":10};
//   %wire_1473 = &"net160" @WIRE(mode="straight") {#"I1573":1 %marker_1159};
//   %wire_1474 = &"net160" @WIRE(mode="straight") {#"I1566":1 #"I1573":1};
//   %wire_1475 = &"net160" @WIRE(mode="straight") {#"I1205":3 #"I1425":1};
//   %wire_1476 = &"net160" @WIRE(mode="straight") {#"I1188":1 #"I1408":1};
//   %wire_1477 = &"net160" @WIRE(mode="straight") {#"I828":1 #"I788":1};
//   %wire_1478 = &"net160" @WIRE(mode="straight") {#"I788":1 #"I635":1};
//   %wire_1479 = &"net160" @WIRE(mode="straight") {#"I1391":1 #"I1108":1};
//   %wire_1480 = &"net160" @WIRE(mode="straight") {#"I1068":1 #"I1357":1};
//   %wire_1481 = &"net160" @WIRE(mode="straight") {#"I1306":1 #"I908":1};
//   %wire_1482 = &"net160" @WIRE(mode="straight") {#"I1374":1 #"I1068":1};
//   %wire_1483 = &"net160" @WIRE(mode="straight") {#"I1425":1 #"I1188":1};
//   %wire_1484 = &"net160" @WIRE(mode="straight") {#"I1408":1 #"I1148":1};
//   %wire_1485 = &"net160" @WIRE(mode="straight") {#"I1272":1 #"I828":1};
//   %wire_1486 = &"net160" @WIRE(mode="straight") {#"I1357":1 #"I1028":1};
//   %wire_1487 = &"net160" @WIRE(mode="straight") {#"I1289":1 #"I868":1};
//   %wire_1488 = &"net160" @WIRE(mode="straight") {#"I988":1 #"I1323":1};
//   %wire_1489 = &"net160" @WIRE(mode="straight") {#"I1340":1 #"I988":1};
//   %wire_1490 = &"net160" @WIRE(mode="straight") {#"I1323":1 #"I948":1};
//   %wire_1491 = &"net160" @WIRE(mode="straight") {#"I1028":1 #"I1340":1};
//   %wire_1492 = &"net160" @WIRE(mode="straight") {#"I868":1 #"I1272":1};
//   %wire_1493 = &"net160" @WIRE(mode="straight") {#"I1148":1 #"I1391":1};
//   %wire_1494 = &"net160" @WIRE(mode="straight") {#"I635":1 #"I1566":1};
//   %wire_1495 = &"net160" @WIRE(mode="straight") {#"I948":1 #"I1306":1};
//   %wire_1496 = &"net160" @WIRE(mode="straight") {#"I908":1 #"I1289":1};
//   %wire_1497 = &"net160" @WIRE(mode="straight") {#"I1108":1 #"I1374":1};
//   %p382 = (300, 16);
//   %wire_1498 = &"net165" @WIRE(mode="straight") {#"I657":3 %p382};
//   %p383 = (302, 16);
//   %wire_1499 = &"net165" @WIRE(mode="straight") {%p382 %p383};
//   %wire_1500 = &"net165" @WIRE(mode="straight") {#"I657":6 %p383};
//   %p384 = (280, 16);
//   %wire_1501 = &"net165" @WIRE(mode="straight") {%p384 %p382};
//   %wire_1502 = &"net165" @WIRE(mode="straight") {#"I635":7 %p384};
//   %wire_1503 = &"net166" @WIRE(mode="straight") {#"I1573":10 %marker_24};
//   %wire_1504 = &"net166" @WIRE(mode="straight") {#"I1566":10 #"I1573":10};
//   %wire_1505 = &"net166" @WIRE(mode="straight") {#"I1425":10 #"I1188":10};
//   %p385 = (272, -748);
//   %wire_1506 = &"net166" @WIRE(mode="straight") {%p385 #"I1629":3};
//   %wire_1507 = &"net166" @WIRE(mode="straight") {%p385 #"I1425":10};
//   %wire_1508 = &"net166" @WIRE(mode="straight") {#"I1188":10 #"I1408":10};
//   %wire_1509 = &"net166" @WIRE(mode="straight") {#"I868":10 #"I1272":10};
//   %wire_1510 = &"net166" @WIRE(mode="straight") {#"I1323":10 #"I948":10};
//   %wire_1511 = &"net166" @WIRE(mode="straight") {#"I948":10 #"I1306":10};
//   %wire_1512 = &"net166" @WIRE(mode="straight") {#"I1391":10 #"I1108":10};
//   %wire_1513 = &"net166" @WIRE(mode="straight") {#"I1306":10 #"I908":10};
//   %wire_1514 = &"net166" @WIRE(mode="straight") {#"I1408":10 #"I1148":10};
//   %wire_1515 = &"net166" @WIRE(mode="straight") {#"I1374":10 #"I1068":10};
//   %wire_1516 = &"net166" @WIRE(mode="straight") {#"I1340":10 #"I988":10};
//   %wire_1517 = &"net166" @WIRE(mode="straight") {#"I1272":10 #"I828":10};
//   %wire_1518 = &"net166" @WIRE(mode="straight") {#"I1357":10 #"I1028":10};
//   %wire_1519 = &"net166" @WIRE(mode="straight") {#"I1289":10 #"I868":10};
//   %wire_1520 = &"net166" @WIRE(mode="straight") {#"I1028":10 #"I1340":10};
//   %wire_1521 = &"net166" @WIRE(mode="straight") {#"I635":10 #"I1566":10};
//   %wire_1522 = &"net166" @WIRE(mode="straight") {#"I1108":10 #"I1374":10};
//   %wire_1523 = &"net166" @WIRE(mode="straight") {#"I988":10 #"I1323":10};
//   %wire_1524 = &"net166" @WIRE(mode="straight") {#"I1148":10 #"I1391":10};
//   %wire_1525 = &"net166" @WIRE(mode="straight") {#"I908":10 #"I1289":10};
//   %wire_1526 = &"net166" @WIRE(mode="straight") {#"I1068":10 #"I1357":10};
//   %wire_1527 = &"net166" @WIRE(mode="straight") {#"I788":10 #"I635":10};
//   %wire_1528 = &"net166" @WIRE(mode="straight") {#"I828":10 #"I788":10};
//   %p386 = (97, -31);
//   %wire_1529 = &"net20" @WIRE(mode="straight") {#"M23":3 %p386};
//   %p387 = (97, -28);
//   %wire_1530 = &"net20" @WIRE(mode="straight") {%p386 %p387};
//   %p388 = (-18, -31);
//   %wire_1531 = &"net20" @WIRE(mode="straight") {%p388 #"I770":4};
//   %wire_1532 = &"net20" @WIRE(mode="straight") {%p388 #"M1":1};
//   %wire_1533 = &"net20" @WIRE(mode="straight") {#"I772":4 #"I773":4};
//   %wire_1534 = &"net20" @WIRE(mode="straight") {#"I770":4 #"I771":4};
//   %wire_1535 = &"net20" @WIRE(mode="straight") {#"I771":4 #"I772":4};
//   %wire_1536 = &"net20" @WIRE(mode="straight") {#"I769":1 %p388};
//   %p389 = (-26, -33);
//   %wire_1537 = &"net20" @WIRE(mode="straight") {%p389 #"I769":1};
//   %wire_1538 = &"net20" @WIRE(mode="straight") {#"I773":4 %p386};
//   %wire_1539 = &"net20" @WIRE(mode="straight") {%p387 #"M130":3};
//   %wire_1540 = &"net20" @WIRE(mode="straight") {#"I1432":2 %p389};
//   %wire_1541 = &"net170" @WIRE(mode="straight") {#"I1603":1 %marker_789};
//   %wire_1542 = &"net170" @WIRE(mode="straight") {#"I1601":1 #"I1603":1};
//   %wire_1543 = &"net170" @WIRE(mode="straight") {#"I1210":3 #"I1426":1};
//   %wire_1544 = &"net170" @WIRE(mode="straight") {#"I1187":1 #"I1409":1};
//   %wire_1545 = &"net170" @WIRE(mode="straight") {#"I1307":1 #"I907":1};
//   %wire_1546 = &"net170" @WIRE(mode="straight") {#"I1027":1 #"I1341":1};
//   %wire_1547 = &"net170" @WIRE(mode="straight") {#"I1107":1 #"I1375":1};
//   %wire_1548 = &"net170" @WIRE(mode="straight") {#"I987":1 #"I1324":1};
//   %wire_1549 = &"net170" @WIRE(mode="straight") {#"I1290":1 #"I867":1};
//   %wire_1550 = &"net170" @WIRE(mode="straight") {#"I1375":1 #"I1067":1};
//   %wire_1551 = &"net170" @WIRE(mode="straight") {#"I1392":1 #"I1107":1};
//   %wire_1552 = &"net170" @WIRE(mode="straight") {#"I1341":1 #"I987":1};
//   %wire_1553 = &"net170" @WIRE(mode="straight") {#"I1409":1 #"I1147":1};
//   %wire_1554 = &"net170" @WIRE(mode="straight") {#"I787":1 #"I657":1};
//   %wire_1555 = &"net170" @WIRE(mode="straight") {#"I1324":1 #"I947":1};
//   %wire_1556 = &"net170" @WIRE(mode="straight") {#"I827":1 #"I787":1};
//   %wire_1557 = &"net170" @WIRE(mode="straight") {#"I1067":1 #"I1358":1};
//   %wire_1558 = &"net170" @WIRE(mode="straight") {#"I907":1 #"I1290":1};
//   %wire_1559 = &"net170" @WIRE(mode="straight") {#"I1358":1 #"I1027":1};
//   %wire_1560 = &"net170" @WIRE(mode="straight") {#"I947":1 #"I1307":1};
//   %wire_1561 = &"net170" @WIRE(mode="straight") {#"I657":1 #"I1601":1};
//   %wire_1562 = &"net170" @WIRE(mode="straight") {#"I1147":1 #"I1392":1};
//   %wire_1563 = &"net170" @WIRE(mode="straight") {#"I867":1 #"I1273":1};
//   %wire_1564 = &"net170" @WIRE(mode="straight") {#"I1426":1 #"I1187":1};
//   %wire_1565 = &"net170" @WIRE(mode="straight") {#"I1273":1 #"I827":1};
//   %wire_1566 = &"net3" @WIRE(mode="straight") {#"I1553":1 %marker_106};
//   %wire_1567 = &"net3" @WIRE(mode="straight") {#"I1545":1 #"I1553":1};
//   %wire_1568 = &"net3" @WIRE(mode="straight") {#"I1189":3 #"I1417":1};
//   %wire_1569 = &"net3" @WIRE(mode="straight") {#"I1159":1 #"I1400":1};
//   %wire_1570 = &"net3" @WIRE(mode="straight") {#"I879":1 #"I1281":1};
//   %wire_1571 = &"net3" @WIRE(mode="straight") {#"I1366":1 #"I1039":1};
//   %wire_1572 = &"net3" @WIRE(mode="straight") {#"I1383":1 #"I1079":1};
//   %wire_1573 = &"net3" @WIRE(mode="straight") {#"I799":1 #"I770":1};
//   %wire_1574 = &"net3" @WIRE(mode="straight") {#"I1298":1 #"I879":1};
//   %wire_1575 = &"net3" @WIRE(mode="straight") {#"I919":1 #"I1298":1};
//   %wire_1576 = &"net3" @WIRE(mode="straight") {#"I959":1 #"I1315":1};
//   %wire_1577 = &"net3" @WIRE(mode="straight") {#"I839":1 #"I1264":1};
//   %wire_1578 = &"net3" @WIRE(mode="straight") {#"I1079":1 #"I1366":1};
//   %wire_1579 = &"net3" @WIRE(mode="straight") {#"I1039":1 #"I1349":1};
//   %wire_1580 = &"net3" @WIRE(mode="straight") {#"I1417":1 #"I1159":1};
//   %wire_1581 = &"net3" @WIRE(mode="straight") {#"I1349":1 #"I999":1};
//   %wire_1582 = &"net3" @WIRE(mode="straight") {#"I1400":1 #"I1119":1};
//   %wire_1583 = &"net3" @WIRE(mode="straight") {#"I770":1 #"I415":1};
//   %wire_1584 = &"net3" @WIRE(mode="straight") {#"I1281":1 #"I839":1};
//   %wire_1585 = &"net3" @WIRE(mode="straight") {#"I1332":1 #"I959":1};
//   %wire_1586 = &"net3" @WIRE(mode="straight") {#"I999":1 #"I1332":1};
//   %wire_1587 = &"net3" @WIRE(mode="straight") {#"I415":1 #"I1545":1};
//   %wire_1588 = &"net3" @WIRE(mode="straight") {#"I1119":1 #"I1383":1};
//   %wire_1589 = &"net3" @WIRE(mode="straight") {#"I1315":1 #"I919":1};
//   %wire_1590 = &"net3" @WIRE(mode="straight") {#"I1264":1 #"I799":1};
//   %wire_1591 = &"net176" @WIRE(mode="straight") {#"I1603":10 %marker_819};
//   %wire_1592 = &"net176" @WIRE(mode="straight") {#"I1601":10 #"I1603":10};
//   %p390 = (296, -748);
//   %wire_1593 = &"net176" @WIRE(mode="straight") {%p390 #"I1630":3};
//   %wire_1594 = &"net176" @WIRE(mode="straight") {%p390 #"I1426":10};
//   %wire_1595 = &"net176" @WIRE(mode="straight") {#"I1187":10 #"I1409":10};
//   %wire_1596 = &"net176" @WIRE(mode="straight") {#"I1307":10 #"I907":10};
//   %wire_1597 = &"net176" @WIRE(mode="straight") {#"I907":10 #"I1290":10};
//   %wire_1598 = &"net176" @WIRE(mode="straight") {#"I1107":10 #"I1375":10};
//   %wire_1599 = &"net176" @WIRE(mode="straight") {#"I987":10 #"I1324":10};
//   %wire_1600 = &"net176" @WIRE(mode="straight") {#"I1426":10 #"I1187":10};
//   %wire_1601 = &"net176" @WIRE(mode="straight") {#"I657":10 #"I1601":10};
//   %wire_1602 = &"net176" @WIRE(mode="straight") {#"I1341":10 #"I987":10};
//   %wire_1603 = &"net176" @WIRE(mode="straight") {#"I1375":10 #"I1067":10};
//   %wire_1604 = &"net176" @WIRE(mode="straight") {#"I1392":10 #"I1107":10};
//   %wire_1605 = &"net176" @WIRE(mode="straight") {#"I1273":10 #"I827":10};
//   %wire_1606 = &"net176" @WIRE(mode="straight") {#"I787":10 #"I657":10};
//   %wire_1607 = &"net176" @WIRE(mode="straight") {#"I1409":10 #"I1147":10};
//   %wire_1608 = &"net176" @WIRE(mode="straight") {#"I1324":10 #"I947":10};
//   %wire_1609 = &"net176" @WIRE(mode="straight") {#"I1067":10 #"I1358":10};
//   %wire_1610 = &"net176" @WIRE(mode="straight") {#"I947":10 #"I1307":10};
//   %wire_1611 = &"net176" @WIRE(mode="straight") {#"I1027":10 #"I1341":10};
//   %wire_1612 = &"net176" @WIRE(mode="straight") {#"I1290":10 #"I867":10};
//   %wire_1613 = &"net176" @WIRE(mode="straight") {#"I1147":10 #"I1392":10};
//   %wire_1614 = &"net176" @WIRE(mode="straight") {#"I867":10 #"I1273":10};
//   %wire_1615 = &"net176" @WIRE(mode="straight") {#"I1358":10 #"I1027":10};
//   %wire_1616 = &"net176" @WIRE(mode="straight") {#"I827":10 #"I787":10};
//   %p391 = (170, -19);
//   %p392 = (196, -17);
//   %wire_1617 = &"net65" @WIRE(mode="straight") {%p391 %p392};
//   %wire_1618 = &"net65" @WIRE(mode="straight") {#"I778":7 %p392};
//   %p393 = (228, -19);
//   %wire_1619 = &"net65" @WIRE(mode="straight") {#"I777":3 %p393};
//   %wire_1620 = &"net65" @WIRE(mode="straight") {%p393 %p392};
//   %wire_1621 = &"net65" @WIRE(mode="straight") {#"I779":6 %p391};
//   %p394 = (-23, -615);
//   %wire_1622 = &"net2337" @WIRE(mode="straight") {%p394 #"I1533":1};
//   %wire_1623 = &"net2337" @WIRE(mode="straight") {#"I1526":3 #"M83":2};
//   %p395 = (-23, -652);
//   %wire_1624 = &"net2337" @WIRE(mode="straight") {%p395 #"M83":2};
//   %wire_1625 = &"net2337" @WIRE(mode="straight") {%p395 %p394};
//   %wire_1626 = &"net7" @WIRE(mode="straight") {#"I767":1 #"I411":3};
//   %wire_1627 = &"net17" @WIRE(mode="straight") {#"I411":1 #"I412":2};
//   %p396 = (12, -617);
//   %wire_1628 = &"net2349" @WIRE(mode="straight") {#"I1119":6 %p396};
//   %wire_1629 = &"net2349" @WIRE(mode="straight") {#"M84":2 %p396};
//   %wire_1630 = &"net2349" @WIRE(mode="straight") {#"I1533":3 #"M84":2};
//   %p397 = (12, -267);
//   %wire_1631 = &"net2189" @WIRE(mode="straight") {#"I919":6 %p397};
//   %wire_1632 = &"net2189" @WIRE(mode="straight") {#"M74":2 %p397};
//   %wire_1633 = &"net2189" @WIRE(mode="straight") {#"I1493":3 #"M74":2};
//   %p398 = (-23, -685);
//   %wire_1634 = &"net2369" @WIRE(mode="straight") {%p398 #"I1541":1};
//   %wire_1635 = &"net2369" @WIRE(mode="straight") {#"I1534":3 #"M85":2};
//   %p399 = (-23, -722);
//   %wire_1636 = &"net2369" @WIRE(mode="straight") {%p399 #"M85":2};
//   %wire_1637 = &"net2369" @WIRE(mode="straight") {%p399 %p398};
//   %p400 = (12, -687);
//   %wire_1638 = &"net2381" @WIRE(mode="straight") {#"I1159":6 %p400};
//   %wire_1639 = &"net2381" @WIRE(mode="straight") {#"M86":2 %p400};
//   %wire_1640 = &"net2381" @WIRE(mode="straight") {#"I1541":3 #"M86":2};
//   %p401 = (-4, -367);
//   %wire_1641 = &"net396" @WIRE(mode="straight") {#"I1494":1 %p401};
//   %p402 = (34, -369);
//   %p403 = (14, -367);
//   %wire_1642 = &"net396" @WIRE(mode="straight") {%p402 %p403};
//   %wire_1643 = &"net396" @WIRE(mode="straight") {%p401 %p403};
//   %wire_1644 = &"net396" @WIRE(mode="straight") {#"I1331":3 %p402};
//   %wire_1645 = &"net396" @WIRE(mode="straight") {#"I1332":7 %p403};
//   %p404 = (12, 13);
//   %wire_1646 = &"net134" @WIRE(mode="straight") {#"I415":6 %p404};
//   %wire_1647 = &"net134" @WIRE(mode="straight") {#"M0":2 %p404};
//   %wire_1648 = &"net134" @WIRE(mode="straight") {#"I1460":3 #"M0":2};
//   %p405 = (-23, 15);
//   %wire_1649 = &"net472" @WIRE(mode="straight") {%p405 #"I1460":1};
//   %wire_1650 = &"net472" @WIRE(mode="straight") {#"I1461":3 #"M1":2};
//   %p406 = (-23, -22);
//   %wire_1651 = &"net472" @WIRE(mode="straight") {%p406 %p405};
//   %wire_1652 = &"net472" @WIRE(mode="straight") {%p406 #"M1":2};
//   %wire_1653 = &"net295" @WIRE(mode="straight") {#"I1490":1 #"I1487":2};
//   %wire_1654 = &"net414" @WIRE(mode="straight") {#"I1497":1 #"I1498":3};
//   %wire_1655 = &"net250" @WIRE(mode="straight") {#"I1499":1 #"I1500":3};
//   %wire_1656 = &"net329" @WIRE(mode="straight") {#"I1483":1 #"I1484":3};
//   %wire_1657 = &"net70" @WIRE(mode="straight") {#"I1508":1 #"I1504":2};
//   %wire_1658 = &"net338" @WIRE(mode="straight") {#"I1476":1 #"I1472":2};
//   %wire_1659 = &"net213" @WIRE(mode="straight") {#"I1506":1 #"I1503":2};
//   %wire_1660 = &"net327" @WIRE(mode="straight") {#"I1484":1 #"I1480":2};
//   %wire_1661 = &"net318" @WIRE(mode="straight") {#"I1489":1 #"I1490":3};
//   %wire_1662 = &"net249" @WIRE(mode="straight") {#"I1500":1 #"I1496":2};
//   %wire_1663 = &"net377" @WIRE(mode="straight") {#"I1474":1 #"I1471":2};
//   %p407 = (-23, -545);
//   %wire_1664 = &"net2305" @WIRE(mode="straight") {%p407 #"I1525":1};
//   %wire_1665 = &"net2305" @WIRE(mode="straight") {#"I1518":3 #"M81":2};
//   %p408 = (-23, -582);
//   %wire_1666 = &"net2305" @WIRE(mode="straight") {%p408 #"M81":2};
//   %wire_1667 = &"net2305" @WIRE(mode="straight") {%p408 %p407};
//   %p409 = (-23, -195);
//   %wire_1668 = &"net2145" @WIRE(mode="straight") {%p409 #"I1485":1};
//   %p410 = (-23, -232);
//   %wire_1669 = &"net2145" @WIRE(mode="straight") {%p410 %p409};
//   %wire_1670 = &"net2145" @WIRE(mode="straight") {%p410 #"M71":2};
//   %wire_1671 = &"net2145" @WIRE(mode="straight") {#"I1478":3 #"M71":2};
//   %p411 = (12, -547);
//   %wire_1672 = &"net2317" @WIRE(mode="straight") {#"I1079":6 %p411};
//   %wire_1673 = &"net2317" @WIRE(mode="straight") {#"M82":2 %p411};
//   %wire_1674 = &"net2317" @WIRE(mode="straight") {#"I1525":3 #"M82":2};
//   %p412 = (400, -773);
//   %wire_1675 = &"REPET_17" @WIRE(mode="straight") {%p412 #"I1634":1};
//   %wire_1675 @TEXT("REPET\_17", size=1, halign="middle", valign="baseline", rotate=90) => @PLACE(399.3, -768);
//   %p413 = (376, -773);
//   %wire_1676 = &"REPET_16" @WIRE(mode="straight") {%p413 #"I1633":1};
//   %wire_1676 @TEXT("REPET\_16", size=1, halign="middle", valign="baseline", rotate=90) => @PLACE(375.3, -768);
//   %p414 = (-6, -696);
//   %wire_1677 = &"net87" @WIRE(mode="straight") {%p414 #"M86":1};
//   %wire_1678 = &"net87" @WIRE(mode="straight") {#"I1536":1 %p414};
//   %p415 = (-26, -698);
//   %wire_1679 = &"net87" @WIRE(mode="straight") {%p415 #"I1536":1};
//   %wire_1680 = &"net87" @WIRE(mode="straight") {#"I1540":2 %p415};
//   %p416 = (97, -693);
//   %wire_1681 = &"net87" @WIRE(mode="straight") {%p416 #"M149":3};
//   %p417 = (97, -696);
//   %wire_1682 = &"net87" @WIRE(mode="straight") {#"I1162":4 %p417};
//   %wire_1683 = &"net87" @WIRE(mode="straight") {#"I1161":4 #"I1162":4};
//   %wire_1684 = &"net87" @WIRE(mode="straight") {#"I1160":4 #"I1161":4};
//   %wire_1685 = &"net87" @WIRE(mode="straight") {#"I1159":4 #"I1160":4};
//   %wire_1686 = &"net87" @WIRE(mode="straight") {%p414 #"I1159":4};
//   %wire_1687 = &"net87" @WIRE(mode="straight") {#"M42":3 %p417};
//   %wire_1688 = &"net87" @WIRE(mode="straight") {%p417 %p416};
//   %p418 = (-20, -708);
//   %p419 = (14, -708);
//   %wire_1689 = &"net89" @WIRE(mode="straight") {%p418 %p419};
//   %wire_1690 = &"net89" @WIRE(mode="straight") {%p418 #"I1541":2};
//   %p420 = (400, -708);
//   %wire_1691 = &"net89" @WIRE(mode="straight") {%p420 #"I1182":2};
//   %wire_1692 = &"net89" @WIRE(mode="straight") {%p420 #"I1183":5};
//   %p421 = (376, -708);
//   %wire_1693 = &"net89" @WIRE(mode="straight") {%p421 %p420};
//   %wire_1694 = &"net89" @WIRE(mode="straight") {%p421 #"I1184":5};
//   %p422 = (352, -708);
//   %wire_1695 = &"net89" @WIRE(mode="straight") {%p422 %p421};
//   %wire_1696 = &"net89" @WIRE(mode="straight") {%p422 #"I1185":5};
//   %p423 = (328, -708);
//   %wire_1697 = &"net89" @WIRE(mode="straight") {%p423 %p422};
//   %wire_1698 = &"net89" @WIRE(mode="straight") {%p423 #"I1186":5};
//   %p424 = (304, -708);
//   %wire_1699 = &"net89" @WIRE(mode="straight") {%p424 %p423};
//   %wire_1700 = &"net89" @WIRE(mode="straight") {%p424 #"I1187":5};
//   %p425 = (280, -708);
//   %wire_1701 = &"net89" @WIRE(mode="straight") {%p425 %p424};
//   %wire_1702 = &"net89" @WIRE(mode="straight") {%p425 #"I1188":5};
//   %p426 = (256, -708);
//   %wire_1703 = &"net89" @WIRE(mode="straight") {%p426 %p425};
//   %wire_1704 = &"net89" @WIRE(mode="straight") {%p426 #"I1169":5};
//   %p427 = (232, -708);
//   %wire_1705 = &"net89" @WIRE(mode="straight") {%p427 %p426};
//   %wire_1706 = &"net89" @WIRE(mode="straight") {%p427 #"I1170":5};
//   %p428 = (196, -708);
//   %wire_1707 = &"net89" @WIRE(mode="straight") {%p428 %p427};
//   %wire_1708 = &"net89" @WIRE(mode="straight") {%p428 #"I1171":5};
//   %p429 = (172, -708);
//   %wire_1709 = &"net89" @WIRE(mode="straight") {%p429 %p428};
//   %wire_1710 = &"net89" @WIRE(mode="straight") {%p429 #"I1172":5};
//   %p430 = (148, -708);
//   %wire_1711 = &"net89" @WIRE(mode="straight") {%p430 %p429};
//   %wire_1712 = &"net89" @WIRE(mode="straight") {%p430 #"I1173":5};
//   %p431 = (124, -708);
//   %wire_1713 = &"net89" @WIRE(mode="straight") {%p431 %p430};
//   %wire_1714 = &"net89" @WIRE(mode="straight") {%p431 #"I1174":5};
//   %p432 = (86, -708);
//   %wire_1715 = &"net89" @WIRE(mode="straight") {%p432 %p431};
//   %wire_1716 = &"net89" @WIRE(mode="straight") {%p432 #"I1162":5};
//   %p433 = (62, -708);
//   %wire_1717 = &"net89" @WIRE(mode="straight") {%p433 %p432};
//   %wire_1718 = &"net89" @WIRE(mode="straight") {%p433 #"I1161":5};
//   %p434 = (38, -708);
//   %wire_1719 = &"net89" @WIRE(mode="straight") {%p434 %p433};
//   %wire_1720 = &"net89" @WIRE(mode="straight") {%p434 #"I1160":5};
//   %wire_1721 = &"net89" @WIRE(mode="straight") {%p419 %p434};
//   %wire_1722 = &"net89" @WIRE(mode="straight") {%p419 #"I1159":5};
//   %p435 = (394, -680);
//   %wire_1723 = &"net90" @WIRE(mode="straight") {#"I1183":9 %p435};
//   %p436 = (370, -680);
//   %wire_1724 = &"net90" @WIRE(mode="straight") {%p436 %p435};
//   %wire_1725 = &"net90" @WIRE(mode="straight") {#"I1184":9 %p436};
//   %p437 = (346, -680);
//   %wire_1726 = &"net90" @WIRE(mode="straight") {%p437 %p436};
//   %wire_1727 = &"net90" @WIRE(mode="straight") {#"I1185":9 %p437};
//   %p438 = (322, -680);
//   %wire_1728 = &"net90" @WIRE(mode="straight") {%p438 %p437};
//   %wire_1729 = &"net90" @WIRE(mode="straight") {#"I1186":9 %p438};
//   %p439 = (298, -680);
//   %wire_1730 = &"net90" @WIRE(mode="straight") {%p439 %p438};
//   %wire_1731 = &"net90" @WIRE(mode="straight") {#"I1187":9 %p439};
//   %p440 = (274, -680);
//   %wire_1732 = &"net90" @WIRE(mode="straight") {%p440 %p439};
//   %wire_1733 = &"net90" @WIRE(mode="straight") {#"I1188":9 %p440};
//   %p441 = (250, -680);
//   %wire_1734 = &"net90" @WIRE(mode="straight") {%p441 %p440};
//   %wire_1735 = &"net90" @WIRE(mode="straight") {#"I1169":9 %p441};
//   %p442 = (226, -680);
//   %wire_1736 = &"net90" @WIRE(mode="straight") {%p442 %p441};
//   %wire_1737 = &"net90" @WIRE(mode="straight") {#"I1170":9 %p442};
//   %p443 = (190, -680);
//   %wire_1738 = &"net90" @WIRE(mode="straight") {%p443 %p442};
//   %wire_1739 = &"net90" @WIRE(mode="straight") {#"I1171":9 %p443};
//   %p444 = (166, -680);
//   %wire_1740 = &"net90" @WIRE(mode="straight") {%p444 %p443};
//   %wire_1741 = &"net90" @WIRE(mode="straight") {#"I1172":9 %p444};
//   %p445 = (142, -680);
//   %wire_1742 = &"net90" @WIRE(mode="straight") {%p445 %p444};
//   %wire_1743 = &"net90" @WIRE(mode="straight") {#"I1173":9 %p445};
//   %p446 = (118, -680);
//   %wire_1744 = &"net90" @WIRE(mode="straight") {%p446 %p445};
//   %wire_1745 = &"net90" @WIRE(mode="straight") {#"I1174":9 %p446};
//   %p447 = (80, -680);
//   %wire_1746 = &"net90" @WIRE(mode="straight") {%p447 %p446};
//   %wire_1747 = &"net90" @WIRE(mode="straight") {#"I1162":9 %p447};
//   %p448 = (56, -680);
//   %wire_1748 = &"net90" @WIRE(mode="straight") {%p448 %p447};
//   %wire_1749 = &"net90" @WIRE(mode="straight") {#"I1161":9 %p448};
//   %p449 = (32, -680);
//   %wire_1750 = &"net90" @WIRE(mode="straight") {%p449 %p448};
//   %wire_1751 = &"net90" @WIRE(mode="straight") {#"I1160":9 %p449};
//   %p450 = (10, -680);
//   %wire_1752 = &"net90" @WIRE(mode="straight") {%p450 %p449};
//   %wire_1753 = &"net90" @WIRE(mode="straight") {#"I1159":3 %p450};
//   %p451 = (8, -680);
//   %wire_1754 = &"net90" @WIRE(mode="straight") {%p451 %p450};
//   %wire_1755 = &"net90" @WIRE(mode="straight") {#"I1159":9 %p451};
//   %p452 = (36, -684);
//   %wire_1756 = &"net91" @WIRE(mode="straight") {#"I1160":6 %p452};
//   %p453 = (34, -684);
//   %wire_1757 = &"net91" @WIRE(mode="straight") {%p453 %p452};
//   %wire_1758 = &"net91" @WIRE(mode="straight") {#"I1160":3 %p453};
//   %p454 = (14, -684);
//   %wire_1759 = &"net91" @WIRE(mode="straight") {%p454 %p453};
//   %wire_1760 = &"net91" @WIRE(mode="straight") {#"I1159":7 %p454};
//   %p455 = (60, -684);
//   %wire_1761 = &"net92" @WIRE(mode="straight") {#"I1161":6 %p455};
//   %p456 = (58, -684);
//   %wire_1762 = &"net92" @WIRE(mode="straight") {%p456 %p455};
//   %wire_1763 = &"net92" @WIRE(mode="straight") {#"I1161":3 %p456};
//   %p457 = (38, -684);
//   %wire_1764 = &"net92" @WIRE(mode="straight") {%p457 %p456};
//   %wire_1765 = &"net92" @WIRE(mode="straight") {#"I1160":7 %p457};
//   %p458 = (84, -684);
//   %wire_1766 = &"net95" @WIRE(mode="straight") {#"I1162":6 %p458};
//   %p459 = (82, -684);
//   %wire_1767 = &"net95" @WIRE(mode="straight") {%p459 %p458};
//   %wire_1768 = &"net95" @WIRE(mode="straight") {#"I1162":3 %p459};
//   %p460 = (62, -684);
//   %wire_1769 = &"net95" @WIRE(mode="straight") {%p460 %p459};
//   %wire_1770 = &"net95" @WIRE(mode="straight") {#"I1161":7 %p460};
//   %p461 = (122, -684);
//   %wire_1771 = &"net96" @WIRE(mode="straight") {#"I1174":6 %p461};
//   %p462 = (120, -684);
//   %wire_1772 = &"net96" @WIRE(mode="straight") {%p462 %p461};
//   %wire_1773 = &"net96" @WIRE(mode="straight") {#"I1174":3 %p462};
//   %p463 = (86, -684);
//   %wire_1774 = &"net96" @WIRE(mode="straight") {%p463 %p462};
//   %wire_1775 = &"net96" @WIRE(mode="straight") {#"I1162":7 %p463};
//   %p464 = (254, -229);
//   %p465 = (280, -227);
//   %wire_1776 = &"net37" @WIRE(mode="straight") {%p464 %p465};
//   %wire_1777 = &"net37" @WIRE(mode="straight") {#"I1299":6 %p464};
//   %wire_1778 = &"net37" @WIRE(mode="straight") {#"I1306":7 %p465};
//   %p466 = (300, -229);
//   %wire_1779 = &"net37" @WIRE(mode="straight") {%p466 %p465};
//   %wire_1780 = &"net37" @WIRE(mode="straight") {#"I1307":3 %p466};
//   %p467 = (215, -241);
//   %wire_1781 = &"net40" @WIRE(mode="straight") {%p467 #"I1304":4};
//   %wire_1782 = &"net40" @WIRE(mode="straight") {%p467 #"M166":1};
//   %p468 = (215, -244);
//   %wire_1783 = &"net40" @WIRE(mode="straight") {%p468 %p467};
//   %wire_1784 = &"net40" @WIRE(mode="straight") {#"M59":1 %p468};
//   %wire_1785 = &"net40" @WIRE(mode="straight") {#"I1308":4 #"I1309":4};
//   %wire_1786 = &"net40" @WIRE(mode="straight") {#"I1307":4 #"I1308":4};
//   %wire_1787 = &"net40" @WIRE(mode="straight") {#"I1304":4 #"I1299":4};
//   %wire_1788 = &"net40" @WIRE(mode="straight") {#"I1310":4 #"I1311":4};
//   %wire_1789 = &"net40" @WIRE(mode="straight") {#"I1309":4 #"I1310":4};
//   %wire_1790 = &"net40" @WIRE(mode="straight") {#"I1299":4 #"I1306":4};
//   %wire_1791 = &"net40" @WIRE(mode="straight") {#"I1306":4 #"I1307":4};
//   %p469 = (352, -253);
//   %p470 = (376, -253);
//   %wire_1792 = &"net42" @WIRE(mode="straight") {%p469 %p470};
//   %p471 = (148, -253);
//   %wire_1793 = &"net42" @WIRE(mode="straight") {%p471 #"I1301":5};
//   %p472 = (38, -253);
//   %p473 = (62, -253);
//   %wire_1794 = &"net42" @WIRE(mode="straight") {%p472 %p473};
//   %p474 = (124, -253);
//   %wire_1795 = &"net42" @WIRE(mode="straight") {%p474 #"I1300":5};
//   %wire_1796 = &"net42" @WIRE(mode="straight") {%p474 %p471};
//   %p475 = (86, -253);
//   %wire_1797 = &"net42" @WIRE(mode="straight") {%p473 %p475};
//   %wire_1798 = &"net42" @WIRE(mode="straight") {%p475 %p474};
//   %wire_1799 = &"net42" @WIRE(mode="straight") {%p475 #"I1295":5};
//   %wire_1800 = &"net42" @WIRE(mode="straight") {%p473 #"I1296":5};
//   %p476 = (14, -253);
//   %wire_1801 = &"net42" @WIRE(mode="straight") {%p476 %p472};
//   %wire_1802 = &"net42" @WIRE(mode="straight") {%p472 #"I1297":5};
//   %wire_1803 = &"net42" @WIRE(mode="straight") {%p476 #"I1298":5};
//   %p477 = (328, -253);
//   %wire_1804 = &"net42" @WIRE(mode="straight") {%p477 #"I1308":5};
//   %p478 = (304, -253);
//   %wire_1805 = &"net42" @WIRE(mode="straight") {%p478 %p477};
//   %p479 = (232, -253);
//   %p480 = (256, -253);
//   %wire_1806 = &"net42" @WIRE(mode="straight") {%p479 %p480};
//   %p481 = (-4, -253);
//   %wire_1807 = &"net42" @WIRE(mode="straight") {%p481 #"I1478":2};
//   %p482 = (172, -253);
//   %wire_1808 = &"net42" @WIRE(mode="straight") {%p471 %p482};
//   %wire_1809 = &"net42" @WIRE(mode="straight") {%p477 %p469};
//   %wire_1810 = &"net42" @WIRE(mode="straight") {%p481 %p476};
//   %p483 = (196, -253);
//   %wire_1811 = &"net42" @WIRE(mode="straight") {%p483 #"I1303":5};
//   %wire_1812 = &"net42" @WIRE(mode="straight") {%p483 %p479};
//   %wire_1813 = &"net42" @WIRE(mode="straight") {%p482 %p483};
//   %wire_1814 = &"net42" @WIRE(mode="straight") {%p478 #"I1307":5};
//   %p484 = (280, -253);
//   %wire_1815 = &"net42" @WIRE(mode="straight") {%p480 %p484};
//   %wire_1816 = &"net42" @WIRE(mode="straight") {%p484 #"I1306":5};
//   %wire_1817 = &"net42" @WIRE(mode="straight") {%p470 #"I1310":5};
//   %wire_1818 = &"net42" @WIRE(mode="straight") {%p484 %p478};
//   %wire_1819 = &"net42" @WIRE(mode="straight") {%p482 #"I1302":5};
//   %wire_1820 = &"net42" @WIRE(mode="straight") {%p479 #"I1304":5};
//   %p485 = (400, -253);
//   %wire_1821 = &"net42" @WIRE(mode="straight") {%p485 #"I1305":2};
//   %wire_1822 = &"net42" @WIRE(mode="straight") {%p485 #"I1311":5};
//   %wire_1823 = &"net42" @WIRE(mode="straight") {%p470 %p485};
//   %wire_1824 = &"net42" @WIRE(mode="straight") {%p469 #"I1309":5};
//   %wire_1825 = &"net42" @WIRE(mode="straight") {%p480 #"I1299":5};
//   %p486 = (232, -227);
//   %wire_1826 = &"net51" @WIRE(mode="straight") {#"I1304":7 %p486};
//   %p487 = (252, -229);
//   %wire_1827 = &"net51" @WIRE(mode="straight") {%p487 %p486};
//   %p488 = (194, -229);
//   %wire_1828 = &"net51" @WIRE(mode="straight") {%p488 %p486};
//   %wire_1829 = &"net51" @WIRE(mode="straight") {#"I1303":6 %p488};
//   %wire_1830 = &"net51" @WIRE(mode="straight") {#"I1299":3 %p487};
//   %p489 = (230, -229);
//   %wire_1831 = &"net52" @WIRE(mode="straight") {#"I1304":6 %p489};
//   %p490 = (276, -229);
//   %wire_1832 = &"net52" @WIRE(mode="straight") {#"I1306":3 %p490};
//   %p491 = (256, -227);
//   %wire_1833 = &"net52" @WIRE(mode="straight") {%p489 %p491};
//   %wire_1834 = &"net52" @WIRE(mode="straight") {%p490 %p491};
//   %wire_1835 = &"net52" @WIRE(mode="straight") {#"I1299":7 %p491};
//   %p492 = (166, -225);
//   %wire_1836 = &"net57" @WIRE(mode="straight") {#"I1302":9 %p492};
//   %p493 = (142, -225);
//   %wire_1837 = &"net57" @WIRE(mode="straight") {%p493 %p492};
//   %wire_1838 = &"net57" @WIRE(mode="straight") {#"I1301":9 %p493};
//   %p494 = (118, -225);
//   %wire_1839 = &"net57" @WIRE(mode="straight") {%p494 %p493};
//   %wire_1840 = &"net57" @WIRE(mode="straight") {#"I1300":9 %p494};
//   %p495 = (80, -225);
//   %wire_1841 = &"net57" @WIRE(mode="straight") {%p495 %p494};
//   %wire_1842 = &"net57" @WIRE(mode="straight") {#"I1295":9 %p495};
//   %p496 = (56, -225);
//   %wire_1843 = &"net57" @WIRE(mode="straight") {%p496 %p495};
//   %wire_1844 = &"net57" @WIRE(mode="straight") {#"I1296":9 %p496};
//   %p497 = (32, -225);
//   %wire_1845 = &"net57" @WIRE(mode="straight") {%p497 %p496};
//   %wire_1846 = &"net57" @WIRE(mode="straight") {#"I1297":9 %p497};
//   %p498 = (10, -225);
//   %wire_1847 = &"net57" @WIRE(mode="straight") {%p498 %p497};
//   %wire_1848 = &"net57" @WIRE(mode="straight") {#"I1298":3 %p498};
//   %p499 = (8, -225);
//   %wire_1849 = &"net57" @WIRE(mode="straight") {%p499 %p498};
//   %wire_1850 = &"net57" @WIRE(mode="straight") {#"I1298":9 %p499};
//   %p500 = (346, -225);
//   %wire_1851 = &"net57" @WIRE(mode="straight") {#"I1309":9 %p500};
//   %p501 = (322, -225);
//   %wire_1852 = &"net57" @WIRE(mode="straight") {%p501 %p500};
//   %p502 = (226, -225);
//   %wire_1853 = &"net57" @WIRE(mode="straight") {#"I1304":9 %p502};
//   %wire_1854 = &"net57" @WIRE(mode="straight") {#"I1308":9 %p501};
//   %p503 = (298, -225);
//   %wire_1855 = &"net57" @WIRE(mode="straight") {%p503 %p501};
//   %p504 = (370, -225);
//   %wire_1856 = &"net57" @WIRE(mode="straight") {%p500 %p504};
//   %p505 = (250, -225);
//   %p506 = (274, -225);
//   %wire_1857 = &"net57" @WIRE(mode="straight") {%p505 %p506};
//   %p507 = (394, -225);
//   %wire_1858 = &"net57" @WIRE(mode="straight") {%p504 %p507};
//   %p508 = (190, -225);
//   %wire_1859 = &"net57" @WIRE(mode="straight") {#"I1303":9 %p508};
//   %wire_1860 = &"net57" @WIRE(mode="straight") {#"I1310":9 %p504};
//   %wire_1861 = &"net57" @WIRE(mode="straight") {#"I1307":9 %p503};
//   %wire_1862 = &"net57" @WIRE(mode="straight") {%p506 %p503};
//   %wire_1863 = &"net57" @WIRE(mode="straight") {#"I1306":9 %p506};
//   %wire_1864 = &"net57" @WIRE(mode="straight") {#"I1311":9 %p507};
//   %wire_1865 = &"net57" @WIRE(mode="straight") {%p492 %p508};
//   %wire_1866 = &"net57" @WIRE(mode="straight") {#"I1299":9 %p505};
//   %wire_1867 = &"net57" @WIRE(mode="straight") {%p502 %p505};
//   %wire_1868 = &"net57" @WIRE(mode="straight") {%p508 %p502};
//   %p509 = (326, -369);
//   %wire_1869 = &"net59" @WIRE(mode="straight") {#"I1342":6 %p509};
//   %p510 = (352, -367);
//   %wire_1870 = &"net59" @WIRE(mode="straight") {%p509 %p510};
//   %wire_1871 = &"net59" @WIRE(mode="straight") {#"I1343":7 %p510};
//   %p511 = (372, -369);
//   %wire_1872 = &"net59" @WIRE(mode="straight") {#"I1344":3 %p511};
//   %wire_1873 = &"net59" @WIRE(mode="straight") {%p511 %p510};
//   %p512 = (215, -381);
//   %wire_1874 = &"net61" @WIRE(mode="straight") {%p512 #"I1338":4};
//   %p513 = (215, -384);
//   %wire_1875 = &"net61" @WIRE(mode="straight") {%p513 %p512};
//   %wire_1876 = &"net61" @WIRE(mode="straight") {%p512 #"M155":1};
//   %wire_1877 = &"net61" @WIRE(mode="straight") {#"M55":1 %p513};
//   %wire_1878 = &"net61" @WIRE(mode="straight") {#"I1342":4 #"I1343":4};
//   %wire_1879 = &"net61" @WIRE(mode="straight") {#"I1344":4 #"I1345":4};
//   %wire_1880 = &"net61" @WIRE(mode="straight") {#"I1333":4 #"I1340":4};
//   %wire_1881 = &"net61" @WIRE(mode="straight") {#"I1341":4 #"I1342":4};
//   %wire_1882 = &"net61" @WIRE(mode="straight") {#"I1340":4 #"I1341":4};
//   %wire_1883 = &"net61" @WIRE(mode="straight") {#"I1343":4 #"I1344":4};
//   %wire_1884 = &"net61" @WIRE(mode="straight") {#"I1338":4 #"I1333":4};
//   %p514 = (328, -393);
//   %wire_1885 = &"net62" @WIRE(mode="straight") {%p514 #"I1342":5};
//   %p515 = (124, -393);
//   %wire_1886 = &"net62" @WIRE(mode="straight") {%p515 #"I1334":5};
//   %p516 = (38, -393);
//   %p517 = (62, -393);
//   %wire_1887 = &"net62" @WIRE(mode="straight") {%p516 %p517};
//   %p518 = (86, -393);
//   %wire_1888 = &"net62" @WIRE(mode="straight") {%p517 %p518};
//   %p519 = (14, -393);
//   %wire_1889 = &"net62" @WIRE(mode="straight") {%p519 #"I1332":5};
//   %p520 = (256, -393);
//   %p521 = (280, -393);
//   %wire_1890 = &"net62" @WIRE(mode="straight") {%p520 %p521};
//   %wire_1891 = &"net62" @WIRE(mode="straight") {%p521 #"I1340":5};
//   %p522 = (-4, -393);
//   %wire_1892 = &"net62" @WIRE(mode="straight") {%p522 %p519};
//   %p523 = (400, -393);
//   %wire_1893 = &"net62" @WIRE(mode="straight") {%p523 #"I1345":5};
//   %wire_1894 = &"net62" @WIRE(mode="straight") {%p518 #"I1329":5};
//   %wire_1895 = &"net62" @WIRE(mode="straight") {%p522 #"I1494":2};
//   %wire_1896 = &"net62" @WIRE(mode="straight") {%p523 #"I1339":2};
//   %p524 = (352, -393);
//   %wire_1897 = &"net62" @WIRE(mode="straight") {%p514 %p524};
//   %p525 = (376, -393);
//   %wire_1898 = &"net62" @WIRE(mode="straight") {%p525 %p523};
//   %p526 = (196, -393);
//   %wire_1899 = &"net62" @WIRE(mode="straight") {%p526 #"I1337":5};
//   %wire_1900 = &"net62" @WIRE(mode="straight") {%p517 #"I1330":5};
//   %wire_1901 = &"net62" @WIRE(mode="straight") {%p524 #"I1343":5};
//   %p527 = (172, -393);
//   %wire_1902 = &"net62" @WIRE(mode="straight") {%p527 %p526};
//   %p528 = (304, -393);
//   %wire_1903 = &"net62" @WIRE(mode="straight") {%p521 %p528};
//   %wire_1904 = &"net62" @WIRE(mode="straight") {%p528 #"I1341":5};
//   %p529 = (232, -393);
//   %wire_1905 = &"net62" @WIRE(mode="straight") {%p529 %p520};
//   %p530 = (148, -393);
//   %wire_1906 = &"net62" @WIRE(mode="straight") {%p530 %p527};
//   %wire_1907 = &"net62" @WIRE(mode="straight") {%p520 #"I1333":5};
//   %wire_1908 = &"net62" @WIRE(mode="straight") {%p525 #"I1344":5};
//   %wire_1909 = &"net62" @WIRE(mode="straight") {%p519 %p516};
//   %wire_1910 = &"net62" @WIRE(mode="straight") {%p526 %p529};
//   %wire_1911 = &"net62" @WIRE(mode="straight") {%p524 %p525};
//   %wire_1912 = &"net62" @WIRE(mode="straight") {%p518 %p515};
//   %wire_1913 = &"net62" @WIRE(mode="straight") {%p516 #"I1331":5};
//   %wire_1914 = &"net62" @WIRE(mode="straight") {%p515 %p530};
//   %wire_1915 = &"net62" @WIRE(mode="straight") {%p527 #"I1336":5};
//   %wire_1916 = &"net62" @WIRE(mode="straight") {%p528 %p514};
//   %wire_1917 = &"net62" @WIRE(mode="straight") {%p529 #"I1338":5};
//   %wire_1918 = &"net62" @WIRE(mode="straight") {%p530 #"I1335":5};
//   %p531 = (324, -369);
//   %wire_1919 = &"net67" @WIRE(mode="straight") {#"I1342":3 %p531};
//   %p532 = (304, -367);
//   %wire_1920 = &"net67" @WIRE(mode="straight") {#"I1341":7 %p532};
//   %p533 = (278, -369);
//   %wire_1921 = &"net67" @WIRE(mode="straight") {#"I1340":6 %p533};
//   %wire_1922 = &"net67" @WIRE(mode="straight") {%p531 %p532};
//   %wire_1923 = &"net67" @WIRE(mode="straight") {%p533 %p532};
//   %p534 = (302, -369);
//   %wire_1924 = &"net71" @WIRE(mode="straight") {#"I1341":6 %p534};
//   %p535 = (328, -367);
//   %wire_1925 = &"net71" @WIRE(mode="straight") {#"I1342":7 %p535};
//   %wire_1926 = &"net71" @WIRE(mode="straight") {%p534 %p535};
//   %p536 = (348, -369);
//   %wire_1927 = &"net71" @WIRE(mode="straight") {#"I1343":3 %p536};
//   %wire_1928 = &"net71" @WIRE(mode="straight") {%p536 %p535};
//   %wire_1929 = &"net6" @WIRE(mode="straight") {#"I1579":1 %marker_142};
//   %wire_1930 = &"net6" @WIRE(mode="straight") {#"I1567":1 #"I1579":1};
//   %wire_1931 = &"net6" @WIRE(mode="straight") {#"I1207":3 #"I1418":1};
//   %wire_1932 = &"net6" @WIRE(mode="straight") {#"I1169":1 #"I1401":1};
//   %wire_1933 = &"net6" @WIRE(mode="straight") {#"I1401":1 #"I1129":1};
//   %wire_1934 = &"net6" @WIRE(mode="straight") {#"I1049":1 #"I1350":1};
//   %wire_1935 = &"net6" @WIRE(mode="straight") {#"I1265":1 #"I809":1};
//   %wire_1936 = &"net6" @WIRE(mode="straight") {#"I1299":1 #"I889":1};
//   %wire_1937 = &"net6" @WIRE(mode="straight") {#"I1089":1 #"I1367":1};
//   %wire_1938 = &"net6" @WIRE(mode="straight") {#"I809":1 #"I776":1};
//   %wire_1939 = &"net6" @WIRE(mode="straight") {#"I969":1 #"I1316":1};
//   %wire_1940 = &"net6" @WIRE(mode="straight") {#"I1367":1 #"I1049":1};
//   %wire_1941 = &"net6" @WIRE(mode="straight") {#"I1333":1 #"I969":1};
//   %wire_1942 = &"net6" @WIRE(mode="straight") {#"I1129":1 #"I1384":1};
//   %wire_1943 = &"net6" @WIRE(mode="straight") {#"I1384":1 #"I1089":1};
//   %wire_1944 = &"net6" @WIRE(mode="straight") {#"I849":1 #"I1265":1};
//   %wire_1945 = &"net6" @WIRE(mode="straight") {#"I1009":1 #"I1333":1};
//   %wire_1946 = &"net6" @WIRE(mode="straight") {#"I776":1 #"I613":1};
//   %wire_1947 = &"net6" @WIRE(mode="straight") {#"I1350":1 #"I1009":1};
//   %wire_1948 = &"net6" @WIRE(mode="straight") {#"I1418":1 #"I1169":1};
//   %wire_1949 = &"net6" @WIRE(mode="straight") {#"I1316":1 #"I929":1};
//   %wire_1950 = &"net6" @WIRE(mode="straight") {#"I889":1 #"I1282":1};
//   %wire_1951 = &"net6" @WIRE(mode="straight") {#"I929":1 #"I1299":1};
//   %wire_1952 = &"net6" @WIRE(mode="straight") {#"I613":1 #"I1567":1};
//   %wire_1953 = &"net6" @WIRE(mode="straight") {#"I1282":1 #"I849":1};
//   %p537 = (-26, -733);
//   %wire_1954 = &"net113" @WIRE(mode="straight") {%p537 #"I1535":1};
//   %p538 = (-18, -731);
//   %wire_1955 = &"net113" @WIRE(mode="straight") {%p538 #"M85":1};
//   %wire_1956 = &"net113" @WIRE(mode="straight") {#"I1535":1 %p538};
//   %wire_1957 = &"net113" @WIRE(mode="straight") {#"I1538":2 %p537};
//   %p539 = (97, -731);
//   %wire_1958 = &"net113" @WIRE(mode="straight") {#"M43":3 %p539};
//   %p540 = (97, -728);
//   %wire_1959 = &"net113" @WIRE(mode="straight") {%p539 %p540};
//   %wire_1960 = &"net113" @WIRE(mode="straight") {#"I1416":4 #"I1415":4};
//   %wire_1961 = &"net113" @WIRE(mode="straight") {%p538 #"I1417":4};
//   %wire_1962 = &"net113" @WIRE(mode="straight") {#"I1417":4 #"I1416":4};
//   %wire_1963 = &"net113" @WIRE(mode="straight") {#"I1415":4 #"I1414":4};
//   %wire_1964 = &"net113" @WIRE(mode="straight") {%p540 #"M150":3};
//   %wire_1965 = &"net113" @WIRE(mode="straight") {#"I1414":4 %p539};
//   %p541 = (374, -19);
//   %p542 = (400, -17);
//   %wire_1966 = &"net244" @WIRE(mode="straight") {%p541 %p542};
//   %wire_1967 = &"net244" @WIRE(mode="straight") {#"I784":6 %p541};
//   %wire_1968 = &"net244" @WIRE(mode="straight") {#"I783":7 %p542};
//   %p543 = (254, -684);
//   %wire_1969 = &"net118" @WIRE(mode="straight") {#"I1169":6 %p543};
//   %p544 = (252, -684);
//   %wire_1970 = &"net118" @WIRE(mode="straight") {%p544 %p543};
//   %wire_1971 = &"net118" @WIRE(mode="straight") {#"I1169":3 %p544};
//   %p545 = (232, -684);
//   %wire_1972 = &"net118" @WIRE(mode="straight") {%p545 %p544};
//   %wire_1973 = &"net118" @WIRE(mode="straight") {#"I1170":7 %p545};
//   %wire_1974 = &"net119" @WIRE(mode="straight") {#"I1184":4 #"I1183":4};
//   %wire_1975 = &"net119" @WIRE(mode="straight") {#"I1185":4 #"I1184":4};
//   %wire_1976 = &"net119" @WIRE(mode="straight") {#"I1186":4 #"I1185":4};
//   %wire_1977 = &"net119" @WIRE(mode="straight") {#"I1187":4 #"I1186":4};
//   %wire_1978 = &"net119" @WIRE(mode="straight") {#"I1188":4 #"I1187":4};
//   %wire_1979 = &"net119" @WIRE(mode="straight") {#"I1169":4 #"I1188":4};
//   %wire_1980 = &"net119" @WIRE(mode="straight") {#"I1170":4 #"I1169":4};
//   %p546 = (215, -699);
//   %wire_1981 = &"net119" @WIRE(mode="straight") {#"M45":1 %p546};
//   %p547 = (215, -696);
//   %wire_1982 = &"net119" @WIRE(mode="straight") {%p546 %p547};
//   %wire_1983 = &"net119" @WIRE(mode="straight") {%p547 #"I1170":4};
//   %wire_1984 = &"net119" @WIRE(mode="straight") {%p547 #"M152":1};
//   %p548 = (278, -684);
//   %wire_1985 = &"net120" @WIRE(mode="straight") {#"I1188":6 %p548};
//   %p549 = (276, -684);
//   %wire_1986 = &"net120" @WIRE(mode="straight") {%p549 %p548};
//   %wire_1987 = &"net120" @WIRE(mode="straight") {#"I1188":3 %p549};
//   %p550 = (256, -684);
//   %wire_1988 = &"net120" @WIRE(mode="straight") {%p550 %p549};
//   %wire_1989 = &"net120" @WIRE(mode="straight") {#"I1169":7 %p550};
//   %p551 = (230, -684);
//   %wire_1990 = &"net121" @WIRE(mode="straight") {#"I1170":6 %p551};
//   %p552 = (228, -684);
//   %wire_1991 = &"net121" @WIRE(mode="straight") {%p552 %p551};
//   %wire_1992 = &"net121" @WIRE(mode="straight") {#"I1170":3 %p552};
//   %p553 = (196, -684);
//   %wire_1993 = &"net121" @WIRE(mode="straight") {%p553 %p552};
//   %wire_1994 = &"net121" @WIRE(mode="straight") {#"I1171":7 %p553};
//   %p554 = (194, -684);
//   %wire_1995 = &"net122" @WIRE(mode="straight") {#"I1171":6 %p554};
//   %p555 = (192, -684);
//   %wire_1996 = &"net122" @WIRE(mode="straight") {%p555 %p554};
//   %wire_1997 = &"net122" @WIRE(mode="straight") {#"I1171":3 %p555};
//   %p556 = (172, -684);
//   %wire_1998 = &"net122" @WIRE(mode="straight") {%p556 %p555};
//   %wire_1999 = &"net122" @WIRE(mode="straight") {#"I1172":7 %p556};
//   %p557 = (205, -696);
//   %p558 = (205, -693);
//   %wire_2000 = &"net123" @WIRE(mode="straight") {%p557 %p558};
//   %wire_2001 = &"net123" @WIRE(mode="straight") {#"M45":3 %p557};
//   %p559 = (107, -696);
//   %wire_2002 = &"net123" @WIRE(mode="straight") {%p559 #"M149":1};
//   %p560 = (107, -699);
//   %wire_2003 = &"net123" @WIRE(mode="straight") {#"M42":1 %p560};
//   %wire_2004 = &"net123" @WIRE(mode="straight") {#"I1171":4 %p557};
//   %wire_2005 = &"net123" @WIRE(mode="straight") {#"I1172":4 #"I1171":4};
//   %wire_2006 = &"net123" @WIRE(mode="straight") {#"I1173":4 #"I1172":4};
//   %wire_2007 = &"net123" @WIRE(mode="straight") {#"I1174":4 #"I1173":4};
//   %wire_2008 = &"net123" @WIRE(mode="straight") {%p560 %p559};
//   %wire_2009 = &"net123" @WIRE(mode="straight") {%p559 #"I1174":4};
//   %wire_2010 = &"net123" @WIRE(mode="straight") {%p558 #"M152":3};
//   %p561 = (170, -684);
//   %wire_2011 = &"net124" @WIRE(mode="straight") {#"I1172":6 %p561};
//   %p562 = (168, -684);
//   %wire_2012 = &"net124" @WIRE(mode="straight") {%p562 %p561};
//   %wire_2013 = &"net124" @WIRE(mode="straight") {#"I1172":3 %p562};
//   %p563 = (148, -684);
//   %wire_2014 = &"net124" @WIRE(mode="straight") {%p563 %p562};
//   %wire_2015 = &"net124" @WIRE(mode="straight") {#"I1173":7 %p563};
//   %p564 = (346, -365);
//   %p565 = (370, -365);
//   %wire_2016 = &"net72" @WIRE(mode="straight") {%p564 %p565};
//   %p566 = (226, -365);
//   %wire_2017 = &"net72" @WIRE(mode="straight") {#"I1338":9 %p566};
//   %wire_2018 = &"net72" @WIRE(mode="straight") {#"I1344":9 %p565};
//   %p567 = (10, -365);
//   %p568 = (32, -365);
//   %wire_2019 = &"net72" @WIRE(mode="straight") {%p567 %p568};
//   %wire_2020 = &"net72" @WIRE(mode="straight") {#"I1331":9 %p568};
//   %p569 = (394, -365);
//   %wire_2021 = &"net72" @WIRE(mode="straight") {%p565 %p569};
//   %wire_2022 = &"net72" @WIRE(mode="straight") {#"I1345":9 %p569};
//   %p570 = (250, -365);
//   %wire_2023 = &"net72" @WIRE(mode="straight") {#"I1333":9 %p570};
//   %p571 = (274, -365);
//   %wire_2024 = &"net72" @WIRE(mode="straight") {%p570 %p571};
//   %wire_2025 = &"net72" @WIRE(mode="straight") {#"I1343":9 %p564};
//   %wire_2026 = &"net72" @WIRE(mode="straight") {%p566 %p570};
//   %p572 = (190, -365);
//   %wire_2027 = &"net72" @WIRE(mode="straight") {#"I1337":9 %p572};
//   %wire_2028 = &"net72" @WIRE(mode="straight") {%p572 %p566};
//   %p573 = (322, -365);
//   %wire_2029 = &"net72" @WIRE(mode="straight") {%p573 %p564};
//   %p574 = (118, -365);
//   %p575 = (142, -365);
//   %wire_2030 = &"net72" @WIRE(mode="straight") {%p574 %p575};
//   %p576 = (56, -365);
//   %wire_2031 = &"net72" @WIRE(mode="straight") {#"I1330":9 %p576};
//   %p577 = (80, -365);
//   %wire_2032 = &"net72" @WIRE(mode="straight") {#"I1329":9 %p577};
//   %wire_2033 = &"net72" @WIRE(mode="straight") {%p576 %p577};
//   %p578 = (298, -365);
//   %wire_2034 = &"net72" @WIRE(mode="straight") {%p578 %p573};
//   %p579 = (166, -365);
//   %wire_2035 = &"net72" @WIRE(mode="straight") {#"I1336":9 %p579};
//   %wire_2036 = &"net72" @WIRE(mode="straight") {#"I1334":9 %p574};
//   %wire_2037 = &"net72" @WIRE(mode="straight") {#"I1340":9 %p571};
//   %p580 = (8, -365);
//   %wire_2038 = &"net72" @WIRE(mode="straight") {#"I1332":9 %p580};
//   %wire_2039 = &"net72" @WIRE(mode="straight") {#"I1341":9 %p578};
//   %wire_2040 = &"net72" @WIRE(mode="straight") {%p579 %p572};
//   %wire_2041 = &"net72" @WIRE(mode="straight") {#"I1332":3 %p567};
//   %wire_2042 = &"net72" @WIRE(mode="straight") {%p580 %p567};
//   %wire_2043 = &"net72" @WIRE(mode="straight") {%p568 %p576};
//   %wire_2044 = &"net72" @WIRE(mode="straight") {#"I1342":9 %p573};
//   %wire_2045 = &"net72" @WIRE(mode="straight") {%p575 %p579};
//   %wire_2046 = &"net72" @WIRE(mode="straight") {%p571 %p578};
//   %wire_2047 = &"net72" @WIRE(mode="straight") {%p577 %p574};
//   %wire_2048 = &"net72" @WIRE(mode="straight") {#"I1335":9 %p575};
//   %p581 = (192, -89);
//   %wire_2049 = &"net75" @WIRE(mode="straight") {#"I1269":3 %p581};
//   %p582 = (172, -87);
//   %wire_2050 = &"net75" @WIRE(mode="straight") {%p581 %p582};
//   %wire_2051 = &"net75" @WIRE(mode="straight") {#"I1268":7 %p582};
//   %p583 = (146, -89);
//   %wire_2052 = &"net75" @WIRE(mode="straight") {%p583 %p582};
//   %wire_2053 = &"net75" @WIRE(mode="straight") {#"I1267":6 %p583};
//   %p584 = (205, -98);
//   %wire_2054 = &"net77" @WIRE(mode="straight") {%p584 #"M170":3};
//   %p585 = (205, -101);
//   %wire_2055 = &"net77" @WIRE(mode="straight") {#"I1269":4 %p585};
//   %wire_2056 = &"net77" @WIRE(mode="straight") {#"I1268":4 #"I1269":4};
//   %wire_2057 = &"net77" @WIRE(mode="straight") {#"I1267":4 #"I1268":4};
//   %wire_2058 = &"net77" @WIRE(mode="straight") {#"I1266":4 #"I1267":4};
//   %p586 = (107, -101);
//   %wire_2059 = &"net77" @WIRE(mode="straight") {%p586 #"I1266":4};
//   %wire_2060 = &"net77" @WIRE(mode="straight") {%p585 %p584};
//   %wire_2061 = &"net77" @WIRE(mode="straight") {%p586 #"M132":1};
//   %wire_2062 = &"net77" @WIRE(mode="straight") {#"M63":3 %p585};
//   %p587 = (107, -104);
//   %wire_2063 = &"net77" @WIRE(mode="straight") {%p587 %p586};
//   %wire_2064 = &"net77" @WIRE(mode="straight") {#"M25":1 %p587};
//   %p588 = (14, -113);
//   %wire_2065 = &"net79" @WIRE(mode="straight") {%p588 #"I1264":5};
//   %p589 = (400, -113);
//   %wire_2066 = &"net79" @WIRE(mode="straight") {%p589 #"I1271":2};
//   %wire_2067 = &"net79" @WIRE(mode="straight") {%p589 #"I1277":5};
//   %p590 = (376, -113);
//   %wire_2068 = &"net79" @WIRE(mode="straight") {%p590 %p589};
//   %wire_2069 = &"net79" @WIRE(mode="straight") {%p590 #"I1276":5};
//   %p591 = (352, -113);
//   %wire_2070 = &"net79" @WIRE(mode="straight") {%p591 %p590};
//   %wire_2071 = &"net79" @WIRE(mode="straight") {%p591 #"I1275":5};
//   %p592 = (328, -113);
//   %wire_2072 = &"net79" @WIRE(mode="straight") {%p592 %p591};
//   %p593 = (304, -113);
//   %wire_2073 = &"net79" @WIRE(mode="straight") {%p593 %p592};
//   %wire_2074 = &"net79" @WIRE(mode="straight") {%p592 #"I1274":5};
//   %p594 = (38, -113);
//   %wire_2075 = &"net79" @WIRE(mode="straight") {%p588 %p594};
//   %wire_2076 = &"net79" @WIRE(mode="straight") {%p593 #"I1273":5};
//   %p595 = (280, -113);
//   %wire_2077 = &"net79" @WIRE(mode="straight") {%p595 #"I1272":5};
//   %wire_2078 = &"net79" @WIRE(mode="straight") {%p594 #"I1263":5};
//   %p596 = (256, -113);
//   %wire_2079 = &"net79" @WIRE(mode="straight") {%p596 #"I1265":5};
//   %p597 = (232, -113);
//   %wire_2080 = &"net79" @WIRE(mode="straight") {%p597 %p596};
//   %wire_2081 = &"net79" @WIRE(mode="straight") {%p597 #"I1270":5};
//   %p598 = (196, -113);
//   %wire_2082 = &"net79" @WIRE(mode="straight") {%p598 %p597};
//   %wire_2083 = &"net79" @WIRE(mode="straight") {%p598 #"I1269":5};
//   %p599 = (172, -113);
//   %wire_2084 = &"net79" @WIRE(mode="straight") {%p599 %p598};
//   %wire_2085 = &"net79" @WIRE(mode="straight") {%p595 %p593};
//   %wire_2086 = &"net79" @WIRE(mode="straight") {%p599 #"I1268":5};
//   %p600 = (148, -113);
//   %wire_2087 = &"net79" @WIRE(mode="straight") {%p600 %p599};
//   %wire_2088 = &"net79" @WIRE(mode="straight") {%p600 #"I1267":5};
//   %p601 = (124, -113);
//   %wire_2089 = &"net79" @WIRE(mode="straight") {%p601 %p600};
//   %wire_2090 = &"net79" @WIRE(mode="straight") {%p601 #"I1266":5};
//   %p602 = (86, -113);
//   %wire_2091 = &"net79" @WIRE(mode="straight") {%p602 %p601};
//   %wire_2092 = &"net79" @WIRE(mode="straight") {%p596 %p595};
//   %wire_2093 = &"net79" @WIRE(mode="straight") {%p602 #"I1261":5};
//   %p603 = (62, -113);
//   %wire_2094 = &"net79" @WIRE(mode="straight") {%p603 %p602};
//   %wire_2095 = &"net79" @WIRE(mode="straight") {%p603 #"I1262":5};
//   %p604 = (-4, -113);
//   %wire_2096 = &"net79" @WIRE(mode="straight") {%p604 #"I1462":2};
//   %wire_2097 = &"net79" @WIRE(mode="straight") {%p594 %p603};
//   %wire_2098 = &"net79" @WIRE(mode="straight") {%p604 %p588};
//   %p605 = (144, -89);
//   %wire_2099 = &"net80" @WIRE(mode="straight") {#"I1267":3 %p605};
//   %p606 = (124, -87);
//   %wire_2100 = &"net80" @WIRE(mode="straight") {%p605 %p606};
//   %wire_2101 = &"net80" @WIRE(mode="straight") {#"I1266":7 %p606};
//   %p607 = (84, -89);
//   %wire_2102 = &"net80" @WIRE(mode="straight") {#"I1261":6 %p607};
//   %wire_2103 = &"net80" @WIRE(mode="straight") {%p606 %p607};
//   %wire_2104 = &"net2241" @WIRE(mode="straight") {#"I1502":3 #"M77":2};
//   %p608 = (-23, -405);
//   %wire_2105 = &"net2241" @WIRE(mode="straight") {%p608 #"I1509":1};
//   %p609 = (-23, -442);
//   %wire_2106 = &"net2241" @WIRE(mode="straight") {%p609 %p608};
//   %wire_2107 = &"net2241" @WIRE(mode="straight") {%p609 #"M77":2};
//   %p610 = (14, -87);
//   %wire_2108 = &"net427" @WIRE(mode="straight") {#"I1264":7 %p610};
//   %p611 = (34, -89);
//   %wire_2109 = &"net427" @WIRE(mode="straight") {%p611 %p610};
//   %wire_2110 = &"net427" @WIRE(mode="straight") {#"I1263":3 %p611};
//   %p612 = (-4, -87);
//   %wire_2111 = &"net427" @WIRE(mode="straight") {#"I1462":1 %p612};
//   %wire_2112 = &"net427" @WIRE(mode="straight") {%p612 %p610};
//   %p613 = (398, -684);
//   %wire_2113 = &"net136" @WIRE(mode="straight") {#"I1183":6 %p613};
//   %p614 = (396, -684);
//   %wire_2114 = &"net136" @WIRE(mode="straight") {%p614 %p613};
//   %wire_2115 = &"net136" @WIRE(mode="straight") {#"I1183":3 %p614};
//   %p615 = (376, -684);
//   %wire_2116 = &"net136" @WIRE(mode="straight") {%p615 %p614};
//   %wire_2117 = &"net136" @WIRE(mode="straight") {#"I1184":7 %p615};
//   %p616 = (398, -680);
//   %wire_2118 = &"net137" @WIRE(mode="straight") {%p616 #"I1413":6};
//   %p617 = (400, -680);
//   %wire_2119 = &"net137" @WIRE(mode="straight") {#"I1183":7 %p617};
//   %wire_2120 = &"net137" @WIRE(mode="straight") {%p616 %p617};
//   %p618 = (374, -684);
//   %wire_2121 = &"net138" @WIRE(mode="straight") {#"I1184":6 %p618};
//   %p619 = (372, -684);
//   %wire_2122 = &"net138" @WIRE(mode="straight") {%p619 %p618};
//   %wire_2123 = &"net138" @WIRE(mode="straight") {#"I1184":3 %p619};
//   %p620 = (352, -684);
//   %wire_2124 = &"net138" @WIRE(mode="straight") {%p620 %p619};
//   %wire_2125 = &"net138" @WIRE(mode="straight") {#"I1185":7 %p620};
//   %p621 = (350, -684);
//   %wire_2126 = &"net139" @WIRE(mode="straight") {#"I1185":6 %p621};
//   %p622 = (348, -684);
//   %wire_2127 = &"net139" @WIRE(mode="straight") {%p622 %p621};
//   %wire_2128 = &"net139" @WIRE(mode="straight") {#"I1185":3 %p622};
//   %p623 = (328, -684);
//   %wire_2129 = &"net139" @WIRE(mode="straight") {%p623 %p622};
//   %wire_2130 = &"net139" @WIRE(mode="straight") {#"I1186":7 %p623};
//   %p624 = (326, -684);
//   %wire_2131 = &"net141" @WIRE(mode="straight") {#"I1186":6 %p624};
//   %p625 = (324, -684);
//   %wire_2132 = &"net141" @WIRE(mode="straight") {%p625 %p624};
//   %wire_2133 = &"net141" @WIRE(mode="straight") {#"I1186":3 %p625};
//   %p626 = (304, -684);
//   %wire_2134 = &"net141" @WIRE(mode="straight") {%p626 %p625};
//   %wire_2135 = &"net141" @WIRE(mode="straight") {#"I1187":7 %p626};
//   %p627 = (302, -684);
//   %wire_2136 = &"net142" @WIRE(mode="straight") {#"I1187":6 %p627};
//   %p628 = (300, -684);
//   %wire_2137 = &"net142" @WIRE(mode="straight") {%p628 %p627};
//   %wire_2138 = &"net142" @WIRE(mode="straight") {#"I1187":3 %p628};
//   %p629 = (280, -684);
//   %wire_2139 = &"net142" @WIRE(mode="straight") {%p629 %p628};
//   %wire_2140 = &"net142" @WIRE(mode="straight") {#"I1188":7 %p629};
//   %p630 = (168, -89);
//   %wire_2141 = &"net97" @WIRE(mode="straight") {#"I1268":3 %p630};
//   %p631 = (148, -87);
//   %wire_2142 = &"net97" @WIRE(mode="straight") {%p630 %p631};
//   %wire_2143 = &"net97" @WIRE(mode="straight") {#"I1267":7 %p631};
//   %p632 = (122, -89);
//   %wire_2144 = &"net97" @WIRE(mode="straight") {%p632 %p631};
//   %wire_2145 = &"net97" @WIRE(mode="straight") {#"I1266":6 %p632};
//   %p633 = (394, -85);
//   %wire_2146 = &"net99" @WIRE(mode="straight") {#"I1277":9 %p633};
//   %p634 = (370, -85);
//   %wire_2147 = &"net99" @WIRE(mode="straight") {%p634 %p633};
//   %p635 = (346, -85);
//   %wire_2148 = &"net99" @WIRE(mode="straight") {%p635 %p634};
//   %p636 = (32, -85);
//   %wire_2149 = &"net99" @WIRE(mode="straight") {#"I1263":9 %p636};
//   %wire_2150 = &"net99" @WIRE(mode="straight") {#"I1275":9 %p635};
//   %p637 = (322, -85);
//   %wire_2151 = &"net99" @WIRE(mode="straight") {%p637 %p635};
//   %wire_2152 = &"net99" @WIRE(mode="straight") {#"I1274":9 %p637};
//   %p638 = (298, -85);
//   %wire_2153 = &"net99" @WIRE(mode="straight") {%p638 %p637};
//   %wire_2154 = &"net99" @WIRE(mode="straight") {#"I1273":9 %p638};
//   %p639 = (10, -85);
//   %wire_2155 = &"net99" @WIRE(mode="straight") {%p639 %p636};
//   %p640 = (274, -85);
//   %wire_2156 = &"net99" @WIRE(mode="straight") {%p640 %p638};
//   %p641 = (250, -85);
//   %wire_2157 = &"net99" @WIRE(mode="straight") {%p641 %p640};
//   %p642 = (226, -85);
//   %wire_2158 = &"net99" @WIRE(mode="straight") {%p642 %p641};
//   %wire_2159 = &"net99" @WIRE(mode="straight") {#"I1270":9 %p642};
//   %p643 = (190, -85);
//   %wire_2160 = &"net99" @WIRE(mode="straight") {%p643 %p642};
//   %wire_2161 = &"net99" @WIRE(mode="straight") {#"I1269":9 %p643};
//   %p644 = (166, -85);
//   %wire_2162 = &"net99" @WIRE(mode="straight") {#"I1268":9 %p644};
//   %p645 = (142, -85);
//   %wire_2163 = &"net99" @WIRE(mode="straight") {%p645 %p644};
//   %wire_2164 = &"net99" @WIRE(mode="straight") {#"I1276":9 %p634};
//   %wire_2165 = &"net99" @WIRE(mode="straight") {#"I1267":9 %p645};
//   %p646 = (118, -85);
//   %wire_2166 = &"net99" @WIRE(mode="straight") {%p646 %p645};
//   %wire_2167 = &"net99" @WIRE(mode="straight") {#"I1272":9 %p640};
//   %p647 = (56, -85);
//   %wire_2168 = &"net99" @WIRE(mode="straight") {#"I1262":9 %p647};
//   %wire_2169 = &"net99" @WIRE(mode="straight") {#"I1266":9 %p646};
//   %wire_2170 = &"net99" @WIRE(mode="straight") {#"I1265":9 %p641};
//   %p648 = (80, -85);
//   %wire_2171 = &"net99" @WIRE(mode="straight") {%p648 %p646};
//   %wire_2172 = &"net99" @WIRE(mode="straight") {%p636 %p647};
//   %wire_2173 = &"net99" @WIRE(mode="straight") {#"I1261":9 %p648};
//   %wire_2174 = &"net99" @WIRE(mode="straight") {%p647 %p648};
//   %wire_2175 = &"net99" @WIRE(mode="straight") {%p644 %p643};
//   %p649 = (8, -85);
//   %wire_2176 = &"net99" @WIRE(mode="straight") {%p649 %p639};
//   %wire_2177 = &"net99" @WIRE(mode="straight") {#"I1264":3 %p639};
//   %wire_2178 = &"net99" @WIRE(mode="straight") {#"I1264":9 %p649};
//   %p650 = (228, -89);
//   %wire_2179 = &"net100" @WIRE(mode="straight") {#"I1270":3 %p650};
//   %p651 = (196, -87);
//   %wire_2180 = &"net100" @WIRE(mode="straight") {%p650 %p651};
//   %wire_2181 = &"net100" @WIRE(mode="straight") {#"I1269":7 %p651};
//   %p652 = (170, -89);
//   %wire_2182 = &"net100" @WIRE(mode="straight") {%p652 %p651};
//   %wire_2183 = &"net100" @WIRE(mode="straight") {#"I1268":6 %p652};
//   %p653 = (252, -89);
//   %wire_2184 = &"net101" @WIRE(mode="straight") {#"I1265":3 %p653};
//   %p654 = (232, -87);
//   %wire_2185 = &"net101" @WIRE(mode="straight") {%p653 %p654};
//   %wire_2186 = &"net101" @WIRE(mode="straight") {#"I1270":7 %p654};
//   %p655 = (194, -89);
//   %wire_2187 = &"net101" @WIRE(mode="straight") {%p655 %p654};
//   %wire_2188 = &"net101" @WIRE(mode="straight") {#"I1269":6 %p655};
//   %p656 = (276, -89);
//   %wire_2189 = &"net102" @WIRE(mode="straight") {#"I1272":3 %p656};
//   %p657 = (256, -87);
//   %wire_2190 = &"net102" @WIRE(mode="straight") {%p656 %p657};
//   %wire_2191 = &"net102" @WIRE(mode="straight") {#"I1265":7 %p657};
//   %p658 = (230, -89);
//   %wire_2192 = &"net102" @WIRE(mode="straight") {#"I1270":6 %p658};
//   %wire_2193 = &"net102" @WIRE(mode="straight") {%p658 %p657};
//   %p659 = (14, -194);
//   %p660 = (34, -194);
//   %wire_2194 = &"net149" @WIRE(mode="straight") {%p659 %p660};
//   %wire_2195 = &"net149" @WIRE(mode="straight") {#"I879":7 %p659};
//   %p661 = (36, -194);
//   %wire_2196 = &"net149" @WIRE(mode="straight") {%p660 %p661};
//   %wire_2197 = &"net149" @WIRE(mode="straight") {#"I880":6 %p661};
//   %wire_2198 = &"net149" @WIRE(mode="straight") {#"I880":3 %p660};
//   %p662 = (38, -194);
//   %wire_2199 = &"net151" @WIRE(mode="straight") {#"I880":7 %p662};
//   %p663 = (58, -194);
//   %wire_2200 = &"net151" @WIRE(mode="straight") {#"I881":3 %p663};
//   %wire_2201 = &"net151" @WIRE(mode="straight") {%p662 %p663};
//   %p664 = (60, -194);
//   %wire_2202 = &"net151" @WIRE(mode="straight") {%p663 %p664};
//   %wire_2203 = &"net151" @WIRE(mode="straight") {#"I881":6 %p664};
//   %p665 = (215, -101);
//   %wire_2204 = &"net105" @WIRE(mode="straight") {%p665 #"I1270":4};
//   %p666 = (215, -104);
//   %wire_2205 = &"net105" @WIRE(mode="straight") {%p666 %p665};
//   %wire_2206 = &"net105" @WIRE(mode="straight") {%p665 #"M170":1};
//   %wire_2207 = &"net105" @WIRE(mode="straight") {#"M63":1 %p666};
//   %wire_2208 = &"net105" @WIRE(mode="straight") {#"I1276":4 #"I1277":4};
//   %wire_2209 = &"net105" @WIRE(mode="straight") {#"I1275":4 #"I1276":4};
//   %wire_2210 = &"net105" @WIRE(mode="straight") {#"I1274":4 #"I1275":4};
//   %wire_2211 = &"net105" @WIRE(mode="straight") {#"I1273":4 #"I1274":4};
//   %wire_2212 = &"net105" @WIRE(mode="straight") {#"I1272":4 #"I1273":4};
//   %wire_2213 = &"net105" @WIRE(mode="straight") {#"I1265":4 #"I1272":4};
//   %wire_2214 = &"net105" @WIRE(mode="straight") {#"I1270":4 #"I1265":4};
//   %p667 = (97, -241);
//   %wire_2215 = &"net153" @WIRE(mode="straight") {#"I1295":4 %p667};
//   %wire_2216 = &"net153" @WIRE(mode="straight") {#"I1296":4 #"I1295":4};
//   %wire_2217 = &"net153" @WIRE(mode="straight") {#"I1297":4 #"I1296":4};
//   %wire_2218 = &"net153" @WIRE(mode="straight") {#"I1298":4 #"I1297":4};
//   %p668 = (-26, -243);
//   %wire_2219 = &"net153" @WIRE(mode="straight") {%p668 #"I1479":1};
//   %p669 = (-18, -241);
//   %wire_2220 = &"net153" @WIRE(mode="straight") {#"I1479":1 %p669};
//   %wire_2221 = &"net153" @WIRE(mode="straight") {#"I1482":2 %p668};
//   %wire_2222 = &"net153" @WIRE(mode="straight") {%p669 #"M71":1};
//   %p670 = (97, -238);
//   %wire_2223 = &"net153" @WIRE(mode="straight") {%p667 %p670};
//   %wire_2224 = &"net153" @WIRE(mode="straight") {%p669 #"I1298":4};
//   %wire_2225 = &"net153" @WIRE(mode="straight") {%p670 #"M136":3};
//   %wire_2226 = &"net153" @WIRE(mode="straight") {#"M29":3 %p667};
//   %p671 = (324, -89);
//   %wire_2227 = &"net106" @WIRE(mode="straight") {#"I1274":3 %p671};
//   %p672 = (304, -87);
//   %wire_2228 = &"net106" @WIRE(mode="straight") {%p671 %p672};
//   %wire_2229 = &"net106" @WIRE(mode="straight") {#"I1273":7 %p672};
//   %p673 = (278, -89);
//   %wire_2230 = &"net106" @WIRE(mode="straight") {%p673 %p672};
//   %wire_2231 = &"net106" @WIRE(mode="straight") {#"I1272":6 %p673};
//   %p674 = (300, -89);
//   %wire_2232 = &"net107" @WIRE(mode="straight") {#"I1273":3 %p674};
//   %p675 = (280, -87);
//   %wire_2233 = &"net107" @WIRE(mode="straight") {%p674 %p675};
//   %wire_2234 = &"net107" @WIRE(mode="straight") {#"I1272":7 %p675};
//   %p676 = (254, -89);
//   %wire_2235 = &"net107" @WIRE(mode="straight") {%p676 %p675};
//   %wire_2236 = &"net107" @WIRE(mode="straight") {#"I1265":6 %p676};
//   %p677 = (-26, -663);
//   %wire_2237 = &"net157" @WIRE(mode="straight") {%p677 #"I1527":1};
//   %p678 = (-18, -661);
//   %wire_2238 = &"net157" @WIRE(mode="straight") {%p678 #"M83":1};
//   %wire_2239 = &"net157" @WIRE(mode="straight") {#"I1527":1 %p678};
//   %wire_2240 = &"net157" @WIRE(mode="straight") {#"I1530":2 %p677};
//   %wire_2241 = &"net157" @WIRE(mode="straight") {#"I1398":4 #"I1397":4};
//   %wire_2242 = &"net157" @WIRE(mode="straight") {%p678 #"I1400":4};
//   %wire_2243 = &"net157" @WIRE(mode="straight") {#"I1399":4 #"I1398":4};
//   %wire_2244 = &"net157" @WIRE(mode="straight") {#"I1400":4 #"I1399":4};
//   %p679 = (97, -658);
//   %wire_2245 = &"net157" @WIRE(mode="straight") {%p679 #"M148":3};
//   %p680 = (97, -661);
//   %wire_2246 = &"net157" @WIRE(mode="straight") {#"M41":3 %p680};
//   %wire_2247 = &"net157" @WIRE(mode="straight") {%p680 %p679};
//   %wire_2248 = &"net157" @WIRE(mode="straight") {#"I1397":4 %p680};
//   %p681 = (60, -159);
//   %p682 = (86, -157);
//   %wire_2249 = &"net109" @WIRE(mode="straight") {%p681 %p682};
//   %wire_2250 = &"net109" @WIRE(mode="straight") {#"I1279":6 %p681};
//   %wire_2251 = &"net109" @WIRE(mode="straight") {#"I1278":7 %p682};
//   %p683 = (120, -159);
//   %wire_2252 = &"net109" @WIRE(mode="straight") {%p683 %p682};
//   %wire_2253 = &"net109" @WIRE(mode="straight") {#"I1283":3 %p683};
//   %p684 = (62, -183);
//   %wire_2254 = &"net110" @WIRE(mode="straight") {%p684 #"I1279":5};
//   %p685 = (86, -183);
//   %wire_2255 = &"net110" @WIRE(mode="straight") {%p684 %p685};
//   %p686 = (38, -183);
//   %wire_2256 = &"net110" @WIRE(mode="straight") {%p686 %p684};
//   %wire_2257 = &"net110" @WIRE(mode="straight") {%p686 #"I1280":5};
//   %p687 = (14, -183);
//   %wire_2258 = &"net110" @WIRE(mode="straight") {%p687 %p686};
//   %wire_2259 = &"net110" @WIRE(mode="straight") {%p687 #"I1281":5};
//   %wire_2260 = &"net110" @WIRE(mode="straight") {%p685 #"I1278":5};
//   %p688 = (400, -183);
//   %wire_2261 = &"net110" @WIRE(mode="straight") {%p688 #"I1288":2};
//   %p689 = (376, -183);
//   %wire_2262 = &"net110" @WIRE(mode="straight") {%p689 %p688};
//   %p690 = (352, -183);
//   %wire_2263 = &"net110" @WIRE(mode="straight") {%p690 %p689};
//   %wire_2264 = &"net110" @WIRE(mode="straight") {%p689 #"I1293":5};
//   %p691 = (124, -183);
//   %wire_2265 = &"net110" @WIRE(mode="straight") {%p691 #"I1283":5};
//   %wire_2266 = &"net110" @WIRE(mode="straight") {%p690 #"I1292":5};
//   %wire_2267 = &"net110" @WIRE(mode="straight") {%p685 %p691};
//   %p692 = (328, -183);
//   %wire_2268 = &"net110" @WIRE(mode="straight") {%p692 #"I1291":5};
//   %p693 = (304, -183);
//   %wire_2269 = &"net110" @WIRE(mode="straight") {%p693 %p692};
//   %wire_2270 = &"net110" @WIRE(mode="straight") {%p688 #"I1294":5};
//   %wire_2271 = &"net110" @WIRE(mode="straight") {%p693 #"I1290":5};
//   %p694 = (280, -183);
//   %wire_2272 = &"net110" @WIRE(mode="straight") {%p694 %p693};
//   %wire_2273 = &"net110" @WIRE(mode="straight") {%p694 #"I1289":5};
//   %p695 = (256, -183);
//   %wire_2274 = &"net110" @WIRE(mode="straight") {%p695 %p694};
//   %wire_2275 = &"net110" @WIRE(mode="straight") {%p692 %p690};
//   %wire_2276 = &"net110" @WIRE(mode="straight") {%p695 #"I1282":5};
//   %p696 = (232, -183);
//   %wire_2277 = &"net110" @WIRE(mode="straight") {%p696 %p695};
//   %wire_2278 = &"net110" @WIRE(mode="straight") {%p696 #"I1287":5};
//   %p697 = (196, -183);
//   %wire_2279 = &"net110" @WIRE(mode="straight") {%p697 %p696};
//   %wire_2280 = &"net110" @WIRE(mode="straight") {%p697 #"I1286":5};
//   %p698 = (172, -183);
//   %wire_2281 = &"net110" @WIRE(mode="straight") {%p698 %p697};
//   %wire_2282 = &"net110" @WIRE(mode="straight") {%p698 #"I1285":5};
//   %p699 = (148, -183);
//   %wire_2283 = &"net110" @WIRE(mode="straight") {%p699 %p698};
//   %wire_2284 = &"net110" @WIRE(mode="straight") {%p699 #"I1284":5};
//   %wire_2285 = &"net110" @WIRE(mode="straight") {%p691 %p699};
//   %p700 = (-4, -183);
//   %wire_2286 = &"net110" @WIRE(mode="straight") {%p700 #"I1470":2};
//   %wire_2287 = &"net110" @WIRE(mode="straight") {%p700 %p687};
//   %p701 = (58, -159);
//   %wire_2288 = &"net111" @WIRE(mode="straight") {#"I1279":3 %p701};
//   %p702 = (38, -157);
//   %wire_2289 = &"net111" @WIRE(mode="straight") {%p701 %p702};
//   %p703 = (12, -159);
//   %wire_2290 = &"net111" @WIRE(mode="straight") {%p703 %p702};
//   %wire_2291 = &"net111" @WIRE(mode="straight") {#"I1281":6 %p703};
//   %wire_2292 = &"net111" @WIRE(mode="straight") {#"I1280":7 %p702};
//   %p704 = (280, -544);
//   %wire_2293 = &"net162" @WIRE(mode="straight") {#"I1108":7 %p704};
//   %p705 = (302, -544);
//   %wire_2294 = &"net162" @WIRE(mode="straight") {#"I1107":6 %p705};
//   %p706 = (300, -544);
//   %wire_2295 = &"net162" @WIRE(mode="straight") {%p706 %p705};
//   %wire_2296 = &"net162" @WIRE(mode="straight") {#"I1107":3 %p706};
//   %wire_2297 = &"net162" @WIRE(mode="straight") {%p704 %p706};
//   %p707 = (215, -556);
//   %wire_2298 = &"net163" @WIRE(mode="straight") {%p707 #"I1090":4};
//   %p708 = (215, -559);
//   %wire_2299 = &"net163" @WIRE(mode="straight") {%p708 %p707};
//   %wire_2300 = &"net163" @WIRE(mode="straight") {%p707 #"M157":1};
//   %wire_2301 = &"net163" @WIRE(mode="straight") {#"M50":1 %p708};
//   %wire_2302 = &"net163" @WIRE(mode="straight") {#"I1104":4 #"I1103":4};
//   %wire_2303 = &"net163" @WIRE(mode="straight") {#"I1105":4 #"I1104":4};
//   %wire_2304 = &"net163" @WIRE(mode="straight") {#"I1106":4 #"I1105":4};
//   %wire_2305 = &"net163" @WIRE(mode="straight") {#"I1108":4 #"I1107":4};
//   %wire_2306 = &"net163" @WIRE(mode="straight") {#"I1090":4 #"I1089":4};
//   %wire_2307 = &"net163" @WIRE(mode="straight") {#"I1107":4 #"I1106":4};
//   %wire_2308 = &"net163" @WIRE(mode="straight") {#"I1089":4 #"I1108":4};
//   %p709 = (-20, -568);
//   %p710 = (14, -568);
//   %wire_2309 = &"net164" @WIRE(mode="straight") {%p709 %p710};
//   %wire_2310 = &"net164" @WIRE(mode="straight") {%p709 #"I1525":2};
//   %p711 = (400, -568);
//   %wire_2311 = &"net164" @WIRE(mode="straight") {%p711 #"I1102":2};
//   %wire_2312 = &"net164" @WIRE(mode="straight") {%p711 #"I1103":5};
//   %p712 = (376, -568);
//   %wire_2313 = &"net164" @WIRE(mode="straight") {%p712 %p711};
//   %wire_2314 = &"net164" @WIRE(mode="straight") {%p712 #"I1104":5};
//   %p713 = (352, -568);
//   %wire_2315 = &"net164" @WIRE(mode="straight") {%p713 %p712};
//   %wire_2316 = &"net164" @WIRE(mode="straight") {%p713 #"I1105":5};
//   %p714 = (328, -568);
//   %wire_2317 = &"net164" @WIRE(mode="straight") {%p714 %p713};
//   %wire_2318 = &"net164" @WIRE(mode="straight") {%p714 #"I1106":5};
//   %p715 = (304, -568);
//   %wire_2319 = &"net164" @WIRE(mode="straight") {%p715 %p714};
//   %p716 = (124, -568);
//   %wire_2320 = &"net164" @WIRE(mode="straight") {%p716 #"I1094":5};
//   %p717 = (86, -568);
//   %wire_2321 = &"net164" @WIRE(mode="straight") {%p717 #"I1082":5};
//   %p718 = (38, -568);
//   %wire_2322 = &"net164" @WIRE(mode="straight") {%p710 %p718};
//   %p719 = (62, -568);
//   %wire_2323 = &"net164" @WIRE(mode="straight") {%p718 %p719};
//   %wire_2324 = &"net164" @WIRE(mode="straight") {%p719 #"I1081":5};
//   %p720 = (148, -568);
//   %wire_2325 = &"net164" @WIRE(mode="straight") {%p716 %p720};
//   %p721 = (232, -568);
//   %wire_2326 = &"net164" @WIRE(mode="straight") {%p721 #"I1090":5};
//   %p722 = (256, -568);
//   %p723 = (280, -568);
//   %wire_2327 = &"net164" @WIRE(mode="straight") {%p722 %p723};
//   %wire_2328 = &"net164" @WIRE(mode="straight") {%p723 %p715};
//   %p724 = (196, -568);
//   %wire_2329 = &"net164" @WIRE(mode="straight") {%p724 %p721};
//   %wire_2330 = &"net164" @WIRE(mode="straight") {%p721 %p722};
//   %wire_2331 = &"net164" @WIRE(mode="straight") {%p722 #"I1089":5};
//   %wire_2332 = &"net164" @WIRE(mode="straight") {%p723 #"I1108":5};
//   %wire_2333 = &"net164" @WIRE(mode="straight") {%p720 #"I1093":5};
//   %p725 = (172, -568);
//   %wire_2334 = &"net164" @WIRE(mode="straight") {%p725 %p724};
//   %wire_2335 = &"net164" @WIRE(mode="straight") {%p720 %p725};
//   %wire_2336 = &"net164" @WIRE(mode="straight") {%p725 #"I1092":5};
//   %wire_2337 = &"net164" @WIRE(mode="straight") {%p724 #"I1091":5};
//   %wire_2338 = &"net164" @WIRE(mode="straight") {%p718 #"I1080":5};
//   %wire_2339 = &"net164" @WIRE(mode="straight") {%p715 #"I1107":5};
//   %wire_2340 = &"net164" @WIRE(mode="straight") {%p710 #"I1079":5};
//   %wire_2341 = &"net164" @WIRE(mode="straight") {%p717 %p716};
//   %wire_2342 = &"net164" @WIRE(mode="straight") {%p719 %p717};
//   %p726 = (326, -544);
//   %wire_2343 = &"net167" @WIRE(mode="straight") {#"I1106":6 %p726};
//   %p727 = (324, -544);
//   %wire_2344 = &"net167" @WIRE(mode="straight") {%p727 %p726};
//   %wire_2345 = &"net167" @WIRE(mode="straight") {#"I1106":3 %p727};
//   %p728 = (304, -544);
//   %wire_2346 = &"net167" @WIRE(mode="straight") {%p728 %p727};
//   %wire_2347 = &"net167" @WIRE(mode="straight") {#"I1107":7 %p728};
//   %p729 = (394, -540);
//   %wire_2348 = &"net168" @WIRE(mode="straight") {#"I1103":9 %p729};
//   %p730 = (370, -540);
//   %wire_2349 = &"net168" @WIRE(mode="straight") {%p730 %p729};
//   %wire_2350 = &"net168" @WIRE(mode="straight") {#"I1104":9 %p730};
//   %p731 = (346, -540);
//   %wire_2351 = &"net168" @WIRE(mode="straight") {%p731 %p730};
//   %wire_2352 = &"net168" @WIRE(mode="straight") {#"I1105":9 %p731};
//   %p732 = (322, -540);
//   %wire_2353 = &"net168" @WIRE(mode="straight") {%p732 %p731};
//   %wire_2354 = &"net168" @WIRE(mode="straight") {#"I1106":9 %p732};
//   %p733 = (118, -540);
//   %wire_2355 = &"net168" @WIRE(mode="straight") {#"I1094":9 %p733};
//   %p734 = (32, -540);
//   %p735 = (56, -540);
//   %wire_2356 = &"net168" @WIRE(mode="straight") {%p734 %p735};
//   %p736 = (80, -540);
//   %wire_2357 = &"net168" @WIRE(mode="straight") {%p735 %p736};
//   %wire_2358 = &"net168" @WIRE(mode="straight") {#"I1082":9 %p736};
//   %wire_2359 = &"net168" @WIRE(mode="straight") {#"I1080":9 %p734};
//   %p737 = (8, -540);
//   %wire_2360 = &"net168" @WIRE(mode="straight") {#"I1079":9 %p737};
//   %p738 = (10, -540);
//   %wire_2361 = &"net168" @WIRE(mode="straight") {%p737 %p738};
//   %p739 = (274, -540);
//   %p740 = (298, -540);
//   %wire_2362 = &"net168" @WIRE(mode="straight") {%p739 %p740};
//   %p741 = (142, -540);
//   %wire_2363 = &"net168" @WIRE(mode="straight") {%p733 %p741};
//   %wire_2364 = &"net168" @WIRE(mode="straight") {%p738 %p734};
//   %p742 = (190, -540);
//   %p743 = (226, -540);
//   %wire_2365 = &"net168" @WIRE(mode="straight") {%p742 %p743};
//   %wire_2366 = &"net168" @WIRE(mode="straight") {#"I1108":9 %p739};
//   %p744 = (166, -540);
//   %wire_2367 = &"net168" @WIRE(mode="straight") {%p744 %p742};
//   %p745 = (250, -540);
//   %wire_2368 = &"net168" @WIRE(mode="straight") {#"I1089":9 %p745};
//   %wire_2369 = &"net168" @WIRE(mode="straight") {%p745 %p739};
//   %wire_2370 = &"net168" @WIRE(mode="straight") {%p740 %p732};
//   %wire_2371 = &"net168" @WIRE(mode="straight") {#"I1093":9 %p741};
//   %wire_2372 = &"net168" @WIRE(mode="straight") {#"I1092":9 %p744};
//   %wire_2373 = &"net168" @WIRE(mode="straight") {#"I1091":9 %p742};
//   %wire_2374 = &"net168" @WIRE(mode="straight") {%p743 %p745};
//   %wire_2375 = &"net168" @WIRE(mode="straight") {#"I1090":9 %p743};
//   %wire_2376 = &"net168" @WIRE(mode="straight") {%p741 %p744};
//   %wire_2377 = &"net168" @WIRE(mode="straight") {#"I1107":9 %p740};
//   %wire_2378 = &"net168" @WIRE(mode="straight") {%p736 %p733};
//   %wire_2379 = &"net168" @WIRE(mode="straight") {#"I1081":9 %p735};
//   %wire_2380 = &"net168" @WIRE(mode="straight") {#"I1079":3 %p738};
//   %p746 = (82, -159);
//   %p747 = (62, -157);
//   %wire_2381 = &"net112" @WIRE(mode="straight") {%p746 %p747};
//   %wire_2382 = &"net112" @WIRE(mode="straight") {#"I1278":3 %p746};
//   %wire_2383 = &"net112" @WIRE(mode="straight") {#"I1279":7 %p747};
//   %p748 = (36, -159);
//   %wire_2384 = &"net112" @WIRE(mode="straight") {%p748 %p747};
//   %wire_2385 = &"net112" @WIRE(mode="straight") {#"I1280":6 %p748};
//   %p749 = (80, -155);
//   %wire_2386 = &"net115" @WIRE(mode="straight") {#"I1278":9 %p749};
//   %p750 = (56, -155);
//   %wire_2387 = &"net115" @WIRE(mode="straight") {%p750 %p749};
//   %wire_2388 = &"net115" @WIRE(mode="straight") {#"I1279":9 %p750};
//   %p751 = (32, -155);
//   %wire_2389 = &"net115" @WIRE(mode="straight") {%p751 %p750};
//   %wire_2390 = &"net115" @WIRE(mode="straight") {#"I1280":9 %p751};
//   %p752 = (10, -155);
//   %wire_2391 = &"net115" @WIRE(mode="straight") {%p752 %p751};
//   %p753 = (8, -155);
//   %wire_2392 = &"net115" @WIRE(mode="straight") {%p753 %p752};
//   %wire_2393 = &"net115" @WIRE(mode="straight") {#"I1281":9 %p753};
//   %wire_2394 = &"net115" @WIRE(mode="straight") {#"I1281":3 %p752};
//   %p754 = (118, -155);
//   %wire_2395 = &"net115" @WIRE(mode="straight") {%p749 %p754};
//   %p755 = (394, -155);
//   %wire_2396 = &"net115" @WIRE(mode="straight") {#"I1294":9 %p755};
//   %wire_2397 = &"net115" @WIRE(mode="straight") {#"I1283":9 %p754};
//   %p756 = (370, -155);
//   %wire_2398 = &"net115" @WIRE(mode="straight") {%p756 %p755};
//   %wire_2399 = &"net115" @WIRE(mode="straight") {#"I1293":9 %p756};
//   %p757 = (346, -155);
//   %wire_2400 = &"net115" @WIRE(mode="straight") {%p757 %p756};
//   %wire_2401 = &"net115" @WIRE(mode="straight") {#"I1292":9 %p757};
//   %p758 = (322, -155);
//   %wire_2402 = &"net115" @WIRE(mode="straight") {%p758 %p757};
//   %wire_2403 = &"net115" @WIRE(mode="straight") {#"I1291":9 %p758};
//   %p759 = (298, -155);
//   %wire_2404 = &"net115" @WIRE(mode="straight") {%p759 %p758};
//   %wire_2405 = &"net115" @WIRE(mode="straight") {#"I1290":9 %p759};
//   %p760 = (274, -155);
//   %wire_2406 = &"net115" @WIRE(mode="straight") {%p760 %p759};
//   %wire_2407 = &"net115" @WIRE(mode="straight") {#"I1289":9 %p760};
//   %p761 = (250, -155);
//   %wire_2408 = &"net115" @WIRE(mode="straight") {%p761 %p760};
//   %wire_2409 = &"net115" @WIRE(mode="straight") {#"I1282":9 %p761};
//   %p762 = (226, -155);
//   %wire_2410 = &"net115" @WIRE(mode="straight") {%p762 %p761};
//   %p763 = (190, -155);
//   %wire_2411 = &"net115" @WIRE(mode="straight") {%p763 %p762};
//   %wire_2412 = &"net115" @WIRE(mode="straight") {#"I1287":9 %p762};
//   %p764 = (166, -155);
//   %wire_2413 = &"net115" @WIRE(mode="straight") {%p764 %p763};
//   %p765 = (142, -155);
//   %wire_2414 = &"net115" @WIRE(mode="straight") {%p754 %p765};
//   %wire_2415 = &"net115" @WIRE(mode="straight") {#"I1286":9 %p763};
//   %wire_2416 = &"net115" @WIRE(mode="straight") {#"I1285":9 %p764};
//   %wire_2417 = &"net115" @WIRE(mode="straight") {%p765 %p764};
//   %wire_2418 = &"net115" @WIRE(mode="straight") {#"I1284":9 %p765};
//   %p766 = (205, -416);
//   %p767 = (205, -413);
//   %wire_2419 = &"net172" @WIRE(mode="straight") {%p766 %p767};
//   %wire_2420 = &"net172" @WIRE(mode="straight") {#"M54":3 %p766};
//   %wire_2421 = &"net172" @WIRE(mode="straight") {%p767 #"M161":3};
//   %wire_2422 = &"net172" @WIRE(mode="straight") {#"I1013":4 #"I1012":4};
//   %wire_2423 = &"net172" @WIRE(mode="straight") {#"I1014":4 #"I1013":4};
//   %wire_2424 = &"net172" @WIRE(mode="straight") {#"I1011":4 %p766};
//   %p768 = (107, -419);
//   %wire_2425 = &"net172" @WIRE(mode="straight") {#"M34":1 %p768};
//   %wire_2426 = &"net172" @WIRE(mode="straight") {#"I1012":4 #"I1011":4};
//   %p769 = (107, -416);
//   %wire_2427 = &"net172" @WIRE(mode="straight") {%p768 %p769};
//   %wire_2428 = &"net172" @WIRE(mode="straight") {%p769 #"I1014":4};
//   %wire_2429 = &"net172" @WIRE(mode="straight") {%p769 #"M141":1};
//   %p770 = (-6, -416);
//   %wire_2430 = &"net173" @WIRE(mode="straight") {#"I1504":1 %p770};
//   %wire_2431 = &"net173" @WIRE(mode="straight") {%p770 #"M78":1};
//   %p771 = (97, -416);
//   %wire_2432 = &"net173" @WIRE(mode="straight") {#"I1002":4 %p771};
//   %p772 = (97, -413);
//   %wire_2433 = &"net173" @WIRE(mode="straight") {%p772 #"M141":3};
//   %wire_2434 = &"net173" @WIRE(mode="straight") {#"I1001":4 #"I1002":4};
//   %wire_2435 = &"net173" @WIRE(mode="straight") {#"I999":4 #"I1000":4};
//   %wire_2436 = &"net173" @WIRE(mode="straight") {%p770 #"I999":4};
//   %wire_2437 = &"net173" @WIRE(mode="straight") {%p771 %p772};
//   %wire_2438 = &"net173" @WIRE(mode="straight") {#"I1000":4 #"I1001":4};
//   %p773 = (-26, -418);
//   %wire_2439 = &"net173" @WIRE(mode="straight") {%p773 #"I1504":1};
//   %wire_2440 = &"net173" @WIRE(mode="straight") {#"M34":3 %p771};
//   %wire_2441 = &"net173" @WIRE(mode="straight") {#"I1508":2 %p773};
//   %p774 = (252, -404);
//   %p775 = (254, -404);
//   %wire_2442 = &"net175" @WIRE(mode="straight") {%p774 %p775};
//   %p776 = (232, -404);
//   %wire_2443 = &"net175" @WIRE(mode="straight") {#"I1010":7 %p776};
//   %wire_2444 = &"net175" @WIRE(mode="straight") {#"I1009":6 %p775};
//   %wire_2445 = &"net175" @WIRE(mode="straight") {%p776 %p774};
//   %wire_2446 = &"net175" @WIRE(mode="straight") {#"I1009":3 %p774};
//   %p777 = (215, -416);
//   %wire_2447 = &"net177" @WIRE(mode="straight") {%p777 #"I1010":4};
//   %wire_2448 = &"net177" @WIRE(mode="straight") {%p777 #"M161":1};
//   %p778 = (215, -419);
//   %wire_2449 = &"net177" @WIRE(mode="straight") {%p778 %p777};
//   %wire_2450 = &"net177" @WIRE(mode="straight") {#"M54":1 %p778};
//   %wire_2451 = &"net177" @WIRE(mode="straight") {#"I1024":4 #"I1023":4};
//   %wire_2452 = &"net177" @WIRE(mode="straight") {#"I1028":4 #"I1027":4};
//   %wire_2453 = &"net177" @WIRE(mode="straight") {#"I1009":4 #"I1028":4};
//   %wire_2454 = &"net177" @WIRE(mode="straight") {#"I1026":4 #"I1025":4};
//   %wire_2455 = &"net177" @WIRE(mode="straight") {#"I1010":4 #"I1009":4};
//   %wire_2456 = &"net177" @WIRE(mode="straight") {#"I1027":4 #"I1026":4};
//   %wire_2457 = &"net177" @WIRE(mode="straight") {#"I1025":4 #"I1024":4};
//   %p779 = (280, -428);
//   %wire_2458 = &"net178" @WIRE(mode="straight") {%p779 #"I1028":5};
//   %p780 = (196, -428);
//   %wire_2459 = &"net178" @WIRE(mode="straight") {%p780 #"I1011":5};
//   %p781 = (148, -428);
//   %wire_2460 = &"net178" @WIRE(mode="straight") {%p781 #"I1013":5};
//   %p782 = (38, -428);
//   %wire_2461 = &"net178" @WIRE(mode="straight") {%p782 #"I1000":5};
//   %p783 = (62, -428);
//   %p784 = (86, -428);
//   %wire_2462 = &"net178" @WIRE(mode="straight") {%p783 %p784};
//   %p785 = (400, -428);
//   %wire_2463 = &"net178" @WIRE(mode="straight") {%p785 #"I1022":2};
//   %p786 = (352, -428);
//   %p787 = (376, -428);
//   %wire_2464 = &"net178" @WIRE(mode="straight") {%p786 %p787};
//   %p788 = (304, -428);
//   %wire_2465 = &"net178" @WIRE(mode="straight") {%p788 #"I1027":5};
//   %wire_2466 = &"net178" @WIRE(mode="straight") {%p785 #"I1023":5};
//   %p789 = (232, -428);
//   %wire_2467 = &"net178" @WIRE(mode="straight") {%p789 #"I1010":5};
//   %wire_2468 = &"net178" @WIRE(mode="straight") {%p780 %p789};
//   %wire_2469 = &"net178" @WIRE(mode="straight") {%p787 #"I1024":5};
//   %p790 = (328, -428);
//   %wire_2470 = &"net178" @WIRE(mode="straight") {%p788 %p790};
//   %p791 = (256, -428);
//   %wire_2471 = &"net178" @WIRE(mode="straight") {%p789 %p791};
//   %p792 = (-20, -428);
//   %p793 = (14, -428);
//   %wire_2472 = &"net178" @WIRE(mode="straight") {%p792 %p793};
//   %p794 = (124, -428);
//   %wire_2473 = &"net178" @WIRE(mode="straight") {%p784 %p794};
//   %wire_2474 = &"net178" @WIRE(mode="straight") {%p782 %p783};
//   %wire_2475 = &"net178" @WIRE(mode="straight") {%p793 %p782};
//   %wire_2476 = &"net178" @WIRE(mode="straight") {%p786 #"I1025":5};
//   %wire_2477 = &"net178" @WIRE(mode="straight") {%p794 %p781};
//   %wire_2478 = &"net178" @WIRE(mode="straight") {%p790 #"I1026":5};
//   %wire_2479 = &"net178" @WIRE(mode="straight") {%p792 #"I1509":2};
//   %p795 = (172, -428);
//   %wire_2480 = &"net178" @WIRE(mode="straight") {%p795 #"I1012":5};
//   %wire_2481 = &"net178" @WIRE(mode="straight") {%p779 %p788};
//   %wire_2482 = &"net178" @WIRE(mode="straight") {%p791 %p779};
//   %wire_2483 = &"net178" @WIRE(mode="straight") {%p791 #"I1009":5};
//   %wire_2484 = &"net178" @WIRE(mode="straight") {%p787 %p785};
//   %wire_2485 = &"net178" @WIRE(mode="straight") {%p790 %p786};
//   %wire_2486 = &"net178" @WIRE(mode="straight") {%p781 %p795};
//   %wire_2487 = &"net178" @WIRE(mode="straight") {%p795 %p780};
//   %wire_2488 = &"net178" @WIRE(mode="straight") {%p794 #"I1014":5};
//   %wire_2489 = &"net178" @WIRE(mode="straight") {%p784 #"I1002":5};
//   %wire_2490 = &"net178" @WIRE(mode="straight") {%p783 #"I1001":5};
//   %wire_2491 = &"net178" @WIRE(mode="straight") {%p793 #"I999":5};
//   %p796 = (278, -404);
//   %wire_2492 = &"net179" @WIRE(mode="straight") {#"I1028":6 %p796};
//   %p797 = (276, -404);
//   %wire_2493 = &"net179" @WIRE(mode="straight") {%p797 %p796};
//   %wire_2494 = &"net179" @WIRE(mode="straight") {#"I1028":3 %p797};
//   %p798 = (256, -404);
//   %wire_2495 = &"net179" @WIRE(mode="straight") {%p798 %p797};
//   %wire_2496 = &"net179" @WIRE(mode="straight") {#"I1009":7 %p798};
//   %p799 = (394, -400);
//   %wire_2497 = &"net180" @WIRE(mode="straight") {#"I1023":9 %p799};
//   %p800 = (370, -400);
//   %wire_2498 = &"net180" @WIRE(mode="straight") {#"I1024":9 %p800};
//   %p801 = (80, -400);
//   %p802 = (118, -400);
//   %wire_2499 = &"net180" @WIRE(mode="straight") {%p801 %p802};
//   %p803 = (32, -400);
//   %p804 = (56, -400);
//   %wire_2500 = &"net180" @WIRE(mode="straight") {%p803 %p804};
//   %wire_2501 = &"net180" @WIRE(mode="straight") {#"I1000":9 %p803};
//   %p805 = (142, -400);
//   %wire_2502 = &"net180" @WIRE(mode="straight") {#"I1013":9 %p805};
//   %p806 = (8, -400);
//   %p807 = (10, -400);
//   %wire_2503 = &"net180" @WIRE(mode="straight") {%p806 %p807};
//   %wire_2504 = &"net180" @WIRE(mode="straight") {%p802 %p805};
//   %wire_2505 = &"net180" @WIRE(mode="straight") {%p804 %p801};
//   %p808 = (250, -400);
//   %p809 = (274, -400);
//   %wire_2506 = &"net180" @WIRE(mode="straight") {%p808 %p809};
//   %p810 = (322, -400);
//   %wire_2507 = &"net180" @WIRE(mode="straight") {#"I1026":9 %p810};
//   %p811 = (346, -400);
//   %wire_2508 = &"net180" @WIRE(mode="straight") {%p811 %p800};
//   %p812 = (190, -400);
//   %p813 = (226, -400);
//   %wire_2509 = &"net180" @WIRE(mode="straight") {%p812 %p813};
//   %wire_2510 = &"net180" @WIRE(mode="straight") {#"I1002":9 %p801};
//   %wire_2511 = &"net180" @WIRE(mode="straight") {#"I999":3 %p807};
//   %p814 = (166, -400);
//   %wire_2512 = &"net180" @WIRE(mode="straight") {%p814 %p812};
//   %wire_2513 = &"net180" @WIRE(mode="straight") {%p805 %p814};
//   %wire_2514 = &"net180" @WIRE(mode="straight") {#"I1011":9 %p812};
//   %wire_2515 = &"net180" @WIRE(mode="straight") {#"I1012":9 %p814};
//   %wire_2516 = &"net180" @WIRE(mode="straight") {#"I1028":9 %p809};
//   %wire_2517 = &"net180" @WIRE(mode="straight") {%p800 %p799};
//   %wire_2518 = &"net180" @WIRE(mode="straight") {#"I1001":9 %p804};
//   %wire_2519 = &"net180" @WIRE(mode="straight") {#"I1014":9 %p802};
//   %wire_2520 = &"net180" @WIRE(mode="straight") {%p807 %p803};
//   %p815 = (298, -400);
//   %wire_2521 = &"net180" @WIRE(mode="straight") {%p815 %p810};
//   %wire_2522 = &"net180" @WIRE(mode="straight") {#"I1027":9 %p815};
//   %wire_2523 = &"net180" @WIRE(mode="straight") {%p809 %p815};
//   %wire_2524 = &"net180" @WIRE(mode="straight") {#"I999":9 %p806};
//   %wire_2525 = &"net180" @WIRE(mode="straight") {#"I1009":9 %p808};
//   %wire_2526 = &"net180" @WIRE(mode="straight") {%p813 %p808};
//   %wire_2527 = &"net180" @WIRE(mode="straight") {#"I1010":9 %p813};
//   %wire_2528 = &"net180" @WIRE(mode="straight") {#"I1025":9 %p811};
//   %wire_2529 = &"net180" @WIRE(mode="straight") {%p810 %p811};
//   %p816 = (348, -89);
//   %p817 = (328, -87);
//   %wire_2530 = &"net117" @WIRE(mode="straight") {%p816 %p817};
//   %wire_2531 = &"net117" @WIRE(mode="straight") {#"I1274":7 %p817};
//   %p818 = (302, -89);
//   %wire_2532 = &"net117" @WIRE(mode="straight") {%p818 %p817};
//   %wire_2533 = &"net117" @WIRE(mode="straight") {#"I1273":6 %p818};
//   %wire_2534 = &"net117" @WIRE(mode="straight") {#"I1275":3 %p816};
//   %p819 = (372, -89);
//   %wire_2535 = &"net125" @WIRE(mode="straight") {#"I1276":3 %p819};
//   %p820 = (352, -87);
//   %wire_2536 = &"net125" @WIRE(mode="straight") {%p819 %p820};
//   %p821 = (326, -89);
//   %wire_2537 = &"net125" @WIRE(mode="straight") {%p821 %p820};
//   %wire_2538 = &"net125" @WIRE(mode="straight") {#"I1275":7 %p820};
//   %wire_2539 = &"net125" @WIRE(mode="straight") {#"I1274":6 %p821};
//   %p822 = (376, -87);
//   %wire_2540 = &"net127" @WIRE(mode="straight") {#"I1276":7 %p822};
//   %p823 = (396, -89);
//   %wire_2541 = &"net127" @WIRE(mode="straight") {#"I1277":3 %p823};
//   %wire_2542 = &"net127" @WIRE(mode="straight") {%p823 %p822};
//   %p824 = (350, -89);
//   %wire_2543 = &"net127" @WIRE(mode="straight") {%p824 %p822};
//   %wire_2544 = &"net127" @WIRE(mode="straight") {#"I1275":6 %p824};
//   %p825 = (-4, -437);
//   %p826 = (14, -437);
//   %wire_2545 = &"net184" @WIRE(mode="straight") {%p825 %p826};
//   %wire_2546 = &"net184" @WIRE(mode="straight") {#"I1502":1 %p825};
//   %p827 = (34, -439);
//   %wire_2547 = &"net184" @WIRE(mode="straight") {#"I1348":3 %p827};
//   %wire_2548 = &"net184" @WIRE(mode="straight") {%p827 %p826};
//   %wire_2549 = &"net184" @WIRE(mode="straight") {#"I1349":7 %p826};
//   %p828 = (34, -404);
//   %wire_2550 = &"net185" @WIRE(mode="straight") {#"I1000":3 %p828};
//   %p829 = (14, -404);
//   %wire_2551 = &"net185" @WIRE(mode="straight") {%p829 %p828};
//   %p830 = (36, -404);
//   %wire_2552 = &"net185" @WIRE(mode="straight") {#"I1000":6 %p830};
//   %wire_2553 = &"net185" @WIRE(mode="straight") {%p828 %p830};
//   %wire_2554 = &"net185" @WIRE(mode="straight") {#"I999":7 %p829};
//   %p831 = (400, -87);
//   %wire_2555 = &"net128" @WIRE(mode="straight") {#"I1277":7 %p831};
//   %p832 = (374, -89);
//   %wire_2556 = &"net128" @WIRE(mode="straight") {%p832 %p831};
//   %wire_2557 = &"net128" @WIRE(mode="straight") {#"I1276":6 %p832};
//   %p833 = (-18, -451);
//   %wire_2558 = &"net187" @WIRE(mode="straight") {%p833 #"I1349":4};
//   %p834 = (97, -451);
//   %wire_2559 = &"net187" @WIRE(mode="straight") {#"I1346":4 %p834};
//   %wire_2560 = &"net187" @WIRE(mode="straight") {#"I1349":4 #"I1348":4};
//   %wire_2561 = &"net187" @WIRE(mode="straight") {%p833 #"M77":1};
//   %p835 = (97, -448);
//   %wire_2562 = &"net187" @WIRE(mode="straight") {%p834 %p835};
//   %p836 = (-26, -453);
//   %wire_2563 = &"net187" @WIRE(mode="straight") {%p836 #"I1503":1};
//   %wire_2564 = &"net187" @WIRE(mode="straight") {#"M35":3 %p834};
//   %wire_2565 = &"net187" @WIRE(mode="straight") {#"I1347":4 #"I1346":4};
//   %wire_2566 = &"net187" @WIRE(mode="straight") {#"I1348":4 #"I1347":4};
//   %wire_2567 = &"net187" @WIRE(mode="straight") {%p835 #"M142":3};
//   %wire_2568 = &"net187" @WIRE(mode="straight") {#"I1506":2 %p836};
//   %wire_2569 = &"net187" @WIRE(mode="straight") {#"I1503":1 %p833};
//   %p837 = (398, -120);
//   %p838 = (400, -120);
//   %wire_2570 = &"net129" @WIRE(mode="straight") {%p837 %p838};
//   %wire_2571 = &"net129" @WIRE(mode="straight") {#"I863":7 %p838};
//   %wire_2572 = &"net129" @WIRE(mode="straight") {%p837 #"I1277":6};
//   %p839 = (300, -334);
//   %p840 = (302, -334);
//   %wire_2573 = &"net189" @WIRE(mode="straight") {%p839 %p840};
//   %wire_2574 = &"net189" @WIRE(mode="straight") {#"I987":6 %p840};
//   %wire_2575 = &"net189" @WIRE(mode="straight") {#"I987":3 %p839};
//   %p841 = (280, -334);
//   %wire_2576 = &"net189" @WIRE(mode="straight") {%p841 %p839};
//   %wire_2577 = &"net189" @WIRE(mode="straight") {#"I988":7 %p841};
//   %p842 = (215, -346);
//   %wire_2578 = &"net190" @WIRE(mode="straight") {%p842 #"I970":4};
//   %p843 = (215, -349);
//   %wire_2579 = &"net190" @WIRE(mode="straight") {%p843 %p842};
//   %wire_2580 = &"net190" @WIRE(mode="straight") {%p842 #"M163":1};
//   %wire_2581 = &"net190" @WIRE(mode="straight") {#"M56":1 %p843};
//   %wire_2582 = &"net190" @WIRE(mode="straight") {#"I987":4 #"I986":4};
//   %wire_2583 = &"net190" @WIRE(mode="straight") {#"I988":4 #"I987":4};
//   %wire_2584 = &"net190" @WIRE(mode="straight") {#"I985":4 #"I984":4};
//   %wire_2585 = &"net190" @WIRE(mode="straight") {#"I969":4 #"I988":4};
//   %wire_2586 = &"net190" @WIRE(mode="straight") {#"I986":4 #"I985":4};
//   %wire_2587 = &"net190" @WIRE(mode="straight") {#"I970":4 #"I969":4};
//   %wire_2588 = &"net190" @WIRE(mode="straight") {#"I984":4 #"I983":4};
//   %p844 = (352, -358);
//   %wire_2589 = &"net191" @WIRE(mode="straight") {%p844 #"I985":5};
//   %p845 = (14, -358);
//   %p846 = (38, -358);
//   %wire_2590 = &"net191" @WIRE(mode="straight") {%p845 %p846};
//   %p847 = (86, -358);
//   %p848 = (124, -358);
//   %wire_2591 = &"net191" @WIRE(mode="straight") {%p847 %p848};
//   %wire_2592 = &"net191" @WIRE(mode="straight") {%p848 #"I974":5};
//   %p849 = (256, -358);
//   %wire_2593 = &"net191" @WIRE(mode="straight") {%p849 #"I969":5};
//   %p850 = (304, -358);
//   %p851 = (328, -358);
//   %wire_2594 = &"net191" @WIRE(mode="straight") {%p850 %p851};
//   %p852 = (62, -358);
//   %wire_2595 = &"net191" @WIRE(mode="straight") {%p852 #"I961":5};
//   %p853 = (232, -358);
//   %wire_2596 = &"net191" @WIRE(mode="straight") {%p853 %p849};
//   %p854 = (400, -358);
//   %wire_2597 = &"net191" @WIRE(mode="straight") {%p854 #"I982":2};
//   %wire_2598 = &"net191" @WIRE(mode="straight") {%p851 #"I986":5};
//   %p855 = (-20, -358);
//   %wire_2599 = &"net191" @WIRE(mode="straight") {%p855 %p845};
//   %p856 = (376, -358);
//   %wire_2600 = &"net191" @WIRE(mode="straight") {%p844 %p856};
//   %wire_2601 = &"net191" @WIRE(mode="straight") {%p853 #"I970":5};
//   %wire_2602 = &"net191" @WIRE(mode="straight") {%p846 #"I960":5};
//   %p857 = (280, -358);
//   %wire_2603 = &"net191" @WIRE(mode="straight") {%p857 %p850};
//   %wire_2604 = &"net191" @WIRE(mode="straight") {%p852 %p847};
//   %wire_2605 = &"net191" @WIRE(mode="straight") {%p846 %p852};
//   %wire_2606 = &"net191" @WIRE(mode="straight") {%p849 %p857};
//   %wire_2607 = &"net191" @WIRE(mode="straight") {%p845 #"I959":5};
//   %wire_2608 = &"net191" @WIRE(mode="straight") {%p850 #"I987":5};
//   %wire_2609 = &"net191" @WIRE(mode="straight") {%p857 #"I988":5};
//   %wire_2610 = &"net191" @WIRE(mode="straight") {%p854 #"I983":5};
//   %wire_2611 = &"net191" @WIRE(mode="straight") {%p856 #"I984":5};
//   %p858 = (148, -358);
//   %wire_2612 = &"net191" @WIRE(mode="straight") {%p848 %p858};
//   %p859 = (172, -358);
//   %wire_2613 = &"net191" @WIRE(mode="straight") {%p859 #"I972":5};
//   %p860 = (196, -358);
//   %wire_2614 = &"net191" @WIRE(mode="straight") {%p860 %p853};
//   %wire_2615 = &"net191" @WIRE(mode="straight") {%p859 %p860};
//   %wire_2616 = &"net191" @WIRE(mode="straight") {%p858 %p859};
//   %wire_2617 = &"net191" @WIRE(mode="straight") {%p858 #"I973":5};
//   %wire_2618 = &"net191" @WIRE(mode="straight") {%p847 #"I962":5};
//   %wire_2619 = &"net191" @WIRE(mode="straight") {%p856 %p854};
//   %wire_2620 = &"net191" @WIRE(mode="straight") {%p855 #"I1501":2};
//   %wire_2621 = &"net191" @WIRE(mode="straight") {%p860 #"I971":5};
//   %wire_2622 = &"net191" @WIRE(mode="straight") {%p851 %p844};
//   %p861 = (304, -334);
//   %p862 = (324, -334);
//   %wire_2623 = &"net192" @WIRE(mode="straight") {%p861 %p862};
//   %p863 = (326, -334);
//   %wire_2624 = &"net192" @WIRE(mode="straight") {%p862 %p863};
//   %wire_2625 = &"net192" @WIRE(mode="straight") {#"I987":7 %p861};
//   %wire_2626 = &"net192" @WIRE(mode="straight") {#"I986":6 %p863};
//   %wire_2627 = &"net192" @WIRE(mode="straight") {#"I986":3 %p862};
//   %p864 = (226, -330);
//   %wire_2628 = &"net193" @WIRE(mode="straight") {#"I970":9 %p864};
//   %p865 = (274, -330);
//   %p866 = (298, -330);
//   %wire_2629 = &"net193" @WIRE(mode="straight") {%p865 %p866};
//   %p867 = (250, -330);
//   %wire_2630 = &"net193" @WIRE(mode="straight") {#"I969":9 %p867};
//   %p868 = (322, -330);
//   %wire_2631 = &"net193" @WIRE(mode="straight") {%p866 %p868};
//   %wire_2632 = &"net193" @WIRE(mode="straight") {#"I987":9 %p866};
//   %p869 = (32, -330);
//   %p870 = (56, -330);
//   %wire_2633 = &"net193" @WIRE(mode="straight") {%p869 %p870};
//   %p871 = (10, -330);
//   %wire_2634 = &"net193" @WIRE(mode="straight") {%p871 %p869};
//   %p872 = (346, -330);
//   %wire_2635 = &"net193" @WIRE(mode="straight") {#"I985":9 %p872};
//   %wire_2636 = &"net193" @WIRE(mode="straight") {%p868 %p872};
//   %p873 = (142, -330);
//   %wire_2637 = &"net193" @WIRE(mode="straight") {#"I973":9 %p873};
//   %p874 = (166, -330);
//   %wire_2638 = &"net193" @WIRE(mode="straight") {%p873 %p874};
//   %p875 = (370, -330);
//   %p876 = (394, -330);
//   %wire_2639 = &"net193" @WIRE(mode="straight") {%p875 %p876};
//   %p877 = (190, -330);
//   %wire_2640 = &"net193" @WIRE(mode="straight") {%p877 %p864};
//   %p878 = (80, -330);
//   %wire_2641 = &"net193" @WIRE(mode="straight") {%p870 %p878};
//   %wire_2642 = &"net193" @WIRE(mode="straight") {#"I962":9 %p878};
//   %wire_2643 = &"net193" @WIRE(mode="straight") {#"I960":9 %p869};
//   %p879 = (8, -330);
//   %wire_2644 = &"net193" @WIRE(mode="straight") {#"I959":9 %p879};
//   %wire_2645 = &"net193" @WIRE(mode="straight") {%p879 %p871};
//   %wire_2646 = &"net193" @WIRE(mode="straight") {#"I988":9 %p865};
//   %wire_2647 = &"net193" @WIRE(mode="straight") {#"I961":9 %p870};
//   %wire_2648 = &"net193" @WIRE(mode="straight") {#"I972":9 %p874};
//   %wire_2649 = &"net193" @WIRE(mode="straight") {%p867 %p865};
//   %wire_2650 = &"net193" @WIRE(mode="straight") {%p874 %p877};
//   %wire_2651 = &"net193" @WIRE(mode="straight") {#"I983":9 %p876};
//   %wire_2652 = &"net193" @WIRE(mode="straight") {%p872 %p875};
//   %wire_2653 = &"net193" @WIRE(mode="straight") {#"I971":9 %p877};
//   %p880 = (118, -330);
//   %wire_2654 = &"net193" @WIRE(mode="straight") {#"I974":9 %p880};
//   %wire_2655 = &"net193" @WIRE(mode="straight") {%p878 %p880};
//   %wire_2656 = &"net193" @WIRE(mode="straight") {%p864 %p867};
//   %wire_2657 = &"net193" @WIRE(mode="straight") {%p880 %p873};
//   %wire_2658 = &"net193" @WIRE(mode="straight") {#"I959":3 %p871};
//   %wire_2659 = &"net193" @WIRE(mode="straight") {#"I984":9 %p875};
//   %wire_2660 = &"net193" @WIRE(mode="straight") {#"I986":9 %p868};
//   %p881 = (84, -159);
//   %wire_2661 = &"net130" @WIRE(mode="straight") {#"I1278":6 %p881};
//   %p882 = (124, -157);
//   %wire_2662 = &"net130" @WIRE(mode="straight") {%p882 %p881};
//   %wire_2663 = &"net130" @WIRE(mode="straight") {#"I1283":7 %p882};
//   %p883 = (144, -159);
//   %wire_2664 = &"net130" @WIRE(mode="straight") {%p883 %p882};
//   %wire_2665 = &"net130" @WIRE(mode="straight") {#"I1284":3 %p883};
//   %p884 = (-26, -313);
//   %wire_2666 = &"net195" @WIRE(mode="straight") {#"I1490":2 %p884};
//   %p885 = (-18, -311);
//   %wire_2667 = &"net195" @WIRE(mode="straight") {%p885 #"M73":1};
//   %p886 = (97, -311);
//   %wire_2668 = &"net195" @WIRE(mode="straight") {#"M31":3 %p886};
//   %p887 = (97, -308);
//   %wire_2669 = &"net195" @WIRE(mode="straight") {%p887 #"M138":3};
//   %wire_2670 = &"net195" @WIRE(mode="straight") {%p885 #"I1315":4};
//   %wire_2671 = &"net195" @WIRE(mode="straight") {%p884 #"I1487":1};
//   %wire_2672 = &"net195" @WIRE(mode="straight") {#"I1314":4 #"I1313":4};
//   %wire_2673 = &"net195" @WIRE(mode="straight") {#"I1315":4 #"I1314":4};
//   %wire_2674 = &"net195" @WIRE(mode="straight") {#"I1313":4 #"I1312":4};
//   %wire_2675 = &"net195" @WIRE(mode="straight") {#"I1312":4 %p886};
//   %wire_2676 = &"net195" @WIRE(mode="straight") {%p886 %p887};
//   %wire_2677 = &"net195" @WIRE(mode="straight") {#"I1487":1 %p885};
//   %p888 = (230, -579);
//   %p889 = (256, -577);
//   %wire_2678 = &"net131" @WIRE(mode="straight") {%p888 %p889};
//   %p890 = (276, -579);
//   %wire_2679 = &"net131" @WIRE(mode="straight") {#"I1391":3 %p890};
//   %wire_2680 = &"net131" @WIRE(mode="straight") {%p890 %p889};
//   %wire_2681 = &"net131" @WIRE(mode="straight") {#"I1384":7 %p889};
//   %wire_2682 = &"net131" @WIRE(mode="straight") {#"I1389":6 %p888};
//   %p891 = (215, -591);
//   %wire_2683 = &"net132" @WIRE(mode="straight") {%p891 #"I1389":4};
//   %wire_2684 = &"net132" @WIRE(mode="straight") {%p891 #"M156":1};
//   %wire_2685 = &"net132" @WIRE(mode="straight") {#"I1391":4 #"I1392":4};
//   %wire_2686 = &"net132" @WIRE(mode="straight") {#"I1384":4 #"I1391":4};
//   %wire_2687 = &"net132" @WIRE(mode="straight") {#"I1394":4 #"I1395":4};
//   %p892 = (215, -594);
//   %wire_2688 = &"net132" @WIRE(mode="straight") {%p892 %p891};
//   %wire_2689 = &"net132" @WIRE(mode="straight") {#"M48":1 %p892};
//   %wire_2690 = &"net132" @WIRE(mode="straight") {#"I1393":4 #"I1394":4};
//   %wire_2691 = &"net132" @WIRE(mode="straight") {#"I1389":4 #"I1384":4};
//   %wire_2692 = &"net132" @WIRE(mode="straight") {#"I1395":4 #"I1396":4};
//   %wire_2693 = &"net132" @WIRE(mode="straight") {#"I1392":4 #"I1393":4};
//   %p893 = (-4, -603);
//   %p894 = (14, -603);
//   %wire_2694 = &"net135" @WIRE(mode="straight") {%p893 %p894};
//   %wire_2695 = &"net135" @WIRE(mode="straight") {%p893 #"I1518":2};
//   %p895 = (232, -603);
//   %wire_2696 = &"net135" @WIRE(mode="straight") {%p895 #"I1389":5};
//   %p896 = (376, -603);
//   %p897 = (400, -603);
//   %wire_2697 = &"net135" @WIRE(mode="straight") {%p896 %p897};
//   %p898 = (352, -603);
//   %wire_2698 = &"net135" @WIRE(mode="straight") {%p898 %p896};
//   %p899 = (124, -603);
//   %p900 = (148, -603);
//   %wire_2699 = &"net135" @WIRE(mode="straight") {%p899 %p900};
//   %p901 = (304, -603);
//   %p902 = (328, -603);
//   %wire_2700 = &"net135" @WIRE(mode="straight") {%p901 %p902};
//   %p903 = (256, -603);
//   %wire_2701 = &"net135" @WIRE(mode="straight") {%p895 %p903};
//   %p904 = (280, -603);
//   %wire_2702 = &"net135" @WIRE(mode="straight") {%p903 %p904};
//   %p905 = (62, -603);
//   %wire_2703 = &"net135" @WIRE(mode="straight") {%p905 #"I1381":5};
//   %wire_2704 = &"net135" @WIRE(mode="straight") {%p900 #"I1386":5};
//   %wire_2705 = &"net135" @WIRE(mode="straight") {%p896 #"I1395":5};
//   %wire_2706 = &"net135" @WIRE(mode="straight") {%p902 %p898};
//   %p906 = (172, -603);
//   %wire_2707 = &"net135" @WIRE(mode="straight") {%p906 #"I1387":5};
//   %p907 = (38, -603);
//   %wire_2708 = &"net135" @WIRE(mode="straight") {%p907 #"I1382":5};
//   %p908 = (86, -603);
//   %wire_2709 = &"net135" @WIRE(mode="straight") {%p908 %p899};
//   %wire_2710 = &"net135" @WIRE(mode="straight") {%p897 #"I1390":2};
//   %p909 = (196, -603);
//   %wire_2711 = &"net135" @WIRE(mode="straight") {%p909 #"I1388":5};
//   %wire_2712 = &"net135" @WIRE(mode="straight") {%p901 #"I1392":5};
//   %wire_2713 = &"net135" @WIRE(mode="straight") {%p900 %p906};
//   %wire_2714 = &"net135" @WIRE(mode="straight") {%p897 #"I1396":5};
//   %wire_2715 = &"net135" @WIRE(mode="straight") {%p903 #"I1384":5};
//   %wire_2716 = &"net135" @WIRE(mode="straight") {%p906 %p909};
//   %wire_2717 = &"net135" @WIRE(mode="straight") {%p898 #"I1394":5};
//   %wire_2718 = &"net135" @WIRE(mode="straight") {%p904 %p901};
//   %wire_2719 = &"net135" @WIRE(mode="straight") {%p904 #"I1391":5};
//   %wire_2720 = &"net135" @WIRE(mode="straight") {%p902 #"I1393":5};
//   %wire_2721 = &"net135" @WIRE(mode="straight") {%p909 %p895};
//   %wire_2722 = &"net135" @WIRE(mode="straight") {%p899 #"I1385":5};
//   %wire_2723 = &"net135" @WIRE(mode="straight") {%p907 %p905};
//   %wire_2724 = &"net135" @WIRE(mode="straight") {%p905 %p908};
//   %wire_2725 = &"net135" @WIRE(mode="straight") {%p908 #"I1380":5};
//   %wire_2726 = &"net135" @WIRE(mode="straight") {%p894 #"I1383":5};
//   %wire_2727 = &"net135" @WIRE(mode="straight") {%p894 %p907};
//   %p910 = (300, -194);
//   %p911 = (302, -194);
//   %wire_2728 = &"net199" @WIRE(mode="straight") {%p910 %p911};
//   %wire_2729 = &"net199" @WIRE(mode="straight") {#"I907":6 %p911};
//   %p912 = (280, -194);
//   %wire_2730 = &"net199" @WIRE(mode="straight") {%p912 %p910};
//   %wire_2731 = &"net199" @WIRE(mode="straight") {#"I907":3 %p910};
//   %wire_2732 = &"net199" @WIRE(mode="straight") {#"I908":7 %p912};
//   %p913 = (324, -194);
//   %p914 = (326, -194);
//   %wire_2733 = &"net200" @WIRE(mode="straight") {%p913 %p914};
//   %wire_2734 = &"net200" @WIRE(mode="straight") {#"I906":6 %p914};
//   %p915 = (304, -194);
//   %wire_2735 = &"net200" @WIRE(mode="straight") {%p915 %p913};
//   %wire_2736 = &"net200" @WIRE(mode="straight") {#"I907":7 %p915};
//   %wire_2737 = &"net200" @WIRE(mode="straight") {#"I906":3 %p913};
//   %p916 = (170, -579);
//   %wire_2738 = &"net143" @WIRE(mode="straight") {#"I1387":6 %p916};
//   %p917 = (196, -577);
//   %wire_2739 = &"net143" @WIRE(mode="straight") {#"I1388":7 %p917};
//   %p918 = (228, -579);
//   %wire_2740 = &"net143" @WIRE(mode="straight") {%p918 %p917};
//   %wire_2741 = &"net143" @WIRE(mode="straight") {#"I1389":3 %p918};
//   %wire_2742 = &"net143" @WIRE(mode="straight") {%p916 %p917};
//   %p919 = (252, -579);
//   %wire_2743 = &"net144" @WIRE(mode="straight") {#"I1384":3 %p919};
//   %p920 = (194, -579);
//   %wire_2744 = &"net144" @WIRE(mode="straight") {#"I1388":6 %p920};
//   %p921 = (232, -577);
//   %wire_2745 = &"net144" @WIRE(mode="straight") {%p919 %p921};
//   %wire_2746 = &"net144" @WIRE(mode="straight") {%p920 %p921};
//   %wire_2747 = &"net144" @WIRE(mode="straight") {#"I1389":7 %p921};
//   %p922 = (298, -575);
//   %p923 = (322, -575);
//   %wire_2748 = &"net145" @WIRE(mode="straight") {%p922 %p923};
//   %p924 = (346, -575);
//   %wire_2749 = &"net145" @WIRE(mode="straight") {#"I1394":9 %p924};
//   %wire_2750 = &"net145" @WIRE(mode="straight") {#"I1392":9 %p922};
//   %p925 = (250, -575);
//   %p926 = (274, -575);
//   %wire_2751 = &"net145" @WIRE(mode="straight") {%p925 %p926};
//   %p927 = (394, -575);
//   %wire_2752 = &"net145" @WIRE(mode="straight") {#"I1396":9 %p927};
//   %wire_2753 = &"net145" @WIRE(mode="straight") {#"I1391":9 %p926};
//   %p928 = (370, -575);
//   %wire_2754 = &"net145" @WIRE(mode="straight") {%p928 %p927};
//   %p929 = (142, -575);
//   %p930 = (166, -575);
//   %wire_2755 = &"net145" @WIRE(mode="straight") {%p929 %p930};
//   %p931 = (10, -575);
//   %p932 = (32, -575);
//   %wire_2756 = &"net145" @WIRE(mode="straight") {%p931 %p932};
//   %wire_2757 = &"net145" @WIRE(mode="straight") {#"I1386":9 %p929};
//   %wire_2758 = &"net145" @WIRE(mode="straight") {#"I1393":9 %p923};
//   %wire_2759 = &"net145" @WIRE(mode="straight") {#"I1395":9 %p928};
//   %wire_2760 = &"net145" @WIRE(mode="straight") {#"I1387":9 %p930};
//   %p933 = (80, -575);
//   %wire_2761 = &"net145" @WIRE(mode="straight") {#"I1380":9 %p933};
//   %p934 = (56, -575);
//   %wire_2762 = &"net145" @WIRE(mode="straight") {%p934 %p933};
//   %p935 = (118, -575);
//   %wire_2763 = &"net145" @WIRE(mode="straight") {%p933 %p935};
//   %p936 = (226, -575);
//   %wire_2764 = &"net145" @WIRE(mode="straight") {%p936 %p925};
//   %wire_2765 = &"net145" @WIRE(mode="straight") {#"I1389":9 %p936};
//   %wire_2766 = &"net145" @WIRE(mode="straight") {%p926 %p922};
//   %wire_2767 = &"net145" @WIRE(mode="straight") {#"I1381":9 %p934};
//   %wire_2768 = &"net145" @WIRE(mode="straight") {%p932 %p934};
//   %wire_2769 = &"net145" @WIRE(mode="straight") {#"I1384":9 %p925};
//   %p937 = (190, -575);
//   %wire_2770 = &"net145" @WIRE(mode="straight") {#"I1388":9 %p937};
//   %wire_2771 = &"net145" @WIRE(mode="straight") {%p930 %p937};
//   %p938 = (8, -575);
//   %wire_2772 = &"net145" @WIRE(mode="straight") {%p938 %p931};
//   %wire_2773 = &"net145" @WIRE(mode="straight") {%p937 %p936};
//   %wire_2774 = &"net145" @WIRE(mode="straight") {#"I1383":3 %p931};
//   %wire_2775 = &"net145" @WIRE(mode="straight") {#"I1385":9 %p935};
//   %wire_2776 = &"net145" @WIRE(mode="straight") {%p923 %p924};
//   %wire_2777 = &"net145" @WIRE(mode="straight") {%p935 %p929};
//   %wire_2778 = &"net145" @WIRE(mode="straight") {#"I1382":9 %p932};
//   %wire_2779 = &"net145" @WIRE(mode="straight") {%p924 %p928};
//   %wire_2780 = &"net145" @WIRE(mode="straight") {#"I1383":9 %p938};
//   %p939 = (172, -194);
//   %p940 = (192, -194);
//   %wire_2781 = &"net205" @WIRE(mode="straight") {%p939 %p940};
//   %wire_2782 = &"net205" @WIRE(mode="straight") {#"I891":3 %p940};
//   %p941 = (194, -194);
//   %wire_2783 = &"net205" @WIRE(mode="straight") {#"I891":6 %p941};
//   %wire_2784 = &"net205" @WIRE(mode="straight") {%p940 %p941};
//   %wire_2785 = &"net205" @WIRE(mode="straight") {#"I892":7 %p939};
//   %p942 = (205, -206);
//   %p943 = (205, -203);
//   %wire_2786 = &"net206" @WIRE(mode="straight") {%p942 %p943};
//   %wire_2787 = &"net206" @WIRE(mode="straight") {%p943 #"M167":3};
//   %p944 = (107, -209);
//   %p945 = (107, -206);
//   %wire_2788 = &"net206" @WIRE(mode="straight") {%p944 %p945};
//   %wire_2789 = &"net206" @WIRE(mode="straight") {#"M60":3 %p942};
//   %wire_2790 = &"net206" @WIRE(mode="straight") {%p945 #"M135":1};
//   %wire_2791 = &"net206" @WIRE(mode="straight") {#"I891":4 %p942};
//   %wire_2792 = &"net206" @WIRE(mode="straight") {#"I892":4 #"I891":4};
//   %wire_2793 = &"net206" @WIRE(mode="straight") {#"I893":4 #"I892":4};
//   %wire_2794 = &"net206" @WIRE(mode="straight") {%p945 #"I894":4};
//   %wire_2795 = &"net206" @WIRE(mode="straight") {#"M28":1 %p944};
//   %wire_2796 = &"net206" @WIRE(mode="straight") {#"I894":4 #"I893":4};
//   %p946 = (230, -194);
//   %wire_2797 = &"net207" @WIRE(mode="straight") {#"I890":6 %p946};
//   %p947 = (228, -194);
//   %wire_2798 = &"net207" @WIRE(mode="straight") {#"I890":3 %p947};
//   %p948 = (196, -194);
//   %wire_2799 = &"net207" @WIRE(mode="straight") {%p948 %p947};
//   %wire_2800 = &"net207" @WIRE(mode="straight") {#"I891":7 %p948};
//   %wire_2801 = &"net207" @WIRE(mode="straight") {%p947 %p946};
//   %p949 = (254, -579);
//   %wire_2802 = &"net147" @WIRE(mode="straight") {#"I1384":6 %p949};
//   %p950 = (280, -577);
//   %wire_2803 = &"net147" @WIRE(mode="straight") {%p949 %p950};
//   %wire_2804 = &"net147" @WIRE(mode="straight") {#"I1391":7 %p950};
//   %p951 = (300, -579);
//   %wire_2805 = &"net147" @WIRE(mode="straight") {#"I1392":3 %p951};
//   %wire_2806 = &"net147" @WIRE(mode="straight") {%p951 %p950};
//   %p952 = (34, -229);
//   %wire_2807 = &"net209" @WIRE(mode="straight") {#"I1297":3 %p952};
//   %p953 = (14, -227);
//   %wire_2808 = &"net209" @WIRE(mode="straight") {%p952 %p953};
//   %wire_2809 = &"net209" @WIRE(mode="straight") {#"I1298":7 %p953};
//   %p954 = (-4, -227);
//   %wire_2810 = &"net209" @WIRE(mode="straight") {#"I1478":1 %p954};
//   %wire_2811 = &"net209" @WIRE(mode="straight") {%p954 %p953};
//   %p955 = (205, -171);
//   %wire_2812 = &"net148" @WIRE(mode="straight") {#"M61":3 %p955};
//   %p956 = (205, -168);
//   %wire_2813 = &"net148" @WIRE(mode="straight") {%p956 #"M162":3};
//   %wire_2814 = &"net148" @WIRE(mode="straight") {#"I1286":4 %p955};
//   %wire_2815 = &"net148" @WIRE(mode="straight") {#"I1283":4 #"I1284":4};
//   %wire_2816 = &"net148" @WIRE(mode="straight") {#"I1285":4 #"I1286":4};
//   %wire_2817 = &"net148" @WIRE(mode="straight") {#"I1284":4 #"I1285":4};
//   %p957 = (107, -174);
//   %p958 = (107, -171);
//   %wire_2818 = &"net148" @WIRE(mode="straight") {%p957 %p958};
//   %wire_2819 = &"net148" @WIRE(mode="straight") {#"M27":1 %p957};
//   %wire_2820 = &"net148" @WIRE(mode="straight") {%p955 %p956};
//   %wire_2821 = &"net148" @WIRE(mode="straight") {%p958 #"M134":1};
//   %wire_2822 = &"net148" @WIRE(mode="straight") {%p958 #"I1283":4};
//   %p959 = (124, -437);
//   %p960 = (84, -439);
//   %wire_2823 = &"net152" @WIRE(mode="straight") {%p959 %p960};
//   %p961 = (144, -439);
//   %wire_2824 = &"net152" @WIRE(mode="straight") {#"I1352":3 %p961};
//   %wire_2825 = &"net152" @WIRE(mode="straight") {#"I1346":6 %p960};
//   %wire_2826 = &"net152" @WIRE(mode="straight") {#"I1351":7 %p959};
//   %wire_2827 = &"net152" @WIRE(mode="straight") {%p961 %p959};
//   %p962 = (-4, -463);
//   %p963 = (14, -463);
//   %wire_2828 = &"net154" @WIRE(mode="straight") {%p962 %p963};
//   %p964 = (400, -463);
//   %wire_2829 = &"net154" @WIRE(mode="straight") {%p964 #"I1362":5};
//   %p965 = (256, -463);
//   %p966 = (280, -463);
//   %wire_2830 = &"net154" @WIRE(mode="straight") {%p965 %p966};
//   %wire_2831 = &"net154" @WIRE(mode="straight") {%p962 #"I1502":2};
//   %p967 = (38, -463);
//   %wire_2832 = &"net154" @WIRE(mode="straight") {%p967 #"I1348":5};
//   %wire_2833 = &"net154" @WIRE(mode="straight") {%p966 #"I1357":5};
//   %p968 = (376, -463);
//   %wire_2834 = &"net154" @WIRE(mode="straight") {%p968 %p964};
//   %p969 = (196, -463);
//   %p970 = (232, -463);
//   %wire_2835 = &"net154" @WIRE(mode="straight") {%p969 %p970};
//   %p971 = (124, -463);
//   %wire_2836 = &"net154" @WIRE(mode="straight") {%p971 #"I1351":5};
//   %p972 = (62, -463);
//   %wire_2837 = &"net154" @WIRE(mode="straight") {%p967 %p972};
//   %wire_2838 = &"net154" @WIRE(mode="straight") {%p965 #"I1350":5};
//   %wire_2839 = &"net154" @WIRE(mode="straight") {%p970 #"I1355":5};
//   %p973 = (172, -463);
//   %wire_2840 = &"net154" @WIRE(mode="straight") {%p973 %p969};
//   %p974 = (148, -463);
//   %wire_2841 = &"net154" @WIRE(mode="straight") {%p974 %p973};
//   %wire_2842 = &"net154" @WIRE(mode="straight") {%p973 #"I1353":5};
//   %p975 = (86, -463);
//   %wire_2843 = &"net154" @WIRE(mode="straight") {%p972 %p975};
//   %wire_2844 = &"net154" @WIRE(mode="straight") {%p971 %p974};
//   %p976 = (304, -463);
//   %wire_2845 = &"net154" @WIRE(mode="straight") {%p966 %p976};
//   %wire_2846 = &"net154" @WIRE(mode="straight") {%p964 #"I1356":2};
//   %wire_2847 = &"net154" @WIRE(mode="straight") {%p963 %p967};
//   %wire_2848 = &"net154" @WIRE(mode="straight") {%p963 #"I1349":5};
//   %wire_2849 = &"net154" @WIRE(mode="straight") {%p968 #"I1361":5};
//   %wire_2850 = &"net154" @WIRE(mode="straight") {%p974 #"I1352":5};
//   %wire_2851 = &"net154" @WIRE(mode="straight") {%p975 #"I1346":5};
//   %p977 = (352, -463);
//   %wire_2852 = &"net154" @WIRE(mode="straight") {%p977 %p968};
//   %p978 = (328, -463);
//   %wire_2853 = &"net154" @WIRE(mode="straight") {%p978 %p977};
//   %wire_2854 = &"net154" @WIRE(mode="straight") {%p976 %p978};
//   %wire_2855 = &"net154" @WIRE(mode="straight") {%p977 #"I1360":5};
//   %wire_2856 = &"net154" @WIRE(mode="straight") {%p970 %p965};
//   %wire_2857 = &"net154" @WIRE(mode="straight") {%p976 #"I1358":5};
//   %wire_2858 = &"net154" @WIRE(mode="straight") {%p972 #"I1347":5};
//   %wire_2859 = &"net154" @WIRE(mode="straight") {%p975 %p971};
//   %wire_2860 = &"net154" @WIRE(mode="straight") {%p978 #"I1359":5};
//   %wire_2861 = &"net154" @WIRE(mode="straight") {%p969 #"I1354":5};
//   %p979 = (-6, -276);
//   %wire_2862 = &"net214" @WIRE(mode="straight") {%p979 #"M74":1};
//   %wire_2863 = &"net214" @WIRE(mode="straight") {#"I1488":1 %p979};
//   %wire_2864 = &"net214" @WIRE(mode="straight") {%p979 #"I919":4};
//   %p980 = (97, -276);
//   %wire_2865 = &"net214" @WIRE(mode="straight") {#"M30":3 %p980};
//   %p981 = (97, -273);
//   %wire_2866 = &"net214" @WIRE(mode="straight") {%p980 %p981};
//   %wire_2867 = &"net214" @WIRE(mode="straight") {%p981 #"M137":3};
//   %wire_2868 = &"net214" @WIRE(mode="straight") {#"I920":4 #"I921":4};
//   %p982 = (-26, -278);
//   %wire_2869 = &"net214" @WIRE(mode="straight") {#"I1492":2 %p982};
//   %wire_2870 = &"net214" @WIRE(mode="straight") {#"I922":4 %p980};
//   %wire_2871 = &"net214" @WIRE(mode="straight") {#"I921":4 #"I922":4};
//   %wire_2872 = &"net214" @WIRE(mode="straight") {#"I919":4 #"I920":4};
//   %wire_2873 = &"net214" @WIRE(mode="straight") {%p982 #"I1488":1};
//   %p983 = (350, -614);
//   %wire_2874 = &"net215" @WIRE(mode="straight") {#"I1145":6 %p983};
//   %p984 = (348, -614);
//   %wire_2875 = &"net215" @WIRE(mode="straight") {%p984 %p983};
//   %wire_2876 = &"net215" @WIRE(mode="straight") {#"I1145":3 %p984};
//   %p985 = (328, -614);
//   %wire_2877 = &"net215" @WIRE(mode="straight") {%p985 %p984};
//   %wire_2878 = &"net215" @WIRE(mode="straight") {#"I1146":7 %p985};
//   %wire_2879 = &"net216" @WIRE(mode="straight") {#"I1144":4 #"I1143":4};
//   %wire_2880 = &"net216" @WIRE(mode="straight") {#"I1145":4 #"I1144":4};
//   %wire_2881 = &"net216" @WIRE(mode="straight") {#"I1146":4 #"I1145":4};
//   %wire_2882 = &"net216" @WIRE(mode="straight") {#"I1147":4 #"I1146":4};
//   %wire_2883 = &"net216" @WIRE(mode="straight") {#"I1148":4 #"I1147":4};
//   %wire_2884 = &"net216" @WIRE(mode="straight") {#"I1129":4 #"I1148":4};
//   %wire_2885 = &"net216" @WIRE(mode="straight") {#"I1130":4 #"I1129":4};
//   %p986 = (215, -626);
//   %wire_2886 = &"net216" @WIRE(mode="straight") {%p986 #"I1130":4};
//   %p987 = (215, -629);
//   %wire_2887 = &"net216" @WIRE(mode="straight") {#"M47":1 %p987};
//   %wire_2888 = &"net216" @WIRE(mode="straight") {%p987 %p986};
//   %wire_2889 = &"net216" @WIRE(mode="straight") {%p986 #"M154":1};
//   %p988 = (-20, -638);
//   %p989 = (14, -638);
//   %wire_2890 = &"net217" @WIRE(mode="straight") {%p988 %p989};
//   %wire_2891 = &"net217" @WIRE(mode="straight") {%p988 #"I1533":2};
//   %p990 = (400, -638);
//   %wire_2892 = &"net217" @WIRE(mode="straight") {%p990 #"I1142":2};
//   %wire_2893 = &"net217" @WIRE(mode="straight") {%p990 #"I1143":5};
//   %p991 = (376, -638);
//   %wire_2894 = &"net217" @WIRE(mode="straight") {%p991 %p990};
//   %wire_2895 = &"net217" @WIRE(mode="straight") {%p991 #"I1144":5};
//   %p992 = (352, -638);
//   %wire_2896 = &"net217" @WIRE(mode="straight") {%p992 %p991};
//   %wire_2897 = &"net217" @WIRE(mode="straight") {%p992 #"I1145":5};
//   %p993 = (328, -638);
//   %wire_2898 = &"net217" @WIRE(mode="straight") {%p993 %p992};
//   %wire_2899 = &"net217" @WIRE(mode="straight") {%p993 #"I1146":5};
//   %p994 = (304, -638);
//   %wire_2900 = &"net217" @WIRE(mode="straight") {%p994 %p993};
//   %wire_2901 = &"net217" @WIRE(mode="straight") {%p994 #"I1147":5};
//   %p995 = (280, -638);
//   %wire_2902 = &"net217" @WIRE(mode="straight") {%p995 %p994};
//   %wire_2903 = &"net217" @WIRE(mode="straight") {%p995 #"I1148":5};
//   %p996 = (256, -638);
//   %wire_2904 = &"net217" @WIRE(mode="straight") {%p996 %p995};
//   %wire_2905 = &"net217" @WIRE(mode="straight") {%p996 #"I1129":5};
//   %p997 = (232, -638);
//   %wire_2906 = &"net217" @WIRE(mode="straight") {%p997 %p996};
//   %wire_2907 = &"net217" @WIRE(mode="straight") {%p997 #"I1130":5};
//   %p998 = (196, -638);
//   %wire_2908 = &"net217" @WIRE(mode="straight") {%p998 %p997};
//   %wire_2909 = &"net217" @WIRE(mode="straight") {%p998 #"I1131":5};
//   %p999 = (172, -638);
//   %wire_2910 = &"net217" @WIRE(mode="straight") {%p999 %p998};
//   %wire_2911 = &"net217" @WIRE(mode="straight") {%p999 #"I1132":5};
//   %p1000 = (148, -638);
//   %wire_2912 = &"net217" @WIRE(mode="straight") {%p1000 %p999};
//   %wire_2913 = &"net217" @WIRE(mode="straight") {%p1000 #"I1133":5};
//   %p1001 = (124, -638);
//   %wire_2914 = &"net217" @WIRE(mode="straight") {%p1001 %p1000};
//   %wire_2915 = &"net217" @WIRE(mode="straight") {%p1001 #"I1134":5};
//   %p1002 = (86, -638);
//   %wire_2916 = &"net217" @WIRE(mode="straight") {%p1002 %p1001};
//   %wire_2917 = &"net217" @WIRE(mode="straight") {%p1002 #"I1122":5};
//   %p1003 = (62, -638);
//   %wire_2918 = &"net217" @WIRE(mode="straight") {%p1003 %p1002};
//   %wire_2919 = &"net217" @WIRE(mode="straight") {%p1003 #"I1121":5};
//   %p1004 = (38, -638);
//   %wire_2920 = &"net217" @WIRE(mode="straight") {%p1004 %p1003};
//   %wire_2921 = &"net217" @WIRE(mode="straight") {%p1004 #"I1120":5};
//   %wire_2922 = &"net217" @WIRE(mode="straight") {%p989 %p1004};
//   %wire_2923 = &"net217" @WIRE(mode="straight") {%p989 #"I1119":5};
//   %p1005 = (374, -614);
//   %wire_2924 = &"net218" @WIRE(mode="straight") {#"I1144":6 %p1005};
//   %p1006 = (372, -614);
//   %wire_2925 = &"net218" @WIRE(mode="straight") {%p1006 %p1005};
//   %wire_2926 = &"net218" @WIRE(mode="straight") {#"I1144":3 %p1006};
//   %p1007 = (352, -614);
//   %wire_2927 = &"net218" @WIRE(mode="straight") {%p1007 %p1006};
//   %wire_2928 = &"net218" @WIRE(mode="straight") {#"I1145":7 %p1007};
//   %p1008 = (394, -610);
//   %wire_2929 = &"net219" @WIRE(mode="straight") {#"I1143":9 %p1008};
//   %p1009 = (370, -610);
//   %wire_2930 = &"net219" @WIRE(mode="straight") {%p1009 %p1008};
//   %wire_2931 = &"net219" @WIRE(mode="straight") {#"I1144":9 %p1009};
//   %p1010 = (346, -610);
//   %wire_2932 = &"net219" @WIRE(mode="straight") {%p1010 %p1009};
//   %wire_2933 = &"net219" @WIRE(mode="straight") {#"I1145":9 %p1010};
//   %p1011 = (322, -610);
//   %wire_2934 = &"net219" @WIRE(mode="straight") {%p1011 %p1010};
//   %wire_2935 = &"net219" @WIRE(mode="straight") {#"I1146":9 %p1011};
//   %p1012 = (298, -610);
//   %wire_2936 = &"net219" @WIRE(mode="straight") {%p1012 %p1011};
//   %wire_2937 = &"net219" @WIRE(mode="straight") {#"I1147":9 %p1012};
//   %p1013 = (274, -610);
//   %wire_2938 = &"net219" @WIRE(mode="straight") {%p1013 %p1012};
//   %wire_2939 = &"net219" @WIRE(mode="straight") {#"I1148":9 %p1013};
//   %p1014 = (250, -610);
//   %wire_2940 = &"net219" @WIRE(mode="straight") {%p1014 %p1013};
//   %wire_2941 = &"net219" @WIRE(mode="straight") {#"I1129":9 %p1014};
//   %p1015 = (226, -610);
//   %wire_2942 = &"net219" @WIRE(mode="straight") {%p1015 %p1014};
//   %wire_2943 = &"net219" @WIRE(mode="straight") {#"I1130":9 %p1015};
//   %p1016 = (190, -610);
//   %wire_2944 = &"net219" @WIRE(mode="straight") {%p1016 %p1015};
//   %wire_2945 = &"net219" @WIRE(mode="straight") {#"I1131":9 %p1016};
//   %p1017 = (166, -610);
//   %wire_2946 = &"net219" @WIRE(mode="straight") {%p1017 %p1016};
//   %wire_2947 = &"net219" @WIRE(mode="straight") {#"I1132":9 %p1017};
//   %p1018 = (142, -610);
//   %wire_2948 = &"net219" @WIRE(mode="straight") {%p1018 %p1017};
//   %wire_2949 = &"net219" @WIRE(mode="straight") {#"I1133":9 %p1018};
//   %p1019 = (118, -610);
//   %wire_2950 = &"net219" @WIRE(mode="straight") {%p1019 %p1018};
//   %wire_2951 = &"net219" @WIRE(mode="straight") {#"I1134":9 %p1019};
//   %p1020 = (80, -610);
//   %wire_2952 = &"net219" @WIRE(mode="straight") {%p1020 %p1019};
//   %wire_2953 = &"net219" @WIRE(mode="straight") {#"I1122":9 %p1020};
//   %p1021 = (56, -610);
//   %wire_2954 = &"net219" @WIRE(mode="straight") {%p1021 %p1020};
//   %wire_2955 = &"net219" @WIRE(mode="straight") {#"I1121":9 %p1021};
//   %p1022 = (32, -610);
//   %wire_2956 = &"net219" @WIRE(mode="straight") {%p1022 %p1021};
//   %wire_2957 = &"net219" @WIRE(mode="straight") {#"I1120":9 %p1022};
//   %p1023 = (10, -610);
//   %wire_2958 = &"net219" @WIRE(mode="straight") {%p1023 %p1022};
//   %wire_2959 = &"net219" @WIRE(mode="straight") {#"I1119":3 %p1023};
//   %p1024 = (8, -610);
//   %wire_2960 = &"net219" @WIRE(mode="straight") {%p1024 %p1023};
//   %wire_2961 = &"net219" @WIRE(mode="straight") {#"I1119":9 %p1024};
//   %p1025 = (36, -439);
//   %p1026 = (62, -437);
//   %wire_2962 = &"net155" @WIRE(mode="straight") {%p1025 %p1026};
//   %wire_2963 = &"net155" @WIRE(mode="straight") {#"I1348":6 %p1025};
//   %p1027 = (82, -439);
//   %wire_2964 = &"net155" @WIRE(mode="straight") {%p1027 %p1026};
//   %wire_2965 = &"net155" @WIRE(mode="straight") {#"I1346":3 %p1027};
//   %wire_2966 = &"net155" @WIRE(mode="straight") {#"I1347":7 %p1026};
//   %p1028 = (120, -439);
//   %p1029 = (86, -437);
//   %wire_2967 = &"net158" @WIRE(mode="straight") {%p1028 %p1029};
//   %wire_2968 = &"net158" @WIRE(mode="straight") {#"I1351":3 %p1028};
//   %p1030 = (60, -439);
//   %wire_2969 = &"net158" @WIRE(mode="straight") {#"I1347":6 %p1030};
//   %wire_2970 = &"net158" @WIRE(mode="straight") {%p1030 %p1029};
//   %wire_2971 = &"net158" @WIRE(mode="straight") {#"I1346":7 %p1029};
//   %p1031 = (274, -435);
//   %wire_2972 = &"net159" @WIRE(mode="straight") {#"I1357":9 %p1031};
//   %p1032 = (370, -435);
//   %wire_2973 = &"net159" @WIRE(mode="straight") {#"I1361":9 %p1032};
//   %p1033 = (56, -435);
//   %wire_2974 = &"net159" @WIRE(mode="straight") {#"I1347":9 %p1033};
//   %p1034 = (32, -435);
//   %wire_2975 = &"net159" @WIRE(mode="straight") {#"I1348":9 %p1034};
//   %p1035 = (80, -435);
//   %p1036 = (118, -435);
//   %wire_2976 = &"net159" @WIRE(mode="straight") {%p1035 %p1036};
//   %p1037 = (346, -435);
//   %wire_2977 = &"net159" @WIRE(mode="straight") {%p1037 %p1032};
//   %p1038 = (142, -435);
//   %wire_2978 = &"net159" @WIRE(mode="straight") {#"I1352":9 %p1038};
//   %p1039 = (10, -435);
//   %wire_2979 = &"net159" @WIRE(mode="straight") {%p1039 %p1034};
//   %p1040 = (226, -435);
//   %wire_2980 = &"net159" @WIRE(mode="straight") {#"I1355":9 %p1040};
//   %wire_2981 = &"net159" @WIRE(mode="straight") {#"I1351":9 %p1036};
//   %p1041 = (298, -435);
//   %p1042 = (322, -435);
//   %wire_2982 = &"net159" @WIRE(mode="straight") {%p1041 %p1042};
//   %wire_2983 = &"net159" @WIRE(mode="straight") {#"I1346":9 %p1035};
//   %p1043 = (190, -435);
//   %wire_2984 = &"net159" @WIRE(mode="straight") {%p1043 %p1040};
//   %wire_2985 = &"net159" @WIRE(mode="straight") {%p1033 %p1035};
//   %p1044 = (250, -435);
//   %wire_2986 = &"net159" @WIRE(mode="straight") {%p1044 %p1031};
//   %wire_2987 = &"net159" @WIRE(mode="straight") {%p1040 %p1044};
//   %wire_2988 = &"net159" @WIRE(mode="straight") {#"I1349":3 %p1039};
//   %wire_2989 = &"net159" @WIRE(mode="straight") {#"I1350":9 %p1044};
//   %wire_2990 = &"net159" @WIRE(mode="straight") {%p1036 %p1038};
//   %p1045 = (8, -435);
//   %wire_2991 = &"net159" @WIRE(mode="straight") {#"I1349":9 %p1045};
//   %wire_2992 = &"net159" @WIRE(mode="straight") {%p1031 %p1041};
//   %wire_2993 = &"net159" @WIRE(mode="straight") {%p1045 %p1039};
//   %p1046 = (166, -435);
//   %wire_2994 = &"net159" @WIRE(mode="straight") {%p1046 %p1043};
//   %wire_2995 = &"net159" @WIRE(mode="straight") {%p1038 %p1046};
//   %wire_2996 = &"net159" @WIRE(mode="straight") {#"I1353":9 %p1046};
//   %wire_2997 = &"net159" @WIRE(mode="straight") {%p1034 %p1033};
//   %wire_2998 = &"net159" @WIRE(mode="straight") {#"I1359":9 %p1042};
//   %p1047 = (394, -435);
//   %wire_2999 = &"net159" @WIRE(mode="straight") {%p1032 %p1047};
//   %wire_3000 = &"net159" @WIRE(mode="straight") {#"I1362":9 %p1047};
//   %wire_3001 = &"net159" @WIRE(mode="straight") {#"I1358":9 %p1041};
//   %wire_3002 = &"net159" @WIRE(mode="straight") {#"I1354":9 %p1043};
//   %wire_3003 = &"net159" @WIRE(mode="straight") {%p1042 %p1037};
//   %wire_3004 = &"net159" @WIRE(mode="straight") {#"I1360":9 %p1037};
//   %p1048 = (205, -626);
//   %p1049 = (205, -623);
//   %wire_3005 = &"net223" @WIRE(mode="straight") {%p1048 %p1049};
//   %wire_3006 = &"net223" @WIRE(mode="straight") {#"M47":3 %p1048};
//   %wire_3007 = &"net223" @WIRE(mode="straight") {#"I1131":4 %p1048};
//   %wire_3008 = &"net223" @WIRE(mode="straight") {#"I1132":4 #"I1131":4};
//   %wire_3009 = &"net223" @WIRE(mode="straight") {#"I1133":4 #"I1132":4};
//   %wire_3010 = &"net223" @WIRE(mode="straight") {#"I1134":4 #"I1133":4};
//   %p1050 = (107, -626);
//   %wire_3011 = &"net223" @WIRE(mode="straight") {%p1050 #"M147":1};
//   %p1051 = (107, -629);
//   %wire_3012 = &"net223" @WIRE(mode="straight") {%p1051 %p1050};
//   %wire_3013 = &"net223" @WIRE(mode="straight") {%p1050 #"I1134":4};
//   %wire_3014 = &"net223" @WIRE(mode="straight") {%p1049 #"M154":3};
//   %wire_3015 = &"net223" @WIRE(mode="straight") {#"M40":1 %p1051};
//   %p1052 = (-6, -626);
//   %wire_3016 = &"net224" @WIRE(mode="straight") {%p1052 #"M84":1};
//   %wire_3017 = &"net224" @WIRE(mode="straight") {#"I1528":1 %p1052};
//   %p1053 = (-26, -628);
//   %wire_3018 = &"net224" @WIRE(mode="straight") {%p1053 #"I1528":1};
//   %wire_3019 = &"net224" @WIRE(mode="straight") {#"I1532":2 %p1053};
//   %p1054 = (97, -626);
//   %wire_3020 = &"net224" @WIRE(mode="straight") {#"I1122":4 %p1054};
//   %wire_3021 = &"net224" @WIRE(mode="straight") {#"I1121":4 #"I1122":4};
//   %wire_3022 = &"net224" @WIRE(mode="straight") {#"I1120":4 #"I1121":4};
//   %wire_3023 = &"net224" @WIRE(mode="straight") {#"I1119":4 #"I1120":4};
//   %p1055 = (97, -623);
//   %wire_3024 = &"net224" @WIRE(mode="straight") {%p1055 #"M147":3};
//   %wire_3025 = &"net224" @WIRE(mode="straight") {#"M40":3 %p1054};
//   %wire_3026 = &"net224" @WIRE(mode="straight") {%p1052 #"I1119":4};
//   %wire_3027 = &"net224" @WIRE(mode="straight") {%p1054 %p1055};
//   %p1056 = (398, -50);
//   %wire_3028 = &"net204" @WIRE(mode="straight") {%p1056 #"I783":6};
//   %p1057 = (400, -50);
//   %wire_3029 = &"net204" @WIRE(mode="straight") {%p1056 %p1057};
//   %wire_3030 = &"net204" @WIRE(mode="straight") {#"I823":7 %p1057};
//   %p1058 = (254, -614);
//   %wire_3031 = &"net226" @WIRE(mode="straight") {#"I1129":6 %p1058};
//   %p1059 = (252, -614);
//   %wire_3032 = &"net226" @WIRE(mode="straight") {%p1059 %p1058};
//   %wire_3033 = &"net226" @WIRE(mode="straight") {#"I1129":3 %p1059};
//   %p1060 = (232, -614);
//   %wire_3034 = &"net226" @WIRE(mode="straight") {%p1060 %p1059};
//   %wire_3035 = &"net226" @WIRE(mode="straight") {#"I1130":7 %p1060};
//   %p1061 = (278, -614);
//   %wire_3036 = &"net227" @WIRE(mode="straight") {#"I1148":6 %p1061};
//   %p1062 = (276, -614);
//   %wire_3037 = &"net227" @WIRE(mode="straight") {%p1062 %p1061};
//   %wire_3038 = &"net227" @WIRE(mode="straight") {#"I1148":3 %p1062};
//   %p1063 = (256, -614);
//   %wire_3039 = &"net227" @WIRE(mode="straight") {%p1063 %p1062};
//   %wire_3040 = &"net227" @WIRE(mode="straight") {#"I1129":7 %p1063};
//   %p1064 = (252, -369);
//   %p1065 = (232, -367);
//   %wire_3041 = &"net161" @WIRE(mode="straight") {%p1064 %p1065};
//   %wire_3042 = &"net161" @WIRE(mode="straight") {#"I1338":7 %p1065};
//   %p1066 = (194, -369);
//   %wire_3043 = &"net161" @WIRE(mode="straight") {%p1066 %p1065};
//   %wire_3044 = &"net161" @WIRE(mode="straight") {#"I1333":3 %p1064};
//   %wire_3045 = &"net161" @WIRE(mode="straight") {#"I1337":6 %p1066};
//   %p1067 = (205, -378);
//   %wire_3046 = &"net169" @WIRE(mode="straight") {%p1067 #"M155":3};
//   %p1068 = (205, -381);
//   %wire_3047 = &"net169" @WIRE(mode="straight") {%p1068 %p1067};
//   %wire_3048 = &"net169" @WIRE(mode="straight") {#"M55":3 %p1068};
//   %wire_3049 = &"net169" @WIRE(mode="straight") {#"I1336":4 #"I1337":4};
//   %wire_3050 = &"net169" @WIRE(mode="straight") {#"I1337":4 %p1068};
//   %p1069 = (107, -384);
//   %wire_3051 = &"net169" @WIRE(mode="straight") {#"M33":1 %p1069};
//   %p1070 = (107, -381);
//   %wire_3052 = &"net169" @WIRE(mode="straight") {%p1070 #"I1334":4};
//   %wire_3053 = &"net169" @WIRE(mode="straight") {%p1070 #"M140":1};
//   %wire_3054 = &"net169" @WIRE(mode="straight") {%p1069 %p1070};
//   %wire_3055 = &"net169" @WIRE(mode="straight") {#"I1334":4 #"I1335":4};
//   %wire_3056 = &"net169" @WIRE(mode="straight") {#"I1335":4 #"I1336":4};
//   %p1071 = (172, -367);
//   %wire_3057 = &"net171" @WIRE(mode="straight") {#"I1336":7 %p1071};
//   %p1072 = (146, -369);
//   %wire_3058 = &"net171" @WIRE(mode="straight") {#"I1335":6 %p1072};
//   %wire_3059 = &"net171" @WIRE(mode="straight") {%p1072 %p1071};
//   %p1073 = (192, -369);
//   %wire_3060 = &"net171" @WIRE(mode="straight") {%p1073 %p1071};
//   %wire_3061 = &"net171" @WIRE(mode="straight") {#"I1337":3 %p1073};
//   %p1074 = (-4, -647);
//   %p1075 = (14, -647);
//   %wire_3062 = &"net231" @WIRE(mode="straight") {%p1074 %p1075};
//   %wire_3063 = &"net231" @WIRE(mode="straight") {#"I1526":1 %p1074};
//   %wire_3064 = &"net231" @WIRE(mode="straight") {#"I1400":7 %p1075};
//   %p1076 = (34, -649);
//   %wire_3065 = &"net231" @WIRE(mode="straight") {#"I1399":3 %p1076};
//   %wire_3066 = &"net231" @WIRE(mode="straight") {%p1076 %p1075};
//   %p1077 = (36, -614);
//   %wire_3067 = &"net232" @WIRE(mode="straight") {#"I1120":6 %p1077};
//   %p1078 = (34, -614);
//   %wire_3068 = &"net232" @WIRE(mode="straight") {%p1078 %p1077};
//   %wire_3069 = &"net232" @WIRE(mode="straight") {#"I1120":3 %p1078};
//   %p1079 = (14, -614);
//   %wire_3070 = &"net232" @WIRE(mode="straight") {%p1079 %p1078};
//   %wire_3071 = &"net232" @WIRE(mode="straight") {#"I1119":7 %p1079};
//   %p1080 = (228, -369);
//   %p1081 = (196, -367);
//   %wire_3072 = &"net174" @WIRE(mode="straight") {%p1080 %p1081};
//   %wire_3073 = &"net174" @WIRE(mode="straight") {#"I1338":3 %p1080};
//   %wire_3074 = &"net174" @WIRE(mode="straight") {#"I1337":7 %p1081};
//   %p1082 = (170, -369);
//   %wire_3075 = &"net174" @WIRE(mode="straight") {%p1082 %p1081};
//   %wire_3076 = &"net174" @WIRE(mode="straight") {#"I1336":6 %p1082};
//   %p1083 = (38, -367);
//   %wire_3077 = &"net181" @WIRE(mode="straight") {#"I1331":7 %p1083};
//   %p1084 = (12, -369);
//   %wire_3078 = &"net181" @WIRE(mode="straight") {#"I1332":6 %p1084};
//   %wire_3079 = &"net181" @WIRE(mode="straight") {%p1084 %p1083};
//   %p1085 = (58, -369);
//   %wire_3080 = &"net181" @WIRE(mode="straight") {%p1085 %p1083};
//   %wire_3081 = &"net181" @WIRE(mode="straight") {#"I1330":3 %p1085};
//   %p1086 = (300, -509);
//   %wire_3082 = &"net182" @WIRE(mode="straight") {#"I1375":3 %p1086};
//   %p1087 = (254, -509);
//   %wire_3083 = &"net182" @WIRE(mode="straight") {#"I1367":6 %p1087};
//   %p1088 = (280, -507);
//   %wire_3084 = &"net182" @WIRE(mode="straight") {%p1087 %p1088};
//   %wire_3085 = &"net182" @WIRE(mode="straight") {#"I1374":7 %p1088};
//   %wire_3086 = &"net182" @WIRE(mode="straight") {%p1086 %p1088};
//   %p1089 = (215, -521);
//   %wire_3087 = &"net183" @WIRE(mode="straight") {%p1089 #"I1372":4};
//   %p1090 = (215, -524);
//   %wire_3088 = &"net183" @WIRE(mode="straight") {%p1090 %p1089};
//   %wire_3089 = &"net183" @WIRE(mode="straight") {%p1089 #"M158":1};
//   %wire_3090 = &"net183" @WIRE(mode="straight") {#"M51":1 %p1090};
//   %wire_3091 = &"net183" @WIRE(mode="straight") {#"I1367":4 #"I1374":4};
//   %wire_3092 = &"net183" @WIRE(mode="straight") {#"I1375":4 #"I1376":4};
//   %wire_3093 = &"net183" @WIRE(mode="straight") {#"I1378":4 #"I1379":4};
//   %wire_3094 = &"net183" @WIRE(mode="straight") {#"I1374":4 #"I1375":4};
//   %wire_3095 = &"net183" @WIRE(mode="straight") {#"I1376":4 #"I1377":4};
//   %wire_3096 = &"net183" @WIRE(mode="straight") {#"I1377":4 #"I1378":4};
//   %wire_3097 = &"net183" @WIRE(mode="straight") {#"I1372":4 #"I1367":4};
//   %p1091 = (14, -533);
//   %p1092 = (38, -533);
//   %wire_3098 = &"net186" @WIRE(mode="straight") {%p1091 %p1092};
//   %p1093 = (196, -533);
//   %p1094 = (232, -533);
//   %wire_3099 = &"net186" @WIRE(mode="straight") {%p1093 %p1094};
//   %p1095 = (328, -533);
//   %wire_3100 = &"net186" @WIRE(mode="straight") {%p1095 #"I1376":5};
//   %p1096 = (148, -533);
//   %p1097 = (172, -533);
//   %wire_3101 = &"net186" @WIRE(mode="straight") {%p1096 %p1097};
//   %wire_3102 = &"net186" @WIRE(mode="straight") {%p1096 #"I1369":5};
//   %p1098 = (62, -533);
//   %wire_3103 = &"net186" @WIRE(mode="straight") {%p1092 %p1098};
//   %p1099 = (-4, -533);
//   %wire_3104 = &"net186" @WIRE(mode="straight") {%p1099 #"I1510":2};
//   %wire_3105 = &"net186" @WIRE(mode="straight") {%p1099 %p1091};
//   %wire_3106 = &"net186" @WIRE(mode="straight") {%p1093 #"I1371":5};
//   %p1100 = (124, -533);
//   %wire_3107 = &"net186" @WIRE(mode="straight") {%p1100 %p1096};
//   %p1101 = (400, -533);
//   %wire_3108 = &"net186" @WIRE(mode="straight") {%p1101 #"I1373":2};
//   %p1102 = (376, -533);
//   %wire_3109 = &"net186" @WIRE(mode="straight") {%p1102 #"I1378":5};
//   %wire_3110 = &"net186" @WIRE(mode="straight") {%p1097 %p1093};
//   %wire_3111 = &"net186" @WIRE(mode="straight") {%p1098 #"I1364":5};
//   %wire_3112 = &"net186" @WIRE(mode="straight") {%p1097 #"I1370":5};
//   %p1103 = (304, -533);
//   %wire_3113 = &"net186" @WIRE(mode="straight") {%p1103 %p1095};
//   %p1104 = (86, -533);
//   %wire_3114 = &"net186" @WIRE(mode="straight") {%p1098 %p1104};
//   %wire_3115 = &"net186" @WIRE(mode="straight") {%p1092 #"I1365":5};
//   %p1105 = (280, -533);
//   %wire_3116 = &"net186" @WIRE(mode="straight") {%p1105 %p1103};
//   %wire_3117 = &"net186" @WIRE(mode="straight") {%p1100 #"I1368":5};
//   %p1106 = (352, -533);
//   %wire_3118 = &"net186" @WIRE(mode="straight") {%p1095 %p1106};
//   %wire_3119 = &"net186" @WIRE(mode="straight") {%p1103 #"I1375":5};
//   %wire_3120 = &"net186" @WIRE(mode="straight") {%p1105 #"I1374":5};
//   %p1107 = (256, -533);
//   %wire_3121 = &"net186" @WIRE(mode="straight") {%p1107 #"I1367":5};
//   %wire_3122 = &"net186" @WIRE(mode="straight") {%p1094 #"I1372":5};
//   %wire_3123 = &"net186" @WIRE(mode="straight") {%p1106 #"I1377":5};
//   %wire_3124 = &"net186" @WIRE(mode="straight") {%p1104 #"I1363":5};
//   %wire_3125 = &"net186" @WIRE(mode="straight") {%p1101 #"I1379":5};
//   %wire_3126 = &"net186" @WIRE(mode="straight") {%p1091 #"I1366":5};
//   %wire_3127 = &"net186" @WIRE(mode="straight") {%p1104 %p1100};
//   %wire_3128 = &"net186" @WIRE(mode="straight") {%p1107 %p1105};
//   %wire_3129 = &"net186" @WIRE(mode="straight") {%p1094 %p1107};
//   %wire_3130 = &"net186" @WIRE(mode="straight") {%p1106 %p1102};
//   %wire_3131 = &"net186" @WIRE(mode="straight") {%p1102 %p1101};
//   %p1108 = (146, -474);
//   %wire_3132 = &"net238" @WIRE(mode="straight") {#"I1053":6 %p1108};
//   %p1109 = (144, -474);
//   %wire_3133 = &"net238" @WIRE(mode="straight") {#"I1053":3 %p1109};
//   %p1110 = (124, -474);
//   %wire_3134 = &"net238" @WIRE(mode="straight") {#"I1054":7 %p1110};
//   %wire_3135 = &"net238" @WIRE(mode="straight") {%p1110 %p1109};
//   %wire_3136 = &"net238" @WIRE(mode="straight") {%p1109 %p1108};
//   %p1111 = (205, -486);
//   %p1112 = (205, -483);
//   %wire_3137 = &"net239" @WIRE(mode="straight") {%p1111 %p1112};
//   %wire_3138 = &"net239" @WIRE(mode="straight") {#"M52":3 %p1111};
//   %wire_3139 = &"net239" @WIRE(mode="straight") {%p1112 #"M159":3};
//   %p1113 = (107, -486);
//   %wire_3140 = &"net239" @WIRE(mode="straight") {%p1113 #"I1054":4};
//   %p1114 = (107, -489);
//   %wire_3141 = &"net239" @WIRE(mode="straight") {%p1114 %p1113};
//   %wire_3142 = &"net239" @WIRE(mode="straight") {#"I1053":4 #"I1052":4};
//   %wire_3143 = &"net239" @WIRE(mode="straight") {#"I1051":4 %p1111};
//   %wire_3144 = &"net239" @WIRE(mode="straight") {#"I1054":4 #"I1053":4};
//   %wire_3145 = &"net239" @WIRE(mode="straight") {#"M36":1 %p1114};
//   %wire_3146 = &"net239" @WIRE(mode="straight") {#"I1052":4 #"I1051":4};
//   %wire_3147 = &"net239" @WIRE(mode="straight") {%p1113 #"M143":1};
//   %p1115 = (62, -498);
//   %p1116 = (86, -498);
//   %wire_3148 = &"net240" @WIRE(mode="straight") {%p1115 %p1116};
//   %p1117 = (232, -498);
//   %p1118 = (256, -498);
//   %wire_3149 = &"net240" @WIRE(mode="straight") {%p1117 %p1118};
//   %wire_3150 = &"net240" @WIRE(mode="straight") {%p1117 #"I1050":5};
//   %p1119 = (376, -498);
//   %p1120 = (400, -498);
//   %wire_3151 = &"net240" @WIRE(mode="straight") {%p1119 %p1120};
//   %p1121 = (172, -498);
//   %p1122 = (196, -498);
//   %wire_3152 = &"net240" @WIRE(mode="straight") {%p1121 %p1122};
//   %p1123 = (148, -498);
//   %wire_3153 = &"net240" @WIRE(mode="straight") {%p1123 %p1121};
//   %wire_3154 = &"net240" @WIRE(mode="straight") {%p1115 #"I1041":5};
//   %p1124 = (352, -498);
//   %wire_3155 = &"net240" @WIRE(mode="straight") {%p1124 #"I1065":5};
//   %p1125 = (-20, -498);
//   %p1126 = (14, -498);
//   %wire_3156 = &"net240" @WIRE(mode="straight") {%p1125 %p1126};
//   %wire_3157 = &"net240" @WIRE(mode="straight") {%p1116 #"I1042":5};
//   %p1127 = (38, -498);
//   %wire_3158 = &"net240" @WIRE(mode="straight") {%p1127 %p1115};
//   %wire_3159 = &"net240" @WIRE(mode="straight") {%p1125 #"I1517":2};
//   %p1128 = (328, -498);
//   %wire_3160 = &"net240" @WIRE(mode="straight") {%p1128 %p1124};
//   %p1129 = (280, -498);
//   %p1130 = (304, -498);
//   %wire_3161 = &"net240" @WIRE(mode="straight") {%p1129 %p1130};
//   %wire_3162 = &"net240" @WIRE(mode="straight") {%p1118 #"I1049":5};
//   %p1131 = (124, -498);
//   %wire_3163 = &"net240" @WIRE(mode="straight") {%p1116 %p1131};
//   %wire_3164 = &"net240" @WIRE(mode="straight") {%p1128 #"I1066":5};
//   %wire_3165 = &"net240" @WIRE(mode="straight") {%p1124 %p1119};
//   %wire_3166 = &"net240" @WIRE(mode="straight") {%p1122 %p1117};
//   %wire_3167 = &"net240" @WIRE(mode="straight") {%p1126 #"I1039":5};
//   %wire_3168 = &"net240" @WIRE(mode="straight") {%p1122 #"I1051":5};
//   %wire_3169 = &"net240" @WIRE(mode="straight") {%p1121 #"I1052":5};
//   %wire_3170 = &"net240" @WIRE(mode="straight") {%p1123 #"I1053":5};
//   %wire_3171 = &"net240" @WIRE(mode="straight") {%p1118 %p1129};
//   %wire_3172 = &"net240" @WIRE(mode="straight") {%p1120 #"I1062":2};
//   %wire_3173 = &"net240" @WIRE(mode="straight") {%p1127 #"I1040":5};
//   %wire_3174 = &"net240" @WIRE(mode="straight") {%p1126 %p1127};
//   %wire_3175 = &"net240" @WIRE(mode="straight") {%p1130 %p1128};
//   %wire_3176 = &"net240" @WIRE(mode="straight") {%p1131 %p1123};
//   %wire_3177 = &"net240" @WIRE(mode="straight") {%p1131 #"I1054":5};
//   %wire_3178 = &"net240" @WIRE(mode="straight") {%p1120 #"I1063":5};
//   %wire_3179 = &"net240" @WIRE(mode="straight") {%p1129 #"I1068":5};
//   %wire_3180 = &"net240" @WIRE(mode="straight") {%p1119 #"I1064":5};
//   %wire_3181 = &"net240" @WIRE(mode="straight") {%p1130 #"I1067":5};
//   %p1132 = (168, -474);
//   %p1133 = (170, -474);
//   %wire_3182 = &"net241" @WIRE(mode="straight") {%p1132 %p1133};
//   %wire_3183 = &"net241" @WIRE(mode="straight") {#"I1052":6 %p1133};
//   %wire_3184 = &"net241" @WIRE(mode="straight") {#"I1052":3 %p1132};
//   %p1134 = (148, -474);
//   %wire_3185 = &"net241" @WIRE(mode="straight") {#"I1053":7 %p1134};
//   %wire_3186 = &"net241" @WIRE(mode="straight") {%p1134 %p1132};
//   %p1135 = (298, -470);
//   %p1136 = (322, -470);
//   %wire_3187 = &"net242" @WIRE(mode="straight") {%p1135 %p1136};
//   %p1137 = (166, -470);
//   %wire_3188 = &"net242" @WIRE(mode="straight") {#"I1052":9 %p1137};
//   %p1138 = (190, -470);
//   %wire_3189 = &"net242" @WIRE(mode="straight") {#"I1051":9 %p1138};
//   %p1139 = (8, -470);
//   %wire_3190 = &"net242" @WIRE(mode="straight") {#"I1039":9 %p1139};
//   %p1140 = (56, -470);
//   %p1141 = (80, -470);
//   %wire_3191 = &"net242" @WIRE(mode="straight") {%p1140 %p1141};
//   %wire_3192 = &"net242" @WIRE(mode="straight") {#"I1042":9 %p1141};
//   %wire_3193 = &"net242" @WIRE(mode="straight") {#"I1066":9 %p1136};
//   %p1142 = (10, -470);
//   %p1143 = (32, -470);
//   %wire_3194 = &"net242" @WIRE(mode="straight") {%p1142 %p1143};
//   %p1144 = (226, -470);
//   %wire_3195 = &"net242" @WIRE(mode="straight") {%p1138 %p1144};
//   %wire_3196 = &"net242" @WIRE(mode="straight") {#"I1050":9 %p1144};
//   %p1145 = (274, -470);
//   %wire_3197 = &"net242" @WIRE(mode="straight") {#"I1068":9 %p1145};
//   %p1146 = (250, -470);
//   %wire_3198 = &"net242" @WIRE(mode="straight") {%p1144 %p1146};
//   %p1147 = (346, -470);
//   %p1148 = (370, -470);
//   %wire_3199 = &"net242" @WIRE(mode="straight") {%p1147 %p1148};
//   %wire_3200 = &"net242" @WIRE(mode="straight") {%p1139 %p1142};
//   %p1149 = (118, -470);
//   %wire_3201 = &"net242" @WIRE(mode="straight") {%p1141 %p1149};
//   %wire_3202 = &"net242" @WIRE(mode="straight") {#"I1040":9 %p1143};
//   %p1150 = (142, -470);
//   %wire_3203 = &"net242" @WIRE(mode="straight") {#"I1053":9 %p1150};
//   %wire_3204 = &"net242" @WIRE(mode="straight") {#"I1039":3 %p1142};
//   %wire_3205 = &"net242" @WIRE(mode="straight") {#"I1054":9 %p1149};
//   %wire_3206 = &"net242" @WIRE(mode="straight") {%p1143 %p1140};
//   %wire_3207 = &"net242" @WIRE(mode="straight") {#"I1041":9 %p1140};
//   %wire_3208 = &"net242" @WIRE(mode="straight") {%p1136 %p1147};
//   %wire_3209 = &"net242" @WIRE(mode="straight") {#"I1065":9 %p1147};
//   %wire_3210 = &"net242" @WIRE(mode="straight") {%p1137 %p1138};
//   %wire_3211 = &"net242" @WIRE(mode="straight") {%p1150 %p1137};
//   %p1151 = (394, -470);
//   %wire_3212 = &"net242" @WIRE(mode="straight") {%p1148 %p1151};
//   %wire_3213 = &"net242" @WIRE(mode="straight") {#"I1049":9 %p1146};
//   %wire_3214 = &"net242" @WIRE(mode="straight") {%p1145 %p1135};
//   %wire_3215 = &"net242" @WIRE(mode="straight") {#"I1067":9 %p1135};
//   %wire_3216 = &"net242" @WIRE(mode="straight") {%p1146 %p1145};
//   %wire_3217 = &"net242" @WIRE(mode="straight") {#"I1063":9 %p1151};
//   %wire_3218 = &"net242" @WIRE(mode="straight") {%p1149 %p1150};
//   %wire_3219 = &"net242" @WIRE(mode="straight") {#"I1064":9 %p1148};
//   %p1152 = (252, -509);
//   %p1153 = (232, -507);
//   %wire_3220 = &"net188" @WIRE(mode="straight") {%p1152 %p1153};
//   %p1154 = (194, -509);
//   %wire_3221 = &"net188" @WIRE(mode="straight") {#"I1371":6 %p1154};
//   %wire_3222 = &"net188" @WIRE(mode="straight") {%p1154 %p1153};
//   %wire_3223 = &"net188" @WIRE(mode="straight") {#"I1367":3 %p1152};
//   %wire_3224 = &"net188" @WIRE(mode="straight") {#"I1372":7 %p1153};
//   %p1155 = (276, -509);
//   %wire_3225 = &"net194" @WIRE(mode="straight") {#"I1374":3 %p1155};
//   %p1156 = (230, -509);
//   %p1157 = (256, -507);
//   %wire_3226 = &"net194" @WIRE(mode="straight") {%p1156 %p1157};
//   %wire_3227 = &"net194" @WIRE(mode="straight") {#"I1372":6 %p1156};
//   %wire_3228 = &"net194" @WIRE(mode="straight") {#"I1367":7 %p1157};
//   %wire_3229 = &"net194" @WIRE(mode="straight") {%p1155 %p1157};
//   %p1158 = (118, -505);
//   %p1159 = (142, -505);
//   %wire_3230 = &"net196" @WIRE(mode="straight") {%p1158 %p1159};
//   %p1160 = (322, -505);
//   %p1161 = (346, -505);
//   %wire_3231 = &"net196" @WIRE(mode="straight") {%p1160 %p1161};
//   %p1162 = (32, -505);
//   %p1163 = (56, -505);
//   %wire_3232 = &"net196" @WIRE(mode="straight") {%p1162 %p1163};
//   %p1164 = (370, -505);
//   %wire_3233 = &"net196" @WIRE(mode="straight") {%p1161 %p1164};
//   %p1165 = (250, -505);
//   %p1166 = (274, -505);
//   %wire_3234 = &"net196" @WIRE(mode="straight") {%p1165 %p1166};
//   %p1167 = (298, -505);
//   %wire_3235 = &"net196" @WIRE(mode="straight") {%p1166 %p1167};
//   %wire_3236 = &"net196" @WIRE(mode="straight") {#"I1375":9 %p1167};
//   %wire_3237 = &"net196" @WIRE(mode="straight") {#"I1374":9 %p1166};
//   %wire_3238 = &"net196" @WIRE(mode="straight") {#"I1365":9 %p1162};
//   %p1168 = (8, -505);
//   %wire_3239 = &"net196" @WIRE(mode="straight") {#"I1366":9 %p1168};
//   %p1169 = (10, -505);
//   %wire_3240 = &"net196" @WIRE(mode="straight") {%p1168 %p1169};
//   %p1170 = (394, -505);
//   %wire_3241 = &"net196" @WIRE(mode="straight") {#"I1379":9 %p1170};
//   %p1171 = (166, -505);
//   %wire_3242 = &"net196" @WIRE(mode="straight") {%p1159 %p1171};
//   %wire_3243 = &"net196" @WIRE(mode="straight") {#"I1377":9 %p1161};
//   %wire_3244 = &"net196" @WIRE(mode="straight") {#"I1369":9 %p1159};
//   %wire_3245 = &"net196" @WIRE(mode="straight") {#"I1366":3 %p1169};
//   %p1172 = (190, -505);
//   %wire_3246 = &"net196" @WIRE(mode="straight") {%p1171 %p1172};
//   %p1173 = (80, -505);
//   %wire_3247 = &"net196" @WIRE(mode="straight") {%p1173 %p1158};
//   %wire_3248 = &"net196" @WIRE(mode="straight") {%p1164 %p1170};
//   %p1174 = (226, -505);
//   %wire_3249 = &"net196" @WIRE(mode="straight") {%p1172 %p1174};
//   %wire_3250 = &"net196" @WIRE(mode="straight") {#"I1371":9 %p1172};
//   %wire_3251 = &"net196" @WIRE(mode="straight") {%p1169 %p1162};
//   %wire_3252 = &"net196" @WIRE(mode="straight") {#"I1364":9 %p1163};
//   %wire_3253 = &"net196" @WIRE(mode="straight") {%p1167 %p1160};
//   %wire_3254 = &"net196" @WIRE(mode="straight") {#"I1376":9 %p1160};
//   %wire_3255 = &"net196" @WIRE(mode="straight") {%p1174 %p1165};
//   %wire_3256 = &"net196" @WIRE(mode="straight") {#"I1367":9 %p1165};
//   %wire_3257 = &"net196" @WIRE(mode="straight") {#"I1368":9 %p1158};
//   %wire_3258 = &"net196" @WIRE(mode="straight") {#"I1370":9 %p1171};
//   %wire_3259 = &"net196" @WIRE(mode="straight") {%p1163 %p1173};
//   %wire_3260 = &"net196" @WIRE(mode="straight") {#"I1363":9 %p1173};
//   %wire_3261 = &"net196" @WIRE(mode="straight") {#"I1378":9 %p1164};
//   %wire_3262 = &"net196" @WIRE(mode="straight") {#"I1372":9 %p1174};
//   %p1175 = (-6, -486);
//   %wire_3263 = &"net248" @WIRE(mode="straight") {#"I1512":1 %p1175};
//   %p1176 = (-26, -488);
//   %wire_3264 = &"net248" @WIRE(mode="straight") {#"I1516":2 %p1176};
//   %p1177 = (97, -486);
//   %wire_3265 = &"net248" @WIRE(mode="straight") {#"I1042":4 %p1177};
//   %wire_3266 = &"net248" @WIRE(mode="straight") {#"I1041":4 #"I1042":4};
//   %wire_3267 = &"net248" @WIRE(mode="straight") {#"I1039":4 #"I1040":4};
//   %p1178 = (97, -483);
//   %wire_3268 = &"net248" @WIRE(mode="straight") {%p1177 %p1178};
//   %wire_3269 = &"net248" @WIRE(mode="straight") {%p1175 #"I1039":4};
//   %wire_3270 = &"net248" @WIRE(mode="straight") {%p1175 #"M80":1};
//   %wire_3271 = &"net248" @WIRE(mode="straight") {%p1176 #"I1512":1};
//   %wire_3272 = &"net248" @WIRE(mode="straight") {%p1178 #"M143":3};
//   %wire_3273 = &"net248" @WIRE(mode="straight") {#"I1040":4 #"I1041":4};
//   %wire_3274 = &"net248" @WIRE(mode="straight") {#"M36":3 %p1177};
//   %p1179 = (97, -521);
//   %p1180 = (97, -518);
//   %wire_3275 = &"net251" @WIRE(mode="straight") {%p1179 %p1180};
//   %p1181 = (-18, -521);
//   %wire_3276 = &"net251" @WIRE(mode="straight") {#"I1511":1 %p1181};
//   %p1182 = (-26, -523);
//   %wire_3277 = &"net251" @WIRE(mode="straight") {%p1182 #"I1511":1};
//   %wire_3278 = &"net251" @WIRE(mode="straight") {#"I1365":4 #"I1364":4};
//   %wire_3279 = &"net251" @WIRE(mode="straight") {%p1181 #"I1366":4};
//   %wire_3280 = &"net251" @WIRE(mode="straight") {%p1180 #"M144":3};
//   %wire_3281 = &"net251" @WIRE(mode="straight") {#"I1363":4 %p1179};
//   %wire_3282 = &"net251" @WIRE(mode="straight") {#"M37":3 %p1179};
//   %wire_3283 = &"net251" @WIRE(mode="straight") {#"I1366":4 #"I1365":4};
//   %wire_3284 = &"net251" @WIRE(mode="straight") {%p1181 #"M79":1};
//   %wire_3285 = &"net251" @WIRE(mode="straight") {#"I1514":2 %p1182};
//   %wire_3286 = &"net251" @WIRE(mode="straight") {#"I1364":4 #"I1363":4};
//   %p1183 = (328, -404);
//   %p1184 = (348, -404);
//   %wire_3287 = &"net252" @WIRE(mode="straight") {%p1183 %p1184};
//   %p1185 = (350, -404);
//   %wire_3288 = &"net252" @WIRE(mode="straight") {#"I1025":6 %p1185};
//   %wire_3289 = &"net252" @WIRE(mode="straight") {%p1184 %p1185};
//   %wire_3290 = &"net252" @WIRE(mode="straight") {#"I1026":7 %p1183};
//   %wire_3291 = &"net252" @WIRE(mode="straight") {#"I1025":3 %p1184};
//   %p1186 = (352, -404);
//   %p1187 = (372, -404);
//   %wire_3292 = &"net253" @WIRE(mode="straight") {%p1186 %p1187};
//   %wire_3293 = &"net253" @WIRE(mode="straight") {#"I1025":7 %p1186};
//   %wire_3294 = &"net253" @WIRE(mode="straight") {#"I1024":3 %p1187};
//   %p1188 = (374, -404);
//   %wire_3295 = &"net253" @WIRE(mode="straight") {%p1187 %p1188};
//   %wire_3296 = &"net253" @WIRE(mode="straight") {#"I1024":6 %p1188};
//   %p1189 = (205, -273);
//   %wire_3297 = &"net254" @WIRE(mode="straight") {%p1189 #"M165":3};
//   %wire_3298 = &"net254" @WIRE(mode="straight") {#"I933":4 #"I932":4};
//   %wire_3299 = &"net254" @WIRE(mode="straight") {#"I934":4 #"I933":4};
//   %p1190 = (107, -279);
//   %p1191 = (107, -276);
//   %wire_3300 = &"net254" @WIRE(mode="straight") {%p1190 %p1191};
//   %p1192 = (205, -276);
//   %wire_3301 = &"net254" @WIRE(mode="straight") {#"I931":4 %p1192};
//   %wire_3302 = &"net254" @WIRE(mode="straight") {#"I932":4 #"I931":4};
//   %wire_3303 = &"net254" @WIRE(mode="straight") {%p1192 %p1189};
//   %wire_3304 = &"net254" @WIRE(mode="straight") {#"M58":3 %p1192};
//   %wire_3305 = &"net254" @WIRE(mode="straight") {%p1191 #"M137":1};
//   %wire_3306 = &"net254" @WIRE(mode="straight") {%p1191 #"I934":4};
//   %wire_3307 = &"net254" @WIRE(mode="straight") {#"M30":1 %p1190};
//   %p1193 = (252, -264);
//   %wire_3308 = &"net256" @WIRE(mode="straight") {#"I929":3 %p1193};
//   %p1194 = (254, -264);
//   %wire_3309 = &"net256" @WIRE(mode="straight") {#"I929":6 %p1194};
//   %p1195 = (232, -264);
//   %wire_3310 = &"net256" @WIRE(mode="straight") {%p1195 %p1193};
//   %wire_3311 = &"net256" @WIRE(mode="straight") {%p1193 %p1194};
//   %wire_3312 = &"net256" @WIRE(mode="straight") {#"I930":7 %p1195};
//   %p1196 = (215, -276);
//   %wire_3313 = &"net257" @WIRE(mode="straight") {%p1196 #"I930":4};
//   %p1197 = (215, -279);
//   %wire_3314 = &"net257" @WIRE(mode="straight") {%p1197 %p1196};
//   %wire_3315 = &"net257" @WIRE(mode="straight") {%p1196 #"M165":1};
//   %wire_3316 = &"net257" @WIRE(mode="straight") {#"M58":1 %p1197};
//   %wire_3317 = &"net257" @WIRE(mode="straight") {#"I930":4 #"I929":4};
//   %wire_3318 = &"net257" @WIRE(mode="straight") {#"I929":4 #"I948":4};
//   %wire_3319 = &"net257" @WIRE(mode="straight") {#"I947":4 #"I946":4};
//   %wire_3320 = &"net257" @WIRE(mode="straight") {#"I948":4 #"I947":4};
//   %wire_3321 = &"net257" @WIRE(mode="straight") {#"I945":4 #"I944":4};
//   %wire_3322 = &"net257" @WIRE(mode="straight") {#"I944":4 #"I943":4};
//   %wire_3323 = &"net257" @WIRE(mode="straight") {#"I946":4 #"I945":4};
//   %p1198 = (14, -288);
//   %wire_3324 = &"net258" @WIRE(mode="straight") {%p1198 #"I919":5};
//   %p1199 = (304, -288);
//   %p1200 = (328, -288);
//   %wire_3325 = &"net258" @WIRE(mode="straight") {%p1199 %p1200};
//   %p1201 = (352, -288);
//   %wire_3326 = &"net258" @WIRE(mode="straight") {%p1201 #"I945":5};
//   %p1202 = (196, -288);
//   %p1203 = (232, -288);
//   %wire_3327 = &"net258" @WIRE(mode="straight") {%p1202 %p1203};
//   %p1204 = (256, -288);
//   %wire_3328 = &"net258" @WIRE(mode="straight") {%p1204 #"I929":5};
//   %wire_3329 = &"net258" @WIRE(mode="straight") {%p1199 #"I947":5};
//   %p1205 = (280, -288);
//   %wire_3330 = &"net258" @WIRE(mode="straight") {%p1205 #"I948":5};
//   %wire_3331 = &"net258" @WIRE(mode="straight") {%p1203 %p1204};
//   %wire_3332 = &"net258" @WIRE(mode="straight") {%p1202 #"I931":5};
//   %p1206 = (172, -288);
//   %wire_3333 = &"net258" @WIRE(mode="straight") {%p1206 #"I932":5};
//   %p1207 = (62, -288);
//   %p1208 = (86, -288);
//   %wire_3334 = &"net258" @WIRE(mode="straight") {%p1207 %p1208};
//   %p1209 = (-20, -288);
//   %wire_3335 = &"net258" @WIRE(mode="straight") {%p1209 #"I1493":2};
//   %p1210 = (376, -288);
//   %p1211 = (400, -288);
//   %wire_3336 = &"net258" @WIRE(mode="straight") {%p1210 %p1211};
//   %wire_3337 = &"net258" @WIRE(mode="straight") {%p1201 %p1210};
//   %wire_3338 = &"net258" @WIRE(mode="straight") {%p1200 %p1201};
//   %wire_3339 = &"net258" @WIRE(mode="straight") {%p1209 %p1198};
//   %p1212 = (148, -288);
//   %wire_3340 = &"net258" @WIRE(mode="straight") {%p1212 %p1206};
//   %wire_3341 = &"net258" @WIRE(mode="straight") {%p1204 %p1205};
//   %wire_3342 = &"net258" @WIRE(mode="straight") {%p1210 #"I944":5};
//   %wire_3343 = &"net258" @WIRE(mode="straight") {%p1207 #"I921":5};
//   %p1213 = (124, -288);
//   %wire_3344 = &"net258" @WIRE(mode="straight") {%p1208 %p1213};
//   %wire_3345 = &"net258" @WIRE(mode="straight") {%p1213 #"I934":5};
//   %wire_3346 = &"net258" @WIRE(mode="straight") {%p1211 #"I942":2};
//   %wire_3347 = &"net258" @WIRE(mode="straight") {%p1205 %p1199};
//   %wire_3348 = &"net258" @WIRE(mode="straight") {%p1206 %p1202};
//   %p1214 = (38, -288);
//   %wire_3349 = &"net258" @WIRE(mode="straight") {%p1198 %p1214};
//   %wire_3350 = &"net258" @WIRE(mode="straight") {%p1208 #"I922":5};
//   %wire_3351 = &"net258" @WIRE(mode="straight") {%p1214 #"I920":5};
//   %wire_3352 = &"net258" @WIRE(mode="straight") {%p1213 %p1212};
//   %wire_3353 = &"net258" @WIRE(mode="straight") {%p1212 #"I933":5};
//   %wire_3354 = &"net258" @WIRE(mode="straight") {%p1214 %p1207};
//   %wire_3355 = &"net258" @WIRE(mode="straight") {%p1203 #"I930":5};
//   %wire_3356 = &"net258" @WIRE(mode="straight") {%p1211 #"I943":5};
//   %wire_3357 = &"net258" @WIRE(mode="straight") {%p1200 #"I946":5};
//   %p1215 = (276, -264);
//   %p1216 = (278, -264);
//   %wire_3358 = &"net259" @WIRE(mode="straight") {%p1215 %p1216};
//   %p1217 = (256, -264);
//   %wire_3359 = &"net259" @WIRE(mode="straight") {#"I929":7 %p1217};
//   %wire_3360 = &"net259" @WIRE(mode="straight") {#"I948":6 %p1216};
//   %wire_3361 = &"net259" @WIRE(mode="straight") {#"I948":3 %p1215};
//   %wire_3362 = &"net259" @WIRE(mode="straight") {%p1217 %p1215};
//   %p1218 = (142, -260);
//   %wire_3363 = &"net260" @WIRE(mode="straight") {#"I933":9 %p1218};
//   %p1219 = (226, -260);
//   %wire_3364 = &"net260" @WIRE(mode="straight") {#"I930":9 %p1219};
//   %p1220 = (56, -260);
//   %wire_3365 = &"net260" @WIRE(mode="straight") {#"I921":9 %p1220};
//   %p1221 = (10, -260);
//   %p1222 = (32, -260);
//   %wire_3366 = &"net260" @WIRE(mode="straight") {%p1221 %p1222};
//   %p1223 = (80, -260);
//   %p1224 = (118, -260);
//   %wire_3367 = &"net260" @WIRE(mode="straight") {%p1223 %p1224};
//   %wire_3368 = &"net260" @WIRE(mode="straight") {#"I919":3 %p1221};
//   %wire_3369 = &"net260" @WIRE(mode="straight") {#"I920":9 %p1222};
//   %p1225 = (346, -260);
//   %p1226 = (370, -260);
//   %wire_3370 = &"net260" @WIRE(mode="straight") {%p1225 %p1226};
//   %wire_3371 = &"net260" @WIRE(mode="straight") {#"I934":9 %p1224};
//   %p1227 = (166, -260);
//   %p1228 = (190, -260);
//   %wire_3372 = &"net260" @WIRE(mode="straight") {%p1227 %p1228};
//   %wire_3373 = &"net260" @WIRE(mode="straight") {#"I944":9 %p1226};
//   %p1229 = (322, -260);
//   %wire_3374 = &"net260" @WIRE(mode="straight") {%p1229 %p1225};
//   %p1230 = (298, -260);
//   %wire_3375 = &"net260" @WIRE(mode="straight") {%p1230 %p1229};
//   %wire_3376 = &"net260" @WIRE(mode="straight") {#"I945":9 %p1225};
//   %wire_3377 = &"net260" @WIRE(mode="straight") {%p1218 %p1227};
//   %p1231 = (394, -260);
//   %wire_3378 = &"net260" @WIRE(mode="straight") {%p1226 %p1231};
//   %p1232 = (250, -260);
//   %p1233 = (274, -260);
//   %wire_3379 = &"net260" @WIRE(mode="straight") {%p1232 %p1233};
//   %wire_3380 = &"net260" @WIRE(mode="straight") {%p1228 %p1219};
//   %p1234 = (8, -260);
//   %wire_3381 = &"net260" @WIRE(mode="straight") {#"I919":9 %p1234};
//   %wire_3382 = &"net260" @WIRE(mode="straight") {#"I922":9 %p1223};
//   %wire_3383 = &"net260" @WIRE(mode="straight") {#"I943":9 %p1231};
//   %wire_3384 = &"net260" @WIRE(mode="straight") {%p1234 %p1221};
//   %wire_3385 = &"net260" @WIRE(mode="straight") {#"I946":9 %p1229};
//   %wire_3386 = &"net260" @WIRE(mode="straight") {%p1222 %p1220};
//   %wire_3387 = &"net260" @WIRE(mode="straight") {%p1233 %p1230};
//   %wire_3388 = &"net260" @WIRE(mode="straight") {#"I947":9 %p1230};
//   %wire_3389 = &"net260" @WIRE(mode="straight") {#"I948":9 %p1233};
//   %wire_3390 = &"net260" @WIRE(mode="straight") {%p1219 %p1232};
//   %wire_3391 = &"net260" @WIRE(mode="straight") {#"I931":9 %p1228};
//   %wire_3392 = &"net260" @WIRE(mode="straight") {#"I929":9 %p1232};
//   %wire_3393 = &"net260" @WIRE(mode="straight") {#"I932":9 %p1227};
//   %wire_3394 = &"net260" @WIRE(mode="straight") {%p1224 %p1218};
//   %wire_3395 = &"net260" @WIRE(mode="straight") {%p1220 %p1223};
//   %p1235 = (120, -649);
//   %wire_3396 = &"net197" @WIRE(mode="straight") {#"I1402":3 %p1235};
//   %p1236 = (60, -649);
//   %p1237 = (86, -647);
//   %wire_3397 = &"net197" @WIRE(mode="straight") {%p1236 %p1237};
//   %wire_3398 = &"net197" @WIRE(mode="straight") {#"I1397":7 %p1237};
//   %wire_3399 = &"net197" @WIRE(mode="straight") {%p1235 %p1237};
//   %wire_3400 = &"net197" @WIRE(mode="straight") {#"I1398":6 %p1236};
//   %p1238 = (-4, -297);
//   %p1239 = (14, -297);
//   %wire_3401 = &"net262" @WIRE(mode="straight") {%p1238 %p1239};
//   %wire_3402 = &"net262" @WIRE(mode="straight") {#"I1486":1 %p1238};
//   %wire_3403 = &"net262" @WIRE(mode="straight") {#"I1315":7 %p1239};
//   %p1240 = (34, -299);
//   %wire_3404 = &"net262" @WIRE(mode="straight") {#"I1314":3 %p1240};
//   %wire_3405 = &"net262" @WIRE(mode="straight") {%p1240 %p1239};
//   %p1241 = (14, -264);
//   %p1242 = (34, -264);
//   %wire_3406 = &"net263" @WIRE(mode="straight") {%p1241 %p1242};
//   %p1243 = (36, -264);
//   %wire_3407 = &"net263" @WIRE(mode="straight") {#"I920":6 %p1243};
//   %wire_3408 = &"net263" @WIRE(mode="straight") {#"I919":7 %p1241};
//   %wire_3409 = &"net263" @WIRE(mode="straight") {#"I920":3 %p1242};
//   %wire_3410 = &"net263" @WIRE(mode="straight") {%p1242 %p1243};
//   %p1244 = (326, -614);
//   %wire_3411 = &"net264" @WIRE(mode="straight") {#"I1146":6 %p1244};
//   %p1245 = (324, -614);
//   %wire_3412 = &"net264" @WIRE(mode="straight") {%p1245 %p1244};
//   %wire_3413 = &"net264" @WIRE(mode="straight") {#"I1146":3 %p1245};
//   %p1246 = (304, -614);
//   %wire_3414 = &"net264" @WIRE(mode="straight") {%p1246 %p1245};
//   %wire_3415 = &"net264" @WIRE(mode="straight") {#"I1147":7 %p1246};
//   %p1247 = (-4, -673);
//   %p1248 = (14, -673);
//   %wire_3416 = &"net198" @WIRE(mode="straight") {%p1247 %p1248};
//   %wire_3417 = &"net198" @WIRE(mode="straight") {%p1247 #"I1526":2};
//   %p1249 = (124, -673);
//   %p1250 = (148, -673);
//   %wire_3418 = &"net198" @WIRE(mode="straight") {%p1249 %p1250};
//   %p1251 = (304, -673);
//   %p1252 = (328, -673);
//   %wire_3419 = &"net198" @WIRE(mode="straight") {%p1251 %p1252};
//   %p1253 = (232, -673);
//   %wire_3420 = &"net198" @WIRE(mode="straight") {%p1253 #"I1406":5};
//   %p1254 = (38, -673);
//   %wire_3421 = &"net198" @WIRE(mode="straight") {%p1248 %p1254};
//   %p1255 = (172, -673);
//   %p1256 = (196, -673);
//   %wire_3422 = &"net198" @WIRE(mode="straight") {%p1255 %p1256};
//   %wire_3423 = &"net198" @WIRE(mode="straight") {%p1248 #"I1400":5};
//   %p1257 = (376, -673);
//   %wire_3424 = &"net198" @WIRE(mode="straight") {%p1257 #"I1412":5};
//   %wire_3425 = &"net198" @WIRE(mode="straight") {%p1250 #"I1403":5};
//   %p1258 = (86, -673);
//   %wire_3426 = &"net198" @WIRE(mode="straight") {%p1258 %p1249};
//   %wire_3427 = &"net198" @WIRE(mode="straight") {%p1249 #"I1402":5};
//   %p1259 = (62, -673);
//   %wire_3428 = &"net198" @WIRE(mode="straight") {%p1259 %p1258};
//   %p1260 = (400, -673);
//   %wire_3429 = &"net198" @WIRE(mode="straight") {%p1260 #"I1413":5};
//   %wire_3430 = &"net198" @WIRE(mode="straight") {%p1256 %p1253};
//   %wire_3431 = &"net198" @WIRE(mode="straight") {%p1260 #"I1407":2};
//   %wire_3432 = &"net198" @WIRE(mode="straight") {%p1259 #"I1398":5};
//   %wire_3433 = &"net198" @WIRE(mode="straight") {%p1258 #"I1397":5};
//   %wire_3434 = &"net198" @WIRE(mode="straight") {%p1252 #"I1410":5};
//   %wire_3435 = &"net198" @WIRE(mode="straight") {%p1257 %p1260};
//   %wire_3436 = &"net198" @WIRE(mode="straight") {%p1251 #"I1409":5};
//   %wire_3437 = &"net198" @WIRE(mode="straight") {%p1250 %p1255};
//   %p1261 = (256, -673);
//   %wire_3438 = &"net198" @WIRE(mode="straight") {%p1253 %p1261};
//   %p1262 = (280, -673);
//   %wire_3439 = &"net198" @WIRE(mode="straight") {%p1262 #"I1408":5};
//   %wire_3440 = &"net198" @WIRE(mode="straight") {%p1254 %p1259};
//   %wire_3441 = &"net198" @WIRE(mode="straight") {%p1262 %p1251};
//   %wire_3442 = &"net198" @WIRE(mode="straight") {%p1261 %p1262};
//   %wire_3443 = &"net198" @WIRE(mode="straight") {%p1255 #"I1404":5};
//   %wire_3444 = &"net198" @WIRE(mode="straight") {%p1261 #"I1401":5};
//   %p1263 = (352, -673);
//   %wire_3445 = &"net198" @WIRE(mode="straight") {%p1263 %p1257};
//   %wire_3446 = &"net198" @WIRE(mode="straight") {%p1263 #"I1411":5};
//   %wire_3447 = &"net198" @WIRE(mode="straight") {%p1252 %p1263};
//   %wire_3448 = &"net198" @WIRE(mode="straight") {%p1256 #"I1405":5};
//   %wire_3449 = &"net198" @WIRE(mode="straight") {%p1254 #"I1399":5};
//   %p1264 = (230, -614);
//   %wire_3450 = &"net267" @WIRE(mode="straight") {#"I1130":6 %p1264};
//   %p1265 = (228, -614);
//   %wire_3451 = &"net267" @WIRE(mode="straight") {%p1265 %p1264};
//   %wire_3452 = &"net267" @WIRE(mode="straight") {#"I1130":3 %p1265};
//   %p1266 = (196, -614);
//   %wire_3453 = &"net267" @WIRE(mode="straight") {%p1266 %p1265};
//   %wire_3454 = &"net267" @WIRE(mode="straight") {#"I1131":7 %p1266};
//   %p1267 = (12, -649);
//   %wire_3455 = &"net201" @WIRE(mode="straight") {#"I1400":6 %p1267};
//   %p1268 = (38, -647);
//   %wire_3456 = &"net201" @WIRE(mode="straight") {%p1267 %p1268};
//   %wire_3457 = &"net201" @WIRE(mode="straight") {#"I1399":7 %p1268};
//   %p1269 = (58, -649);
//   %wire_3458 = &"net201" @WIRE(mode="straight") {%p1269 %p1268};
//   %wire_3459 = &"net201" @WIRE(mode="straight") {#"I1398":3 %p1269};
//   %p1270 = (60, -614);
//   %wire_3460 = &"net269" @WIRE(mode="straight") {#"I1121":6 %p1270};
//   %p1271 = (58, -614);
//   %wire_3461 = &"net269" @WIRE(mode="straight") {%p1271 %p1270};
//   %wire_3462 = &"net269" @WIRE(mode="straight") {#"I1121":3 %p1271};
//   %p1272 = (38, -614);
//   %wire_3463 = &"net269" @WIRE(mode="straight") {%p1272 %p1271};
//   %wire_3464 = &"net269" @WIRE(mode="straight") {#"I1120":7 %p1272};
//   %p1273 = (62, -647);
//   %wire_3465 = &"net202" @WIRE(mode="straight") {#"I1398":7 %p1273};
//   %p1274 = (82, -649);
//   %wire_3466 = &"net202" @WIRE(mode="straight") {%p1274 %p1273};
//   %wire_3467 = &"net202" @WIRE(mode="straight") {#"I1397":3 %p1274};
//   %p1275 = (36, -649);
//   %wire_3468 = &"net202" @WIRE(mode="straight") {%p1275 %p1273};
//   %wire_3469 = &"net202" @WIRE(mode="straight") {#"I1399":6 %p1275};
//   %p1276 = (122, -474);
//   %wire_3470 = &"net271" @WIRE(mode="straight") {#"I1054":6 %p1276};
//   %p1277 = (86, -474);
//   %wire_3471 = &"net271" @WIRE(mode="straight") {#"I1042":7 %p1277};
//   %p1278 = (120, -474);
//   %wire_3472 = &"net271" @WIRE(mode="straight") {#"I1054":3 %p1278};
//   %wire_3473 = &"net271" @WIRE(mode="straight") {%p1277 %p1278};
//   %wire_3474 = &"net271" @WIRE(mode="straight") {%p1278 %p1276};
//   %p1279 = (10, -645);
//   %wire_3475 = &"net203" @WIRE(mode="straight") {#"I1400":3 %p1279};
//   %p1280 = (166, -645);
//   %wire_3476 = &"net203" @WIRE(mode="straight") {#"I1404":9 %p1280};
//   %p1281 = (142, -645);
//   %wire_3477 = &"net203" @WIRE(mode="straight") {%p1281 %p1280};
//   %p1282 = (8, -645);
//   %wire_3478 = &"net203" @WIRE(mode="straight") {%p1282 %p1279};
//   %p1283 = (56, -645);
//   %p1284 = (80, -645);
//   %wire_3479 = &"net203" @WIRE(mode="straight") {%p1283 %p1284};
//   %wire_3480 = &"net203" @WIRE(mode="straight") {#"I1403":9 %p1281};
//   %p1285 = (298, -645);
//   %wire_3481 = &"net203" @WIRE(mode="straight") {#"I1409":9 %p1285};
//   %p1286 = (32, -645);
//   %wire_3482 = &"net203" @WIRE(mode="straight") {%p1286 %p1283};
//   %p1287 = (226, -645);
//   %p1288 = (250, -645);
//   %wire_3483 = &"net203" @WIRE(mode="straight") {%p1287 %p1288};
//   %p1289 = (322, -645);
//   %p1290 = (346, -645);
//   %wire_3484 = &"net203" @WIRE(mode="straight") {%p1289 %p1290};
//   %p1291 = (118, -645);
//   %wire_3485 = &"net203" @WIRE(mode="straight") {#"I1402":9 %p1291};
//   %p1292 = (370, -645);
//   %wire_3486 = &"net203" @WIRE(mode="straight") {%p1290 %p1292};
//   %wire_3487 = &"net203" @WIRE(mode="straight") {%p1285 %p1289};
//   %p1293 = (274, -645);
//   %wire_3488 = &"net203" @WIRE(mode="straight") {%p1293 %p1285};
//   %wire_3489 = &"net203" @WIRE(mode="straight") {#"I1406":9 %p1287};
//   %p1294 = (190, -645);
//   %wire_3490 = &"net203" @WIRE(mode="straight") {%p1294 %p1287};
//   %wire_3491 = &"net203" @WIRE(mode="straight") {%p1279 %p1286};
//   %wire_3492 = &"net203" @WIRE(mode="straight") {%p1284 %p1291};
//   %wire_3493 = &"net203" @WIRE(mode="straight") {%p1288 %p1293};
//   %wire_3494 = &"net203" @WIRE(mode="straight") {#"I1400":9 %p1282};
//   %wire_3495 = &"net203" @WIRE(mode="straight") {#"I1397":9 %p1284};
//   %wire_3496 = &"net203" @WIRE(mode="straight") {#"I1408":9 %p1293};
//   %wire_3497 = &"net203" @WIRE(mode="straight") {#"I1401":9 %p1288};
//   %wire_3498 = &"net203" @WIRE(mode="straight") {#"I1411":9 %p1290};
//   %wire_3499 = &"net203" @WIRE(mode="straight") {#"I1410":9 %p1289};
//   %wire_3500 = &"net203" @WIRE(mode="straight") {#"I1398":9 %p1283};
//   %wire_3501 = &"net203" @WIRE(mode="straight") {%p1280 %p1294};
//   %wire_3502 = &"net203" @WIRE(mode="straight") {#"I1412":9 %p1292};
//   %wire_3503 = &"net203" @WIRE(mode="straight") {#"I1399":9 %p1286};
//   %wire_3504 = &"net203" @WIRE(mode="straight") {#"I1405":9 %p1294};
//   %p1295 = (394, -645);
//   %wire_3505 = &"net203" @WIRE(mode="straight") {#"I1413":9 %p1295};
//   %wire_3506 = &"net203" @WIRE(mode="straight") {%p1292 %p1295};
//   %wire_3507 = &"net203" @WIRE(mode="straight") {%p1291 %p1281};
//   %p1296 = (302, -579);
//   %p1297 = (328, -577);
//   %wire_3508 = &"net208" @WIRE(mode="straight") {%p1296 %p1297};
//   %p1298 = (348, -579);
//   %wire_3509 = &"net208" @WIRE(mode="straight") {#"I1394":3 %p1298};
//   %wire_3510 = &"net208" @WIRE(mode="straight") {#"I1393":7 %p1297};
//   %wire_3511 = &"net208" @WIRE(mode="straight") {%p1298 %p1297};
//   %wire_3512 = &"net208" @WIRE(mode="straight") {#"I1392":6 %p1296};
//   %p1299 = (326, -264);
//   %wire_3513 = &"net275" @WIRE(mode="straight") {#"I946":6 %p1299};
//   %p1300 = (324, -264);
//   %wire_3514 = &"net275" @WIRE(mode="straight") {%p1300 %p1299};
//   %wire_3515 = &"net275" @WIRE(mode="straight") {#"I946":3 %p1300};
//   %p1301 = (304, -264);
//   %wire_3516 = &"net275" @WIRE(mode="straight") {%p1301 %p1300};
//   %wire_3517 = &"net275" @WIRE(mode="straight") {#"I947":7 %p1301};
//   %p1302 = (328, -264);
//   %wire_3518 = &"net276" @WIRE(mode="straight") {#"I946":7 %p1302};
//   %p1303 = (350, -264);
//   %wire_3519 = &"net276" @WIRE(mode="straight") {#"I945":6 %p1303};
//   %p1304 = (348, -264);
//   %wire_3520 = &"net276" @WIRE(mode="straight") {#"I945":3 %p1304};
//   %wire_3521 = &"net276" @WIRE(mode="straight") {%p1302 %p1304};
//   %wire_3522 = &"net276" @WIRE(mode="straight") {%p1304 %p1303};
//   %p1305 = (278, -579);
//   %wire_3523 = &"net210" @WIRE(mode="straight") {#"I1391":6 %p1305};
//   %p1306 = (304, -577);
//   %wire_3524 = &"net210" @WIRE(mode="straight") {%p1305 %p1306};
//   %p1307 = (324, -579);
//   %wire_3525 = &"net210" @WIRE(mode="straight") {%p1307 %p1306};
//   %wire_3526 = &"net210" @WIRE(mode="straight") {#"I1393":3 %p1307};
//   %wire_3527 = &"net210" @WIRE(mode="straight") {#"I1392":7 %p1306};
//   %p1308 = (205, -591);
//   %p1309 = (205, -588);
//   %wire_3528 = &"net211" @WIRE(mode="straight") {%p1308 %p1309};
//   %wire_3529 = &"net211" @WIRE(mode="straight") {#"M48":3 %p1308};
//   %wire_3530 = &"net211" @WIRE(mode="straight") {%p1309 #"M156":3};
//   %wire_3531 = &"net211" @WIRE(mode="straight") {#"I1386":4 #"I1387":4};
//   %wire_3532 = &"net211" @WIRE(mode="straight") {#"I1385":4 #"I1386":4};
//   %p1310 = (107, -594);
//   %wire_3533 = &"net211" @WIRE(mode="straight") {#"M39":1 %p1310};
//   %p1311 = (107, -591);
//   %wire_3534 = &"net211" @WIRE(mode="straight") {%p1310 %p1311};
//   %wire_3535 = &"net211" @WIRE(mode="straight") {%p1311 #"M146":1};
//   %wire_3536 = &"net211" @WIRE(mode="straight") {#"I1388":4 %p1308};
//   %wire_3537 = &"net211" @WIRE(mode="straight") {%p1311 #"I1385":4};
//   %wire_3538 = &"net211" @WIRE(mode="straight") {#"I1387":4 #"I1388":4};
//   %p1312 = (122, -579);
//   %p1313 = (148, -577);
//   %wire_3539 = &"net212" @WIRE(mode="straight") {%p1312 %p1313};
//   %wire_3540 = &"net212" @WIRE(mode="straight") {#"I1385":6 %p1312};
//   %wire_3541 = &"net212" @WIRE(mode="straight") {#"I1386":7 %p1313};
//   %p1314 = (168, -579);
//   %wire_3542 = &"net212" @WIRE(mode="straight") {%p1314 %p1313};
//   %wire_3543 = &"net212" @WIRE(mode="straight") {#"I1387":3 %p1314};
//   %p1315 = (228, -264);
//   %wire_3544 = &"net281" @WIRE(mode="straight") {#"I930":3 %p1315};
//   %p1316 = (230, -264);
//   %wire_3545 = &"net281" @WIRE(mode="straight") {#"I930":6 %p1316};
//   %p1317 = (196, -264);
//   %wire_3546 = &"net281" @WIRE(mode="straight") {#"I931":7 %p1317};
//   %wire_3547 = &"net281" @WIRE(mode="straight") {%p1315 %p1316};
//   %wire_3548 = &"net281" @WIRE(mode="straight") {%p1317 %p1315};
//   %p1318 = (86, -577);
//   %wire_3549 = &"net220" @WIRE(mode="straight") {#"I1380":7 %p1318};
//   %p1319 = (60, -579);
//   %wire_3550 = &"net220" @WIRE(mode="straight") {#"I1381":6 %p1319};
//   %wire_3551 = &"net220" @WIRE(mode="straight") {%p1319 %p1318};
//   %p1320 = (120, -579);
//   %wire_3552 = &"net220" @WIRE(mode="straight") {#"I1385":3 %p1320};
//   %wire_3553 = &"net220" @WIRE(mode="straight") {%p1320 %p1318};
//   %p1321 = (58, -264);
//   %p1322 = (60, -264);
//   %wire_3554 = &"net283" @WIRE(mode="straight") {%p1321 %p1322};
//   %wire_3555 = &"net283" @WIRE(mode="straight") {#"I921":6 %p1322};
//   %p1323 = (38, -264);
//   %wire_3556 = &"net283" @WIRE(mode="straight") {%p1323 %p1321};
//   %wire_3557 = &"net283" @WIRE(mode="straight") {#"I921":3 %p1321};
//   %wire_3558 = &"net283" @WIRE(mode="straight") {#"I920":7 %p1323};
//   %p1324 = (302, -614);
//   %wire_3559 = &"net284" @WIRE(mode="straight") {#"I1147":6 %p1324};
//   %p1325 = (300, -614);
//   %wire_3560 = &"net284" @WIRE(mode="straight") {%p1325 %p1324};
//   %wire_3561 = &"net284" @WIRE(mode="straight") {#"I1147":3 %p1325};
//   %p1326 = (280, -614);
//   %wire_3562 = &"net284" @WIRE(mode="straight") {%p1326 %p1325};
//   %wire_3563 = &"net284" @WIRE(mode="straight") {#"I1148":7 %p1326};
//   %p1327 = (124, -577);
//   %wire_3564 = &"net221" @WIRE(mode="straight") {#"I1385":7 %p1327};
//   %p1328 = (144, -579);
//   %wire_3565 = &"net221" @WIRE(mode="straight") {#"I1386":3 %p1328};
//   %p1329 = (84, -579);
//   %wire_3566 = &"net221" @WIRE(mode="straight") {#"I1380":6 %p1329};
//   %wire_3567 = &"net221" @WIRE(mode="straight") {%p1327 %p1329};
//   %wire_3568 = &"net221" @WIRE(mode="straight") {%p1328 %p1327};
//   %wire_3569 = &"net451" @WIRE(mode="straight") {#"I1514":1 #"I1511":2};
//   %p1330 = (194, -614);
//   %wire_3570 = &"net287" @WIRE(mode="straight") {#"I1131":6 %p1330};
//   %p1331 = (192, -614);
//   %wire_3571 = &"net287" @WIRE(mode="straight") {%p1331 %p1330};
//   %wire_3572 = &"net287" @WIRE(mode="straight") {#"I1131":3 %p1331};
//   %p1332 = (172, -614);
//   %wire_3573 = &"net287" @WIRE(mode="straight") {%p1332 %p1331};
//   %wire_3574 = &"net287" @WIRE(mode="straight") {#"I1132":7 %p1332};
//   %p1333 = (170, -509);
//   %wire_3575 = &"net222" @WIRE(mode="straight") {#"I1370":6 %p1333};
//   %p1334 = (228, -509);
//   %p1335 = (196, -507);
//   %wire_3576 = &"net222" @WIRE(mode="straight") {%p1334 %p1335};
//   %wire_3577 = &"net222" @WIRE(mode="straight") {#"I1372":3 %p1334};
//   %wire_3578 = &"net222" @WIRE(mode="straight") {#"I1371":7 %p1335};
//   %wire_3579 = &"net222" @WIRE(mode="straight") {%p1333 %p1335};
//   %p1336 = (84, -614);
//   %wire_3580 = &"net289" @WIRE(mode="straight") {#"I1122":6 %p1336};
//   %p1337 = (82, -614);
//   %wire_3581 = &"net289" @WIRE(mode="straight") {%p1337 %p1336};
//   %wire_3582 = &"net289" @WIRE(mode="straight") {#"I1122":3 %p1337};
//   %p1338 = (62, -614);
//   %wire_3583 = &"net289" @WIRE(mode="straight") {%p1338 %p1337};
//   %wire_3584 = &"net289" @WIRE(mode="straight") {#"I1121":7 %p1338};
//   %p1339 = (205, -521);
//   %p1340 = (205, -518);
//   %wire_3585 = &"net225" @WIRE(mode="straight") {%p1339 %p1340};
//   %wire_3586 = &"net225" @WIRE(mode="straight") {#"M51":3 %p1339};
//   %wire_3587 = &"net225" @WIRE(mode="straight") {%p1340 #"M158":3};
//   %wire_3588 = &"net225" @WIRE(mode="straight") {#"I1369":4 #"I1370":4};
//   %p1341 = (107, -524);
//   %wire_3589 = &"net225" @WIRE(mode="straight") {#"M37":1 %p1341};
//   %wire_3590 = &"net225" @WIRE(mode="straight") {#"I1370":4 #"I1371":4};
//   %wire_3591 = &"net225" @WIRE(mode="straight") {#"I1371":4 %p1339};
//   %p1342 = (107, -521);
//   %wire_3592 = &"net225" @WIRE(mode="straight") {%p1342 #"M144":1};
//   %wire_3593 = &"net225" @WIRE(mode="straight") {%p1342 #"I1368":4};
//   %wire_3594 = &"net225" @WIRE(mode="straight") {%p1341 %p1342};
//   %wire_3595 = &"net225" @WIRE(mode="straight") {#"I1368":4 #"I1369":4};
//   %p1343 = (232, -474);
//   %p1344 = (252, -474);
//   %wire_3596 = &"net292" @WIRE(mode="straight") {%p1343 %p1344};
//   %wire_3597 = &"net292" @WIRE(mode="straight") {#"I1050":7 %p1343};
//   %wire_3598 = &"net292" @WIRE(mode="straight") {#"I1049":3 %p1344};
//   %p1345 = (254, -474);
//   %wire_3599 = &"net292" @WIRE(mode="straight") {%p1344 %p1345};
//   %wire_3600 = &"net292" @WIRE(mode="straight") {#"I1049":6 %p1345};
//   %p1346 = (215, -486);
//   %wire_3601 = &"net293" @WIRE(mode="straight") {%p1346 #"I1050":4};
//   %p1347 = (215, -489);
//   %wire_3602 = &"net293" @WIRE(mode="straight") {%p1347 %p1346};
//   %wire_3603 = &"net293" @WIRE(mode="straight") {%p1346 #"M159":1};
//   %wire_3604 = &"net293" @WIRE(mode="straight") {#"M52":1 %p1347};
//   %wire_3605 = &"net293" @WIRE(mode="straight") {#"I1067":4 #"I1066":4};
//   %wire_3606 = &"net293" @WIRE(mode="straight") {#"I1049":4 #"I1068":4};
//   %wire_3607 = &"net293" @WIRE(mode="straight") {#"I1050":4 #"I1049":4};
//   %wire_3608 = &"net293" @WIRE(mode="straight") {#"I1068":4 #"I1067":4};
//   %wire_3609 = &"net293" @WIRE(mode="straight") {#"I1064":4 #"I1063":4};
//   %wire_3610 = &"net293" @WIRE(mode="straight") {#"I1066":4 #"I1065":4};
//   %wire_3611 = &"net293" @WIRE(mode="straight") {#"I1065":4 #"I1064":4};
//   %p1348 = (276, -474);
//   %p1349 = (278, -474);
//   %wire_3612 = &"net294" @WIRE(mode="straight") {%p1348 %p1349};
//   %wire_3613 = &"net294" @WIRE(mode="straight") {#"I1068":6 %p1349};
//   %p1350 = (256, -474);
//   %wire_3614 = &"net294" @WIRE(mode="straight") {#"I1049":7 %p1350};
//   %wire_3615 = &"net294" @WIRE(mode="straight") {%p1350 %p1348};
//   %wire_3616 = &"net294" @WIRE(mode="straight") {#"I1068":3 %p1348};
//   %p1351 = (148, -507);
//   %wire_3617 = &"net228" @WIRE(mode="straight") {#"I1369":7 %p1351};
//   %p1352 = (122, -509);
//   %wire_3618 = &"net228" @WIRE(mode="straight") {#"I1368":6 %p1352};
//   %wire_3619 = &"net228" @WIRE(mode="straight") {%p1352 %p1351};
//   %p1353 = (168, -509);
//   %wire_3620 = &"net228" @WIRE(mode="straight") {#"I1370":3 %p1353};
//   %wire_3621 = &"net228" @WIRE(mode="straight") {%p1353 %p1351};
//   %p1354 = (97, -378);
//   %wire_3622 = &"net298" @WIRE(mode="straight") {%p1354 #"M140":3};
//   %p1355 = (-18, -381);
//   %wire_3623 = &"net298" @WIRE(mode="straight") {%p1355 #"M75":1};
//   %p1356 = (97, -381);
//   %wire_3624 = &"net298" @WIRE(mode="straight") {%p1356 %p1354};
//   %wire_3625 = &"net298" @WIRE(mode="straight") {#"I1329":4 %p1356};
//   %wire_3626 = &"net298" @WIRE(mode="straight") {%p1355 #"I1332":4};
//   %wire_3627 = &"net298" @WIRE(mode="straight") {#"M33":3 %p1356};
//   %wire_3628 = &"net298" @WIRE(mode="straight") {#"I1495":1 %p1355};
//   %wire_3629 = &"net298" @WIRE(mode="straight") {#"I1332":4 #"I1331":4};
//   %wire_3630 = &"net298" @WIRE(mode="straight") {#"I1330":4 #"I1329":4};
//   %p1357 = (-26, -383);
//   %wire_3631 = &"net298" @WIRE(mode="straight") {%p1357 #"I1495":1};
//   %wire_3632 = &"net298" @WIRE(mode="straight") {#"I1498":2 %p1357};
//   %wire_3633 = &"net298" @WIRE(mode="straight") {#"I1331":4 #"I1330":4};
//   %p1358 = (192, -509);
//   %p1359 = (172, -507);
//   %wire_3634 = &"net229" @WIRE(mode="straight") {%p1358 %p1359};
//   %p1360 = (146, -509);
//   %wire_3635 = &"net229" @WIRE(mode="straight") {#"I1369":6 %p1360};
//   %wire_3636 = &"net229" @WIRE(mode="straight") {%p1360 %p1359};
//   %wire_3637 = &"net229" @WIRE(mode="straight") {#"I1370":7 %p1359};
//   %wire_3638 = &"net229" @WIRE(mode="straight") {#"I1371":3 %p1358};
//   %p1361 = (278, -159);
//   %p1362 = (304, -157);
//   %wire_3639 = &"net230" @WIRE(mode="straight") {%p1361 %p1362};
//   %p1363 = (324, -159);
//   %wire_3640 = &"net230" @WIRE(mode="straight") {#"I1291":3 %p1363};
//   %wire_3641 = &"net230" @WIRE(mode="straight") {%p1363 %p1362};
//   %wire_3642 = &"net230" @WIRE(mode="straight") {#"I1290":7 %p1362};
//   %wire_3643 = &"net230" @WIRE(mode="straight") {#"I1289":6 %p1361};
//   %p1364 = (215, -171);
//   %wire_3644 = &"net233" @WIRE(mode="straight") {%p1364 #"I1287":4};
//   %p1365 = (215, -174);
//   %wire_3645 = &"net233" @WIRE(mode="straight") {%p1365 %p1364};
//   %wire_3646 = &"net233" @WIRE(mode="straight") {%p1364 #"M162":1};
//   %wire_3647 = &"net233" @WIRE(mode="straight") {#"M61":1 %p1365};
//   %wire_3648 = &"net233" @WIRE(mode="straight") {#"I1293":4 #"I1294":4};
//   %wire_3649 = &"net233" @WIRE(mode="straight") {#"I1292":4 #"I1293":4};
//   %wire_3650 = &"net233" @WIRE(mode="straight") {#"I1291":4 #"I1292":4};
//   %wire_3651 = &"net233" @WIRE(mode="straight") {#"I1290":4 #"I1291":4};
//   %wire_3652 = &"net233" @WIRE(mode="straight") {#"I1289":4 #"I1290":4};
//   %wire_3653 = &"net233" @WIRE(mode="straight") {#"I1282":4 #"I1289":4};
//   %wire_3654 = &"net233" @WIRE(mode="straight") {#"I1287":4 #"I1282":4};
//   %p1366 = (302, -264);
//   %wire_3655 = &"net302" @WIRE(mode="straight") {#"I947":6 %p1366};
//   %p1367 = (280, -264);
//   %wire_3656 = &"net302" @WIRE(mode="straight") {#"I948":7 %p1367};
//   %p1368 = (300, -264);
//   %wire_3657 = &"net302" @WIRE(mode="straight") {%p1367 %p1368};
//   %wire_3658 = &"net302" @WIRE(mode="straight") {#"I947":3 %p1368};
//   %wire_3659 = &"net302" @WIRE(mode="straight") {%p1368 %p1366};
//   %p1369 = (276, -159);
//   %p1370 = (256, -157);
//   %wire_3660 = &"net234" @WIRE(mode="straight") {%p1369 %p1370};
//   %wire_3661 = &"net234" @WIRE(mode="straight") {#"I1289":3 %p1369};
//   %wire_3662 = &"net234" @WIRE(mode="straight") {#"I1282":7 %p1370};
//   %p1371 = (230, -159);
//   %wire_3663 = &"net234" @WIRE(mode="straight") {%p1371 %p1370};
//   %wire_3664 = &"net234" @WIRE(mode="straight") {#"I1287":6 %p1371};
//   %wire_3665 = &"net453" @WIRE(mode="straight") {#"I1513":1 #"I1514":3};
//   %p1372 = (172, -264);
//   %wire_3666 = &"net305" @WIRE(mode="straight") {#"I932":7 %p1372};
//   %p1373 = (194, -264);
//   %wire_3667 = &"net305" @WIRE(mode="straight") {#"I931":6 %p1373};
//   %p1374 = (192, -264);
//   %wire_3668 = &"net305" @WIRE(mode="straight") {%p1374 %p1373};
//   %wire_3669 = &"net305" @WIRE(mode="straight") {%p1372 %p1374};
//   %wire_3670 = &"net305" @WIRE(mode="straight") {#"I931":3 %p1374};
//   %p1375 = (300, -159);
//   %wire_3671 = &"net235" @WIRE(mode="straight") {#"I1290":3 %p1375};
//   %p1376 = (280, -157);
//   %wire_3672 = &"net235" @WIRE(mode="straight") {#"I1289":7 %p1376};
//   %p1377 = (254, -159);
//   %wire_3673 = &"net235" @WIRE(mode="straight") {%p1377 %p1376};
//   %wire_3674 = &"net235" @WIRE(mode="straight") {#"I1282":6 %p1377};
//   %wire_3675 = &"net235" @WIRE(mode="straight") {%p1375 %p1376};
//   %p1378 = (84, -264);
//   %wire_3676 = &"net307" @WIRE(mode="straight") {#"I922":6 %p1378};
//   %p1379 = (82, -264);
//   %wire_3677 = &"net307" @WIRE(mode="straight") {%p1379 %p1378};
//   %p1380 = (62, -264);
//   %wire_3678 = &"net307" @WIRE(mode="straight") {#"I921":7 %p1380};
//   %wire_3679 = &"net307" @WIRE(mode="straight") {#"I922":3 %p1379};
//   %wire_3680 = &"net307" @WIRE(mode="straight") {%p1380 %p1379};
//   %p1381 = (374, -299);
//   %wire_3681 = &"net236" @WIRE(mode="straight") {#"I1327":6 %p1381};
//   %p1382 = (400, -297);
//   %wire_3682 = &"net236" @WIRE(mode="straight") {#"I1328":7 %p1382};
//   %wire_3683 = &"net236" @WIRE(mode="straight") {%p1381 %p1382};
//   %p1383 = (215, -311);
//   %wire_3684 = &"net237" @WIRE(mode="straight") {%p1383 #"I1321":4};
//   %p1384 = (215, -314);
//   %wire_3685 = &"net237" @WIRE(mode="straight") {%p1384 %p1383};
//   %wire_3686 = &"net237" @WIRE(mode="straight") {%p1383 #"M164":1};
//   %wire_3687 = &"net237" @WIRE(mode="straight") {#"M57":1 %p1384};
//   %wire_3688 = &"net237" @WIRE(mode="straight") {#"I1321":4 #"I1316":4};
//   %wire_3689 = &"net237" @WIRE(mode="straight") {#"I1316":4 #"I1323":4};
//   %wire_3690 = &"net237" @WIRE(mode="straight") {#"I1325":4 #"I1326":4};
//   %wire_3691 = &"net237" @WIRE(mode="straight") {#"I1324":4 #"I1325":4};
//   %wire_3692 = &"net237" @WIRE(mode="straight") {#"I1326":4 #"I1327":4};
//   %wire_3693 = &"net237" @WIRE(mode="straight") {#"I1327":4 #"I1328":4};
//   %wire_3694 = &"net237" @WIRE(mode="straight") {#"I1323":4 #"I1324":4};
//   %p1385 = (170, -614);
//   %wire_3695 = &"net311" @WIRE(mode="straight") {#"I1132":6 %p1385};
//   %p1386 = (168, -614);
//   %wire_3696 = &"net311" @WIRE(mode="straight") {%p1386 %p1385};
//   %wire_3697 = &"net311" @WIRE(mode="straight") {#"I1132":3 %p1386};
//   %p1387 = (148, -614);
//   %wire_3698 = &"net311" @WIRE(mode="straight") {%p1387 %p1386};
//   %wire_3699 = &"net311" @WIRE(mode="straight") {#"I1133":7 %p1387};
//   %p1388 = (280, -323);
//   %p1389 = (304, -323);
//   %wire_3700 = &"net243" @WIRE(mode="straight") {%p1388 %p1389};
//   %p1390 = (14, -323);
//   %wire_3701 = &"net243" @WIRE(mode="straight") {%p1390 #"I1315":5};
//   %p1391 = (124, -323);
//   %wire_3702 = &"net243" @WIRE(mode="straight") {%p1391 #"I1317":5};
//   %p1392 = (232, -323);
//   %wire_3703 = &"net243" @WIRE(mode="straight") {%p1392 #"I1321":5};
//   %p1393 = (196, -323);
//   %wire_3704 = &"net243" @WIRE(mode="straight") {%p1393 %p1392};
//   %wire_3705 = &"net243" @WIRE(mode="straight") {%p1393 #"I1320":5};
//   %p1394 = (172, -323);
//   %wire_3706 = &"net243" @WIRE(mode="straight") {%p1394 %p1393};
//   %p1395 = (256, -323);
//   %wire_3707 = &"net243" @WIRE(mode="straight") {%p1392 %p1395};
//   %wire_3708 = &"net243" @WIRE(mode="straight") {%p1395 #"I1316":5};
//   %p1396 = (328, -323);
//   %wire_3709 = &"net243" @WIRE(mode="straight") {%p1396 #"I1325":5};
//   %p1397 = (376, -323);
//   %wire_3710 = &"net243" @WIRE(mode="straight") {%p1397 #"I1327":5};
//   %wire_3711 = &"net243" @WIRE(mode="straight") {%p1389 %p1396};
//   %p1398 = (-4, -323);
//   %wire_3712 = &"net243" @WIRE(mode="straight") {%p1398 #"I1486":2};
//   %p1399 = (400, -323);
//   %wire_3713 = &"net243" @WIRE(mode="straight") {%p1399 #"I1322":2};
//   %wire_3714 = &"net243" @WIRE(mode="straight") {%p1398 %p1390};
//   %wire_3715 = &"net243" @WIRE(mode="straight") {%p1395 %p1388};
//   %wire_3716 = &"net243" @WIRE(mode="straight") {%p1399 #"I1328":5};
//   %p1400 = (352, -323);
//   %wire_3717 = &"net243" @WIRE(mode="straight") {%p1396 %p1400};
//   %wire_3718 = &"net243" @WIRE(mode="straight") {%p1397 %p1399};
//   %p1401 = (38, -323);
//   %wire_3719 = &"net243" @WIRE(mode="straight") {%p1390 %p1401};
//   %p1402 = (86, -323);
//   %wire_3720 = &"net243" @WIRE(mode="straight") {%p1402 #"I1312":5};
//   %p1403 = (62, -323);
//   %wire_3721 = &"net243" @WIRE(mode="straight") {%p1403 %p1402};
//   %p1404 = (148, -323);
//   %wire_3722 = &"net243" @WIRE(mode="straight") {%p1404 #"I1318":5};
//   %wire_3723 = &"net243" @WIRE(mode="straight") {%p1401 #"I1314":5};
//   %wire_3724 = &"net243" @WIRE(mode="straight") {%p1402 %p1391};
//   %wire_3725 = &"net243" @WIRE(mode="straight") {%p1391 %p1404};
//   %wire_3726 = &"net243" @WIRE(mode="straight") {%p1403 #"I1313":5};
//   %wire_3727 = &"net243" @WIRE(mode="straight") {%p1394 #"I1319":5};
//   %wire_3728 = &"net243" @WIRE(mode="straight") {%p1404 %p1394};
//   %wire_3729 = &"net243" @WIRE(mode="straight") {%p1400 #"I1326":5};
//   %wire_3730 = &"net243" @WIRE(mode="straight") {%p1401 %p1403};
//   %wire_3731 = &"net243" @WIRE(mode="straight") {%p1400 %p1397};
//   %wire_3732 = &"net243" @WIRE(mode="straight") {%p1388 #"I1323":5};
//   %wire_3733 = &"net243" @WIRE(mode="straight") {%p1389 #"I1324":5};
//   %p1405 = (122, -614);
//   %wire_3734 = &"net313" @WIRE(mode="straight") {#"I1134":6 %p1405};
//   %p1406 = (120, -614);
//   %wire_3735 = &"net313" @WIRE(mode="straight") {%p1406 %p1405};
//   %wire_3736 = &"net313" @WIRE(mode="straight") {#"I1134":3 %p1406};
//   %p1407 = (86, -614);
//   %wire_3737 = &"net313" @WIRE(mode="straight") {%p1407 %p1406};
//   %wire_3738 = &"net313" @WIRE(mode="straight") {#"I1122":7 %p1407};
//   %p1408 = (372, -299);
//   %p1409 = (352, -297);
//   %wire_3739 = &"net245" @WIRE(mode="straight") {%p1408 %p1409};
//   %p1410 = (326, -299);
//   %wire_3740 = &"net245" @WIRE(mode="straight") {#"I1325":6 %p1410};
//   %wire_3741 = &"net245" @WIRE(mode="straight") {%p1410 %p1409};
//   %wire_3742 = &"net245" @WIRE(mode="straight") {#"I1327":3 %p1408};
//   %wire_3743 = &"net245" @WIRE(mode="straight") {#"I1326":7 %p1409};
//   %p1411 = (396, -299);
//   %wire_3744 = &"net246" @WIRE(mode="straight") {#"I1328":3 %p1411};
//   %p1412 = (376, -297);
//   %wire_3745 = &"net246" @WIRE(mode="straight") {#"I1327":7 %p1412};
//   %p1413 = (350, -299);
//   %wire_3746 = &"net246" @WIRE(mode="straight") {#"I1326":6 %p1413};
//   %wire_3747 = &"net246" @WIRE(mode="straight") {%p1413 %p1412};
//   %wire_3748 = &"net246" @WIRE(mode="straight") {%p1411 %p1412};
//   %p1414 = (250, -295);
//   %wire_3749 = &"net255" @WIRE(mode="straight") {#"I1316":9 %p1414};
//   %p1415 = (226, -295);
//   %wire_3750 = &"net255" @WIRE(mode="straight") {%p1415 %p1414};
//   %wire_3751 = &"net255" @WIRE(mode="straight") {#"I1321":9 %p1415};
//   %p1416 = (190, -295);
//   %wire_3752 = &"net255" @WIRE(mode="straight") {%p1416 %p1415};
//   %p1417 = (166, -295);
//   %wire_3753 = &"net255" @WIRE(mode="straight") {%p1417 %p1416};
//   %p1418 = (322, -295);
//   %p1419 = (346, -295);
//   %wire_3754 = &"net255" @WIRE(mode="straight") {%p1418 %p1419};
//   %wire_3755 = &"net255" @WIRE(mode="straight") {#"I1326":9 %p1419};
//   %p1420 = (298, -295);
//   %wire_3756 = &"net255" @WIRE(mode="straight") {%p1420 %p1418};
//   %p1421 = (10, -295);
//   %wire_3757 = &"net255" @WIRE(mode="straight") {#"I1315":3 %p1421};
//   %p1422 = (274, -295);
//   %wire_3758 = &"net255" @WIRE(mode="straight") {#"I1323":9 %p1422};
//   %wire_3759 = &"net255" @WIRE(mode="straight") {#"I1325":9 %p1418};
//   %p1423 = (370, -295);
//   %wire_3760 = &"net255" @WIRE(mode="straight") {%p1419 %p1423};
//   %p1424 = (8, -295);
//   %wire_3761 = &"net255" @WIRE(mode="straight") {#"I1315":9 %p1424};
//   %p1425 = (32, -295);
//   %wire_3762 = &"net255" @WIRE(mode="straight") {#"I1314":9 %p1425};
//   %wire_3763 = &"net255" @WIRE(mode="straight") {#"I1327":9 %p1423};
//   %wire_3764 = &"net255" @WIRE(mode="straight") {%p1414 %p1422};
//   %p1426 = (56, -295);
//   %wire_3765 = &"net255" @WIRE(mode="straight") {%p1425 %p1426};
//   %p1427 = (118, -295);
//   %wire_3766 = &"net255" @WIRE(mode="straight") {#"I1317":9 %p1427};
//   %p1428 = (80, -295);
//   %wire_3767 = &"net255" @WIRE(mode="straight") {#"I1312":9 %p1428};
//   %p1429 = (394, -295);
//   %wire_3768 = &"net255" @WIRE(mode="straight") {#"I1328":9 %p1429};
//   %p1430 = (142, -295);
//   %wire_3769 = &"net255" @WIRE(mode="straight") {%p1430 %p1417};
//   %wire_3770 = &"net255" @WIRE(mode="straight") {%p1421 %p1425};
//   %wire_3771 = &"net255" @WIRE(mode="straight") {%p1428 %p1427};
//   %wire_3772 = &"net255" @WIRE(mode="straight") {#"I1313":9 %p1426};
//   %wire_3773 = &"net255" @WIRE(mode="straight") {%p1427 %p1430};
//   %wire_3774 = &"net255" @WIRE(mode="straight") {%p1426 %p1428};
//   %wire_3775 = &"net255" @WIRE(mode="straight") {%p1423 %p1429};
//   %wire_3776 = &"net255" @WIRE(mode="straight") {%p1424 %p1421};
//   %wire_3777 = &"net255" @WIRE(mode="straight") {#"I1319":9 %p1417};
//   %wire_3778 = &"net255" @WIRE(mode="straight") {%p1422 %p1420};
//   %wire_3779 = &"net255" @WIRE(mode="straight") {#"I1320":9 %p1416};
//   %wire_3780 = &"net255" @WIRE(mode="straight") {#"I1324":9 %p1420};
//   %wire_3781 = &"net255" @WIRE(mode="straight") {#"I1318":9 %p1430};
//   %p1431 = (302, -404);
//   %wire_3782 = &"net317" @WIRE(mode="straight") {#"I1027":6 %p1431};
//   %p1432 = (300, -404);
//   %wire_3783 = &"net317" @WIRE(mode="straight") {%p1432 %p1431};
//   %p1433 = (280, -404);
//   %wire_3784 = &"net317" @WIRE(mode="straight") {#"I1028":7 %p1433};
//   %wire_3785 = &"net317" @WIRE(mode="straight") {#"I1027":3 %p1432};
//   %wire_3786 = &"net317" @WIRE(mode="straight") {%p1433 %p1432};
//   %p1434 = (-6, -346);
//   %wire_3787 = &"net319" @WIRE(mode="straight") {#"I1496":1 %p1434};
//   %wire_3788 = &"net319" @WIRE(mode="straight") {#"I961":4 #"I962":4};
//   %wire_3789 = &"net319" @WIRE(mode="straight") {#"I960":4 #"I961":4};
//   %wire_3790 = &"net319" @WIRE(mode="straight") {%p1434 #"M76":1};
//   %wire_3791 = &"net319" @WIRE(mode="straight") {%p1434 #"I959":4};
//   %p1435 = (97, -346);
//   %wire_3792 = &"net319" @WIRE(mode="straight") {#"I962":4 %p1435};
//   %p1436 = (97, -343);
//   %wire_3793 = &"net319" @WIRE(mode="straight") {%p1435 %p1436};
//   %wire_3794 = &"net319" @WIRE(mode="straight") {#"M32":3 %p1435};
//   %p1437 = (-26, -348);
//   %wire_3795 = &"net319" @WIRE(mode="straight") {#"I1500":2 %p1437};
//   %wire_3796 = &"net319" @WIRE(mode="straight") {%p1437 #"I1496":1};
//   %wire_3797 = &"net319" @WIRE(mode="straight") {%p1436 #"M139":3};
//   %wire_3798 = &"net319" @WIRE(mode="straight") {#"I959":4 #"I960":4};
//   %p1438 = (252, -299);
//   %wire_3799 = &"net261" @WIRE(mode="straight") {#"I1316":3 %p1438};
//   %p1439 = (232, -297);
//   %wire_3800 = &"net261" @WIRE(mode="straight") {%p1438 %p1439};
//   %wire_3801 = &"net261" @WIRE(mode="straight") {#"I1321":7 %p1439};
//   %p1440 = (194, -299);
//   %wire_3802 = &"net261" @WIRE(mode="straight") {%p1440 %p1439};
//   %wire_3803 = &"net261" @WIRE(mode="straight") {#"I1320":6 %p1440};
//   %wire_3804 = &"net461" @WIRE(mode="straight") {#"I1475":1 #"I1476":3};
//   %p1441 = (205, -311);
//   %p1442 = (205, -308);
//   %wire_3805 = &"net265" @WIRE(mode="straight") {%p1441 %p1442};
//   %wire_3806 = &"net265" @WIRE(mode="straight") {%p1442 #"M164":3};
//   %wire_3807 = &"net265" @WIRE(mode="straight") {#"M57":3 %p1441};
//   %wire_3808 = &"net265" @WIRE(mode="straight") {#"I1320":4 %p1441};
//   %wire_3809 = &"net265" @WIRE(mode="straight") {#"I1319":4 #"I1320":4};
//   %wire_3810 = &"net265" @WIRE(mode="straight") {#"I1317":4 #"I1318":4};
//   %wire_3811 = &"net265" @WIRE(mode="straight") {#"I1318":4 #"I1319":4};
//   %p1443 = (107, -314);
//   %wire_3812 = &"net265" @WIRE(mode="straight") {#"M31":1 %p1443};
//   %p1444 = (107, -311);
//   %wire_3813 = &"net265" @WIRE(mode="straight") {%p1444 #"I1317":4};
//   %wire_3814 = &"net265" @WIRE(mode="straight") {%p1444 #"M138":1};
//   %wire_3815 = &"net265" @WIRE(mode="straight") {%p1443 %p1444};
//   %p1445 = (192, -299);
//   %wire_3816 = &"net266" @WIRE(mode="straight") {#"I1320":3 %p1445};
//   %p1446 = (172, -297);
//   %wire_3817 = &"net266" @WIRE(mode="straight") {%p1445 %p1446};
//   %wire_3818 = &"net266" @WIRE(mode="straight") {#"I1319":7 %p1446};
//   %p1447 = (146, -299);
//   %wire_3819 = &"net266" @WIRE(mode="straight") {%p1447 %p1446};
//   %wire_3820 = &"net266" @WIRE(mode="straight") {#"I1318":6 %p1447};
//   %p1448 = (170, -264);
//   %wire_3821 = &"net324" @WIRE(mode="straight") {#"I932":6 %p1448};
//   %p1449 = (148, -264);
//   %wire_3822 = &"net324" @WIRE(mode="straight") {#"I933":7 %p1449};
//   %p1450 = (168, -264);
//   %wire_3823 = &"net324" @WIRE(mode="straight") {%p1449 %p1450};
//   %wire_3824 = &"net324" @WIRE(mode="straight") {#"I932":3 %p1450};
//   %wire_3825 = &"net324" @WIRE(mode="straight") {%p1450 %p1448};
//   %p1451 = (228, -299);
//   %wire_3826 = &"net268" @WIRE(mode="straight") {#"I1321":3 %p1451};
//   %p1452 = (196, -297);
//   %wire_3827 = &"net268" @WIRE(mode="straight") {%p1451 %p1452};
//   %wire_3828 = &"net268" @WIRE(mode="straight") {#"I1320":7 %p1452};
//   %p1453 = (170, -299);
//   %wire_3829 = &"net268" @WIRE(mode="straight") {%p1453 %p1452};
//   %wire_3830 = &"net268" @WIRE(mode="straight") {#"I1319":6 %p1453};
//   %p1454 = (86, -264);
//   %wire_3831 = &"net326" @WIRE(mode="straight") {#"I922":7 %p1454};
//   %p1455 = (122, -264);
//   %wire_3832 = &"net326" @WIRE(mode="straight") {#"I934":6 %p1455};
//   %p1456 = (120, -264);
//   %wire_3833 = &"net326" @WIRE(mode="straight") {%p1454 %p1456};
//   %wire_3834 = &"net326" @WIRE(mode="straight") {#"I934":3 %p1456};
//   %wire_3835 = &"net326" @WIRE(mode="straight") {%p1456 %p1455};
//   %p1457 = (144, -299);
//   %p1458 = (124, -297);
//   %wire_3836 = &"net270" @WIRE(mode="straight") {%p1457 %p1458};
//   %wire_3837 = &"net270" @WIRE(mode="straight") {#"I1317":7 %p1458};
//   %p1459 = (84, -299);
//   %wire_3838 = &"net270" @WIRE(mode="straight") {%p1458 %p1459};
//   %wire_3839 = &"net270" @WIRE(mode="straight") {#"I1318":3 %p1457};
//   %wire_3840 = &"net270" @WIRE(mode="straight") {#"I1312":6 %p1459};
//   %p1460 = (122, -299);
//   %wire_3841 = &"net272" @WIRE(mode="straight") {#"I1317":6 %p1460};
//   %p1461 = (168, -299);
//   %wire_3842 = &"net272" @WIRE(mode="straight") {#"I1319":3 %p1461};
//   %p1462 = (148, -297);
//   %wire_3843 = &"net272" @WIRE(mode="straight") {%p1460 %p1462};
//   %wire_3844 = &"net272" @WIRE(mode="straight") {%p1461 %p1462};
//   %wire_3845 = &"net272" @WIRE(mode="straight") {#"I1318":7 %p1462};
//   %p1463 = (348, -159);
//   %wire_3846 = &"net273" @WIRE(mode="straight") {#"I1292":3 %p1463};
//   %p1464 = (328, -157);
//   %wire_3847 = &"net273" @WIRE(mode="straight") {%p1463 %p1464};
//   %wire_3848 = &"net273" @WIRE(mode="straight") {#"I1291":7 %p1464};
//   %p1465 = (302, -159);
//   %wire_3849 = &"net273" @WIRE(mode="straight") {%p1465 %p1464};
//   %wire_3850 = &"net273" @WIRE(mode="straight") {#"I1290":6 %p1465};
//   %p1466 = (372, -159);
//   %wire_3851 = &"net274" @WIRE(mode="straight") {#"I1293":3 %p1466};
//   %p1467 = (352, -157);
//   %wire_3852 = &"net274" @WIRE(mode="straight") {%p1466 %p1467};
//   %wire_3853 = &"net274" @WIRE(mode="straight") {#"I1292":7 %p1467};
//   %p1468 = (326, -159);
//   %wire_3854 = &"net274" @WIRE(mode="straight") {%p1468 %p1467};
//   %wire_3855 = &"net274" @WIRE(mode="straight") {#"I1291":6 %p1468};
//   %p1469 = (-26, -593);
//   %wire_3856 = &"net334" @WIRE(mode="straight") {%p1469 #"I1519":1};
//   %p1470 = (-18, -591);
//   %wire_3857 = &"net334" @WIRE(mode="straight") {%p1470 #"M81":1};
//   %wire_3858 = &"net334" @WIRE(mode="straight") {#"I1519":1 %p1470};
//   %wire_3859 = &"net334" @WIRE(mode="straight") {#"I1522":2 %p1469};
//   %wire_3860 = &"net334" @WIRE(mode="straight") {#"I1383":4 #"I1382":4};
//   %wire_3861 = &"net334" @WIRE(mode="straight") {%p1470 #"I1383":4};
//   %wire_3862 = &"net334" @WIRE(mode="straight") {#"I1381":4 #"I1380":4};
//   %p1471 = (97, -588);
//   %wire_3863 = &"net334" @WIRE(mode="straight") {%p1471 #"M146":3};
//   %p1472 = (97, -591);
//   %wire_3864 = &"net334" @WIRE(mode="straight") {#"I1380":4 %p1472};
//   %wire_3865 = &"net334" @WIRE(mode="straight") {#"I1382":4 #"I1381":4};
//   %wire_3866 = &"net334" @WIRE(mode="straight") {#"M39":3 %p1472};
//   %wire_3867 = &"net334" @WIRE(mode="straight") {%p1472 %p1471};
//   %p1473 = (328, -297);
//   %wire_3868 = &"net277" @WIRE(mode="straight") {#"I1325":7 %p1473};
//   %p1474 = (348, -299);
//   %wire_3869 = &"net277" @WIRE(mode="straight") {%p1474 %p1473};
//   %p1475 = (302, -299);
//   %wire_3870 = &"net277" @WIRE(mode="straight") {%p1475 %p1473};
//   %wire_3871 = &"net277" @WIRE(mode="straight") {#"I1324":6 %p1475};
//   %wire_3872 = &"net277" @WIRE(mode="straight") {#"I1326":3 %p1474};
//   %p1476 = (278, -299);
//   %p1477 = (304, -297);
//   %wire_3873 = &"net278" @WIRE(mode="straight") {%p1476 %p1477};
//   %wire_3874 = &"net278" @WIRE(mode="straight") {#"I1323":6 %p1476};
//   %p1478 = (324, -299);
//   %wire_3875 = &"net278" @WIRE(mode="straight") {#"I1325":3 %p1478};
//   %wire_3876 = &"net278" @WIRE(mode="straight") {#"I1324":7 %p1477};
//   %wire_3877 = &"net278" @WIRE(mode="straight") {%p1478 %p1477};
//   %p1479 = (280, -474);
//   %wire_3878 = &"net339" @WIRE(mode="straight") {#"I1068":7 %p1479};
//   %p1480 = (300, -474);
//   %wire_3879 = &"net339" @WIRE(mode="straight") {#"I1067":3 %p1480};
//   %p1481 = (302, -474);
//   %wire_3880 = &"net339" @WIRE(mode="straight") {#"I1067":6 %p1481};
//   %wire_3881 = &"net339" @WIRE(mode="straight") {%p1480 %p1481};
//   %wire_3882 = &"net339" @WIRE(mode="straight") {%p1479 %p1480};
//   %p1482 = (324, -474);
//   %p1483 = (326, -474);
//   %wire_3883 = &"net340" @WIRE(mode="straight") {%p1482 %p1483};
//   %wire_3884 = &"net340" @WIRE(mode="straight") {#"I1066":3 %p1482};
//   %wire_3885 = &"net340" @WIRE(mode="straight") {#"I1066":6 %p1483};
//   %p1484 = (304, -474);
//   %wire_3886 = &"net340" @WIRE(mode="straight") {%p1484 %p1482};
//   %wire_3887 = &"net340" @WIRE(mode="straight") {#"I1067":7 %p1484};
//   %p1485 = (396, -474);
//   %wire_3888 = &"net341" @WIRE(mode="straight") {#"I1063":3 %p1485};
//   %p1486 = (398, -474);
//   %wire_3889 = &"net341" @WIRE(mode="straight") {%p1485 %p1486};
//   %p1487 = (376, -474);
//   %wire_3890 = &"net341" @WIRE(mode="straight") {%p1487 %p1485};
//   %wire_3891 = &"net341" @WIRE(mode="straight") {#"I1063":6 %p1486};
//   %wire_3892 = &"net341" @WIRE(mode="straight") {#"I1064":7 %p1487};
//   %p1488 = (398, -470);
//   %p1489 = (400, -470);
//   %wire_3893 = &"net342" @WIRE(mode="straight") {%p1488 %p1489};
//   %wire_3894 = &"net342" @WIRE(mode="straight") {%p1488 #"I1362":6};
//   %wire_3895 = &"net342" @WIRE(mode="straight") {#"I1063":7 %p1489};
//   %p1490 = (230, -299);
//   %wire_3896 = &"net279" @WIRE(mode="straight") {#"I1321":6 %p1490};
//   %p1491 = (256, -297);
//   %wire_3897 = &"net279" @WIRE(mode="straight") {#"I1316":7 %p1491};
//   %wire_3898 = &"net279" @WIRE(mode="straight") {%p1490 %p1491};
//   %p1492 = (276, -299);
//   %wire_3899 = &"net279" @WIRE(mode="straight") {%p1492 %p1491};
//   %wire_3900 = &"net279" @WIRE(mode="straight") {#"I1323":3 %p1492};
//   %p1493 = (300, -299);
//   %wire_3901 = &"net280" @WIRE(mode="straight") {#"I1324":3 %p1493};
//   %p1494 = (254, -299);
//   %wire_3902 = &"net280" @WIRE(mode="straight") {#"I1316":6 %p1494};
//   %p1495 = (280, -297);
//   %wire_3903 = &"net280" @WIRE(mode="straight") {%p1494 %p1495};
//   %wire_3904 = &"net280" @WIRE(mode="straight") {#"I1323":7 %p1495};
//   %wire_3905 = &"net280" @WIRE(mode="straight") {%p1493 %p1495};
//   %p1496 = (62, -577);
//   %wire_3906 = &"net282" @WIRE(mode="straight") {#"I1381":7 %p1496};
//   %p1497 = (36, -579);
//   %wire_3907 = &"net282" @WIRE(mode="straight") {#"I1382":6 %p1497};
//   %p1498 = (82, -579);
//   %wire_3908 = &"net282" @WIRE(mode="straight") {%p1498 %p1496};
//   %wire_3909 = &"net282" @WIRE(mode="straight") {#"I1380":3 %p1498};
//   %wire_3910 = &"net282" @WIRE(mode="straight") {%p1497 %p1496};
//   %p1499 = (205, -343);
//   %wire_3911 = &"net347" @WIRE(mode="straight") {%p1499 #"M163":3};
//   %p1500 = (205, -346);
//   %wire_3912 = &"net347" @WIRE(mode="straight") {#"M56":3 %p1500};
//   %wire_3913 = &"net347" @WIRE(mode="straight") {#"I974":4 #"I973":4};
//   %wire_3914 = &"net347" @WIRE(mode="straight") {#"I971":4 %p1500};
//   %p1501 = (107, -349);
//   %wire_3915 = &"net347" @WIRE(mode="straight") {#"M32":1 %p1501};
//   %p1502 = (107, -346);
//   %wire_3916 = &"net347" @WIRE(mode="straight") {%p1502 #"M139":1};
//   %wire_3917 = &"net347" @WIRE(mode="straight") {%p1501 %p1502};
//   %wire_3918 = &"net347" @WIRE(mode="straight") {#"I972":4 #"I971":4};
//   %wire_3919 = &"net347" @WIRE(mode="straight") {#"I973":4 #"I972":4};
//   %wire_3920 = &"net347" @WIRE(mode="straight") {%p1500 %p1499};
//   %wire_3921 = &"net347" @WIRE(mode="straight") {%p1502 #"I974":4};
//   %p1503 = (168, -334);
//   %p1504 = (170, -334);
//   %wire_3922 = &"net349" @WIRE(mode="straight") {%p1503 %p1504};
//   %wire_3923 = &"net349" @WIRE(mode="straight") {#"I972":6 %p1504};
//   %wire_3924 = &"net349" @WIRE(mode="straight") {#"I972":3 %p1503};
//   %p1505 = (148, -334);
//   %wire_3925 = &"net349" @WIRE(mode="straight") {%p1505 %p1503};
//   %wire_3926 = &"net349" @WIRE(mode="straight") {#"I973":7 %p1505};
//   %p1506 = (192, -334);
//   %wire_3927 = &"net350" @WIRE(mode="straight") {#"I971":3 %p1506};
//   %p1507 = (172, -334);
//   %wire_3928 = &"net350" @WIRE(mode="straight") {%p1507 %p1506};
//   %wire_3929 = &"net350" @WIRE(mode="straight") {#"I972":7 %p1507};
//   %p1508 = (194, -334);
//   %wire_3930 = &"net350" @WIRE(mode="straight") {%p1506 %p1508};
//   %wire_3931 = &"net350" @WIRE(mode="straight") {#"I971":6 %p1508};
//   %p1509 = (396, -159);
//   %wire_3932 = &"net285" @WIRE(mode="straight") {#"I1294":3 %p1509};
//   %p1510 = (376, -157);
//   %wire_3933 = &"net285" @WIRE(mode="straight") {%p1509 %p1510};
//   %wire_3934 = &"net285" @WIRE(mode="straight") {#"I1293":7 %p1510};
//   %p1511 = (350, -159);
//   %wire_3935 = &"net285" @WIRE(mode="straight") {%p1511 %p1510};
//   %wire_3936 = &"net285" @WIRE(mode="straight") {#"I1292":6 %p1511};
//   %p1512 = (400, -157);
//   %wire_3937 = &"net286" @WIRE(mode="straight") {#"I1294":7 %p1512};
//   %p1513 = (374, -159);
//   %wire_3938 = &"net286" @WIRE(mode="straight") {%p1513 %p1512};
//   %wire_3939 = &"net286" @WIRE(mode="straight") {#"I1293":6 %p1513};
//   %p1514 = (400, -190);
//   %wire_3940 = &"net288" @WIRE(mode="straight") {#"I903":7 %p1514};
//   %p1515 = (398, -190);
//   %wire_3941 = &"net288" @WIRE(mode="straight") {%p1515 #"I1294":6};
//   %wire_3942 = &"net288" @WIRE(mode="straight") {%p1515 %p1514};
//   %p1516 = (120, -369);
//   %p1517 = (86, -367);
//   %wire_3943 = &"net290" @WIRE(mode="straight") {%p1516 %p1517};
//   %wire_3944 = &"net290" @WIRE(mode="straight") {#"I1329":7 %p1517};
//   %p1518 = (60, -369);
//   %wire_3945 = &"net290" @WIRE(mode="straight") {%p1518 %p1517};
//   %wire_3946 = &"net290" @WIRE(mode="straight") {#"I1330":6 %p1518};
//   %wire_3947 = &"net290" @WIRE(mode="straight") {#"I1334":3 %p1516};
//   %p1519 = (82, -369);
//   %p1520 = (62, -367);
//   %wire_3948 = &"net291" @WIRE(mode="straight") {%p1519 %p1520};
//   %p1521 = (36, -369);
//   %wire_3949 = &"net291" @WIRE(mode="straight") {%p1521 %p1520};
//   %wire_3950 = &"net291" @WIRE(mode="straight") {#"I1330":7 %p1520};
//   %wire_3951 = &"net291" @WIRE(mode="straight") {#"I1331":6 %p1521};
//   %wire_3952 = &"net291" @WIRE(mode="straight") {#"I1329":3 %p1519};
//   %p1522 = (38, -437);
//   %wire_3953 = &"net296" @WIRE(mode="straight") {#"I1348":7 %p1522};
//   %p1523 = (12, -439);
//   %wire_3954 = &"net296" @WIRE(mode="straight") {%p1523 %p1522};
//   %p1524 = (58, -439);
//   %wire_3955 = &"net296" @WIRE(mode="straight") {%p1524 %p1522};
//   %wire_3956 = &"net296" @WIRE(mode="straight") {#"I1347":3 %p1524};
//   %wire_3957 = &"net296" @WIRE(mode="straight") {#"I1349":6 %p1523};
//   %p1525 = (12, -579);
//   %wire_3958 = &"net297" @WIRE(mode="straight") {#"I1383":6 %p1525};
//   %p1526 = (38, -577);
//   %wire_3959 = &"net297" @WIRE(mode="straight") {#"I1382":7 %p1526};
//   %wire_3960 = &"net297" @WIRE(mode="straight") {%p1525 %p1526};
//   %p1527 = (58, -579);
//   %wire_3961 = &"net297" @WIRE(mode="straight") {#"I1381":3 %p1527};
//   %wire_3962 = &"net297" @WIRE(mode="straight") {%p1527 %p1526};
//   %p1528 = (348, -509);
//   %p1529 = (328, -507);
//   %wire_3963 = &"net299" @WIRE(mode="straight") {%p1528 %p1529};
//   %p1530 = (302, -509);
//   %wire_3964 = &"net299" @WIRE(mode="straight") {%p1530 %p1529};
//   %wire_3965 = &"net299" @WIRE(mode="straight") {#"I1377":3 %p1528};
//   %wire_3966 = &"net299" @WIRE(mode="straight") {#"I1375":6 %p1530};
//   %wire_3967 = &"net299" @WIRE(mode="straight") {#"I1376":7 %p1529};
//   %p1531 = (215, -136);
//   %wire_3968 = &"net360" @WIRE(mode="straight") {%p1531 #"I850":4};
//   %p1532 = (215, -139);
//   %wire_3969 = &"net360" @WIRE(mode="straight") {%p1532 %p1531};
//   %wire_3970 = &"net360" @WIRE(mode="straight") {%p1531 #"M169":1};
//   %wire_3971 = &"net360" @WIRE(mode="straight") {#"M62":1 %p1532};
//   %wire_3972 = &"net360" @WIRE(mode="straight") {#"I864":4 #"I863":4};
//   %wire_3973 = &"net360" @WIRE(mode="straight") {#"I867":4 #"I866":4};
//   %wire_3974 = &"net360" @WIRE(mode="straight") {#"I866":4 #"I865":4};
//   %wire_3975 = &"net360" @WIRE(mode="straight") {#"I849":4 #"I868":4};
//   %wire_3976 = &"net360" @WIRE(mode="straight") {#"I865":4 #"I864":4};
//   %wire_3977 = &"net360" @WIRE(mode="straight") {#"I850":4 #"I849":4};
//   %wire_3978 = &"net360" @WIRE(mode="straight") {#"I868":4 #"I867":4};
//   %p1533 = (205, -133);
//   %wire_3979 = &"net361" @WIRE(mode="straight") {%p1533 #"M169":3};
//   %p1534 = (107, -139);
//   %wire_3980 = &"net361" @WIRE(mode="straight") {#"M26":1 %p1534};
//   %p1535 = (107, -136);
//   %wire_3981 = &"net361" @WIRE(mode="straight") {%p1535 #"M133":1};
//   %p1536 = (205, -136);
//   %wire_3982 = &"net361" @WIRE(mode="straight") {#"I851":4 %p1536};
//   %wire_3983 = &"net361" @WIRE(mode="straight") {#"I854":4 #"I853":4};
//   %wire_3984 = &"net361" @WIRE(mode="straight") {#"M62":3 %p1536};
//   %wire_3985 = &"net361" @WIRE(mode="straight") {%p1534 %p1535};
//   %wire_3986 = &"net361" @WIRE(mode="straight") {#"I853":4 #"I852":4};
//   %wire_3987 = &"net361" @WIRE(mode="straight") {#"I852":4 #"I851":4};
//   %wire_3988 = &"net361" @WIRE(mode="straight") {%p1535 #"I854":4};
//   %wire_3989 = &"net361" @WIRE(mode="straight") {%p1536 %p1533};
//   %p1537 = (168, -124);
//   %wire_3990 = &"net363" @WIRE(mode="straight") {#"I852":3 %p1537};
//   %p1538 = (148, -124);
//   %wire_3991 = &"net363" @WIRE(mode="straight") {%p1538 %p1537};
//   %p1539 = (170, -124);
//   %wire_3992 = &"net363" @WIRE(mode="straight") {%p1537 %p1539};
//   %wire_3993 = &"net363" @WIRE(mode="straight") {#"I852":6 %p1539};
//   %wire_3994 = &"net363" @WIRE(mode="straight") {#"I853":7 %p1538};
//   %p1540 = (86, -148);
//   %wire_3995 = &"net364" @WIRE(mode="straight") {%p1540 #"I842":5};
//   %p1541 = (352, -148);
//   %p1542 = (376, -148);
//   %wire_3996 = &"net364" @WIRE(mode="straight") {%p1541 %p1542};
//   %p1543 = (232, -148);
//   %wire_3997 = &"net364" @WIRE(mode="straight") {%p1543 #"I850":5};
//   %p1544 = (256, -148);
//   %p1545 = (280, -148);
//   %wire_3998 = &"net364" @WIRE(mode="straight") {%p1544 %p1545};
//   %p1546 = (124, -148);
//   %wire_3999 = &"net364" @WIRE(mode="straight") {%p1546 #"I854":5};
//   %p1547 = (14, -148);
//   %p1548 = (38, -148);
//   %wire_4000 = &"net364" @WIRE(mode="straight") {%p1547 %p1548};
//   %wire_4001 = &"net364" @WIRE(mode="straight") {%p1541 #"I865":5};
//   %p1549 = (400, -148);
//   %wire_4002 = &"net364" @WIRE(mode="straight") {%p1549 #"I862":2};
//   %p1550 = (62, -148);
//   %wire_4003 = &"net364" @WIRE(mode="straight") {%p1550 %p1540};
//   %wire_4004 = &"net364" @WIRE(mode="straight") {%p1548 %p1550};
//   %p1551 = (304, -148);
//   %wire_4005 = &"net364" @WIRE(mode="straight") {%p1545 %p1551};
//   %wire_4006 = &"net364" @WIRE(mode="straight") {%p1545 #"I868":5};
//   %p1552 = (-20, -148);
//   %wire_4007 = &"net364" @WIRE(mode="straight") {%p1552 #"I1477":2};
//   %p1553 = (328, -148);
//   %wire_4008 = &"net364" @WIRE(mode="straight") {%p1553 #"I866":5};
//   %wire_4009 = &"net364" @WIRE(mode="straight") {%p1551 %p1553};
//   %wire_4010 = &"net364" @WIRE(mode="straight") {%p1551 #"I867":5};
//   %wire_4011 = &"net364" @WIRE(mode="straight") {%p1550 #"I841":5};
//   %wire_4012 = &"net364" @WIRE(mode="straight") {%p1547 #"I839":5};
//   %wire_4013 = &"net364" @WIRE(mode="straight") {%p1542 %p1549};
//   %wire_4014 = &"net364" @WIRE(mode="straight") {%p1544 #"I849":5};
//   %p1554 = (148, -148);
//   %wire_4015 = &"net364" @WIRE(mode="straight") {%p1546 %p1554};
//   %p1555 = (196, -148);
//   %wire_4016 = &"net364" @WIRE(mode="straight") {%p1555 %p1543};
//   %wire_4017 = &"net364" @WIRE(mode="straight") {%p1543 %p1544};
//   %p1556 = (172, -148);
//   %wire_4018 = &"net364" @WIRE(mode="straight") {%p1556 %p1555};
//   %wire_4019 = &"net364" @WIRE(mode="straight") {%p1554 #"I853":5};
//   %wire_4020 = &"net364" @WIRE(mode="straight") {%p1552 %p1547};
//   %wire_4021 = &"net364" @WIRE(mode="straight") {%p1540 %p1546};
//   %wire_4022 = &"net364" @WIRE(mode="straight") {%p1555 #"I851":5};
//   %wire_4023 = &"net364" @WIRE(mode="straight") {%p1554 %p1556};
//   %wire_4024 = &"net364" @WIRE(mode="straight") {%p1556 #"I852":5};
//   %wire_4025 = &"net364" @WIRE(mode="straight") {%p1542 #"I864":5};
//   %wire_4026 = &"net364" @WIRE(mode="straight") {%p1548 #"I840":5};
//   %wire_4027 = &"net364" @WIRE(mode="straight") {%p1553 %p1541};
//   %wire_4028 = &"net364" @WIRE(mode="straight") {%p1549 #"I863":5};
//   %p1557 = (172, -124);
//   %p1558 = (192, -124);
//   %wire_4029 = &"net365" @WIRE(mode="straight") {%p1557 %p1558};
//   %wire_4030 = &"net365" @WIRE(mode="straight") {#"I851":3 %p1558};
//   %p1559 = (194, -124);
//   %wire_4031 = &"net365" @WIRE(mode="straight") {#"I851":6 %p1559};
//   %wire_4032 = &"net365" @WIRE(mode="straight") {%p1558 %p1559};
//   %wire_4033 = &"net365" @WIRE(mode="straight") {#"I852":7 %p1557};
//   %p1560 = (370, -120);
//   %wire_4034 = &"net366" @WIRE(mode="straight") {#"I864":9 %p1560};
//   %p1561 = (346, -120);
//   %wire_4035 = &"net366" @WIRE(mode="straight") {%p1561 %p1560};
//   %p1562 = (142, -120);
//   %wire_4036 = &"net366" @WIRE(mode="straight") {#"I853":9 %p1562};
//   %p1563 = (80, -120);
//   %wire_4037 = &"net366" @WIRE(mode="straight") {#"I842":9 %p1563};
//   %p1564 = (32, -120);
//   %wire_4038 = &"net366" @WIRE(mode="straight") {#"I840":9 %p1564};
//   %p1565 = (394, -120);
//   %wire_4039 = &"net366" @WIRE(mode="straight") {#"I863":9 %p1565};
//   %p1566 = (190, -120);
//   %p1567 = (226, -120);
//   %wire_4040 = &"net366" @WIRE(mode="straight") {%p1566 %p1567};
//   %p1568 = (56, -120);
//   %wire_4041 = &"net366" @WIRE(mode="straight") {%p1564 %p1568};
//   %p1569 = (8, -120);
//   %wire_4042 = &"net366" @WIRE(mode="straight") {#"I839":9 %p1569};
//   %p1570 = (10, -120);
//   %wire_4043 = &"net366" @WIRE(mode="straight") {%p1569 %p1570};
//   %p1571 = (298, -120);
//   %wire_4044 = &"net366" @WIRE(mode="straight") {#"I867":9 %p1571};
//   %p1572 = (166, -120);
//   %wire_4045 = &"net366" @WIRE(mode="straight") {#"I852":9 %p1572};
//   %wire_4046 = &"net366" @WIRE(mode="straight") {#"I865":9 %p1561};
//   %p1573 = (322, -120);
//   %wire_4047 = &"net366" @WIRE(mode="straight") {%p1571 %p1573};
//   %wire_4048 = &"net366" @WIRE(mode="straight") {%p1562 %p1572};
//   %wire_4049 = &"net366" @WIRE(mode="straight") {%p1573 %p1561};
//   %p1574 = (250, -120);
//   %p1575 = (274, -120);
//   %wire_4050 = &"net366" @WIRE(mode="straight") {%p1574 %p1575};
//   %wire_4051 = &"net366" @WIRE(mode="straight") {%p1572 %p1566};
//   %p1576 = (118, -120);
//   %wire_4052 = &"net366" @WIRE(mode="straight") {#"I854":9 %p1576};
//   %wire_4053 = &"net366" @WIRE(mode="straight") {#"I851":9 %p1566};
//   %wire_4054 = &"net366" @WIRE(mode="straight") {%p1570 %p1564};
//   %wire_4055 = &"net366" @WIRE(mode="straight") {%p1576 %p1562};
//   %wire_4056 = &"net366" @WIRE(mode="straight") {%p1567 %p1574};
//   %wire_4057 = &"net366" @WIRE(mode="straight") {#"I849":9 %p1574};
//   %wire_4058 = &"net366" @WIRE(mode="straight") {#"I841":9 %p1568};
//   %wire_4059 = &"net366" @WIRE(mode="straight") {%p1568 %p1563};
//   %wire_4060 = &"net366" @WIRE(mode="straight") {#"I839":3 %p1570};
//   %wire_4061 = &"net366" @WIRE(mode="straight") {%p1560 %p1565};
//   %wire_4062 = &"net366" @WIRE(mode="straight") {%p1563 %p1576};
//   %wire_4063 = &"net366" @WIRE(mode="straight") {#"I850":9 %p1567};
//   %wire_4064 = &"net366" @WIRE(mode="straight") {#"I866":9 %p1573};
//   %wire_4065 = &"net366" @WIRE(mode="straight") {%p1575 %p1571};
//   %wire_4066 = &"net366" @WIRE(mode="straight") {#"I868":9 %p1575};
//   %p1577 = (278, -509);
//   %wire_4067 = &"net300" @WIRE(mode="straight") {#"I1374":6 %p1577};
//   %p1578 = (304, -507);
//   %wire_4068 = &"net300" @WIRE(mode="straight") {%p1577 %p1578};
//   %p1579 = (324, -509);
//   %wire_4069 = &"net300" @WIRE(mode="straight") {#"I1376":3 %p1579};
//   %wire_4070 = &"net300" @WIRE(mode="straight") {#"I1375":7 %p1578};
//   %wire_4071 = &"net300" @WIRE(mode="straight") {%p1579 %p1578};
//   %p1580 = (97, -171);
//   %wire_4072 = &"net368" @WIRE(mode="straight") {#"I1278":4 %p1580};
//   %wire_4073 = &"net368" @WIRE(mode="straight") {#"I1279":4 #"I1278":4};
//   %wire_4074 = &"net368" @WIRE(mode="straight") {#"I1280":4 #"I1279":4};
//   %wire_4075 = &"net368" @WIRE(mode="straight") {#"I1281":4 #"I1280":4};
//   %p1581 = (-18, -171);
//   %wire_4076 = &"net368" @WIRE(mode="straight") {%p1581 #"I1281":4};
//   %p1582 = (-26, -173);
//   %wire_4077 = &"net368" @WIRE(mode="straight") {%p1582 #"I1471":1};
//   %wire_4078 = &"net368" @WIRE(mode="straight") {#"I1471":1 %p1581};
//   %wire_4079 = &"net368" @WIRE(mode="straight") {#"I1474":2 %p1582};
//   %wire_4080 = &"net368" @WIRE(mode="straight") {#"M27":3 %p1580};
//   %wire_4081 = &"net368" @WIRE(mode="straight") {%p1581 #"M69":1};
//   %p1583 = (97, -168);
//   %wire_4082 = &"net368" @WIRE(mode="straight") {%p1583 #"M134":3};
//   %wire_4083 = &"net368" @WIRE(mode="straight") {%p1580 %p1583};
//   %p1584 = (144, -229);
//   %wire_4084 = &"net301" @WIRE(mode="straight") {#"I1301":3 %p1584};
//   %p1585 = (124, -227);
//   %wire_4085 = &"net301" @WIRE(mode="straight") {%p1584 %p1585};
//   %wire_4086 = &"net301" @WIRE(mode="straight") {#"I1300":7 %p1585};
//   %p1586 = (84, -229);
//   %wire_4087 = &"net301" @WIRE(mode="straight") {%p1585 %p1586};
//   %wire_4088 = &"net301" @WIRE(mode="straight") {#"I1295":6 %p1586};
//   %p1587 = (82, -229);
//   %wire_4089 = &"net303" @WIRE(mode="straight") {#"I1295":3 %p1587};
//   %p1588 = (62, -227);
//   %wire_4090 = &"net303" @WIRE(mode="straight") {%p1587 %p1588};
//   %wire_4091 = &"net303" @WIRE(mode="straight") {#"I1296":7 %p1588};
//   %p1589 = (36, -229);
//   %wire_4092 = &"net303" @WIRE(mode="straight") {%p1589 %p1588};
//   %wire_4093 = &"net303" @WIRE(mode="straight") {#"I1297":6 %p1589};
//   %p1590 = (84, -544);
//   %wire_4094 = &"net372" @WIRE(mode="straight") {#"I1082":6 %p1590};
//   %p1591 = (62, -544);
//   %p1592 = (82, -544);
//   %wire_4095 = &"net372" @WIRE(mode="straight") {%p1591 %p1592};
//   %wire_4096 = &"net372" @WIRE(mode="straight") {#"I1082":3 %p1592};
//   %wire_4097 = &"net372" @WIRE(mode="straight") {#"I1081":7 %p1591};
//   %wire_4098 = &"net372" @WIRE(mode="straight") {%p1592 %p1590};
//   %p1593 = (-6, -556);
//   %wire_4099 = &"net373" @WIRE(mode="straight") {%p1593 #"M82":1};
//   %wire_4100 = &"net373" @WIRE(mode="straight") {#"I1520":1 %p1593};
//   %p1594 = (-26, -558);
//   %wire_4101 = &"net373" @WIRE(mode="straight") {%p1594 #"I1520":1};
//   %wire_4102 = &"net373" @WIRE(mode="straight") {#"I1524":2 %p1594};
//   %wire_4103 = &"net373" @WIRE(mode="straight") {#"I1079":4 #"I1080":4};
//   %wire_4104 = &"net373" @WIRE(mode="straight") {#"I1080":4 #"I1081":4};
//   %wire_4105 = &"net373" @WIRE(mode="straight") {%p1593 #"I1079":4};
//   %p1595 = (97, -556);
//   %p1596 = (97, -553);
//   %wire_4106 = &"net373" @WIRE(mode="straight") {%p1595 %p1596};
//   %wire_4107 = &"net373" @WIRE(mode="straight") {#"M38":3 %p1595};
//   %wire_4108 = &"net373" @WIRE(mode="straight") {%p1596 #"M145":3};
//   %wire_4109 = &"net373" @WIRE(mode="straight") {#"I1082":4 %p1595};
//   %wire_4110 = &"net373" @WIRE(mode="straight") {#"I1081":4 #"I1082":4};
//   %p1597 = (120, -544);
//   %p1598 = (122, -544);
//   %wire_4111 = &"net374" @WIRE(mode="straight") {%p1597 %p1598};
//   %p1599 = (86, -544);
//   %wire_4112 = &"net374" @WIRE(mode="straight") {%p1599 %p1597};
//   %wire_4113 = &"net374" @WIRE(mode="straight") {#"I1082":7 %p1599};
//   %wire_4114 = &"net374" @WIRE(mode="straight") {#"I1094":6 %p1598};
//   %wire_4115 = &"net374" @WIRE(mode="straight") {#"I1094":3 %p1597};
//   %p1600 = (86, -227);
//   %wire_4116 = &"net304" @WIRE(mode="straight") {#"I1295":7 %p1600};
//   %p1601 = (120, -229);
//   %wire_4117 = &"net304" @WIRE(mode="straight") {#"I1300":3 %p1601};
//   %wire_4118 = &"net304" @WIRE(mode="straight") {%p1601 %p1600};
//   %p1602 = (60, -229);
//   %wire_4119 = &"net304" @WIRE(mode="straight") {%p1602 %p1600};
//   %wire_4120 = &"net304" @WIRE(mode="straight") {#"I1296":6 %p1602};
//   %p1603 = (350, -474);
//   %wire_4121 = &"net378" @WIRE(mode="straight") {#"I1065":6 %p1603};
//   %p1604 = (328, -474);
//   %wire_4122 = &"net378" @WIRE(mode="straight") {#"I1066":7 %p1604};
//   %p1605 = (348, -474);
//   %wire_4123 = &"net378" @WIRE(mode="straight") {%p1605 %p1603};
//   %wire_4124 = &"net378" @WIRE(mode="straight") {#"I1065":3 %p1605};
//   %wire_4125 = &"net378" @WIRE(mode="straight") {%p1604 %p1605};
//   %p1606 = (-4, -577);
//   %p1607 = (14, -577);
//   %wire_4126 = &"net463" @WIRE(mode="straight") {%p1606 %p1607};
//   %wire_4127 = &"net463" @WIRE(mode="straight") {#"I1518":1 %p1606};
//   %p1608 = (34, -579);
//   %wire_4128 = &"net463" @WIRE(mode="straight") {%p1608 %p1607};
//   %wire_4129 = &"net463" @WIRE(mode="straight") {#"I1383":7 %p1607};
//   %wire_4130 = &"net463" @WIRE(mode="straight") {#"I1382":3 %p1608};
//   %p1609 = (396, -334);
//   %wire_4131 = &"net380" @WIRE(mode="straight") {#"I983":3 %p1609};
//   %p1610 = (376, -334);
//   %wire_4132 = &"net380" @WIRE(mode="straight") {%p1610 %p1609};
//   %p1611 = (398, -334);
//   %wire_4133 = &"net380" @WIRE(mode="straight") {%p1609 %p1611};
//   %wire_4134 = &"net380" @WIRE(mode="straight") {#"I984":7 %p1610};
//   %wire_4135 = &"net380" @WIRE(mode="straight") {#"I983":6 %p1611};
//   %p1612 = (398, -330);
//   %wire_4136 = &"net381" @WIRE(mode="straight") {%p1612 #"I1328":6};
//   %p1613 = (400, -330);
//   %wire_4137 = &"net381" @WIRE(mode="straight") {%p1612 %p1613};
//   %wire_4138 = &"net381" @WIRE(mode="straight") {#"I983":7 %p1613};
//   %p1614 = (58, -229);
//   %wire_4139 = &"net306" @WIRE(mode="straight") {#"I1296":3 %p1614};
//   %p1615 = (38, -227);
//   %wire_4140 = &"net306" @WIRE(mode="straight") {%p1614 %p1615};
//   %wire_4141 = &"net306" @WIRE(mode="straight") {#"I1297":7 %p1615};
//   %p1616 = (12, -229);
//   %wire_4142 = &"net306" @WIRE(mode="straight") {%p1616 %p1615};
//   %wire_4143 = &"net306" @WIRE(mode="straight") {#"I1298":6 %p1616};
//   %p1617 = (124, -334);
//   %p1618 = (144, -334);
//   %wire_4144 = &"net384" @WIRE(mode="straight") {%p1617 %p1618};
//   %wire_4145 = &"net384" @WIRE(mode="straight") {#"I974":7 %p1617};
//   %wire_4146 = &"net384" @WIRE(mode="straight") {#"I973":3 %p1618};
//   %p1619 = (146, -334);
//   %wire_4147 = &"net384" @WIRE(mode="straight") {%p1618 %p1619};
//   %wire_4148 = &"net384" @WIRE(mode="straight") {#"I973":6 %p1619};
//   %p1620 = (302, -124);
//   %wire_4149 = &"net385" @WIRE(mode="straight") {#"I867":6 %p1620};
//   %p1621 = (280, -124);
//   %p1622 = (300, -124);
//   %wire_4150 = &"net385" @WIRE(mode="straight") {%p1621 %p1622};
//   %wire_4151 = &"net385" @WIRE(mode="straight") {#"I867":3 %p1622};
//   %wire_4152 = &"net385" @WIRE(mode="straight") {#"I868":7 %p1621};
//   %wire_4153 = &"net385" @WIRE(mode="straight") {%p1622 %p1620};
//   %p1623 = (326, -124);
//   %wire_4154 = &"net386" @WIRE(mode="straight") {#"I866":6 %p1623};
//   %p1624 = (324, -124);
//   %wire_4155 = &"net386" @WIRE(mode="straight") {#"I866":3 %p1624};
//   %p1625 = (304, -124);
//   %wire_4156 = &"net386" @WIRE(mode="straight") {%p1625 %p1624};
//   %wire_4157 = &"net386" @WIRE(mode="straight") {#"I867":7 %p1625};
//   %wire_4158 = &"net386" @WIRE(mode="straight") {%p1624 %p1623};
//   %p1626 = (396, -124);
//   %wire_4159 = &"net387" @WIRE(mode="straight") {#"I863":3 %p1626};
//   %p1627 = (376, -124);
//   %wire_4160 = &"net387" @WIRE(mode="straight") {%p1627 %p1626};
//   %p1628 = (398, -124);
//   %wire_4161 = &"net387" @WIRE(mode="straight") {%p1626 %p1628};
//   %wire_4162 = &"net387" @WIRE(mode="straight") {#"I863":6 %p1628};
//   %wire_4163 = &"net387" @WIRE(mode="straight") {#"I864":7 %p1627};
//   %p1629 = (144, -369);
//   %wire_4164 = &"net308" @WIRE(mode="straight") {#"I1335":3 %p1629};
//   %p1630 = (124, -367);
//   %p1631 = (84, -369);
//   %wire_4165 = &"net308" @WIRE(mode="straight") {%p1630 %p1631};
//   %wire_4166 = &"net308" @WIRE(mode="straight") {#"I1334":7 %p1630};
//   %wire_4167 = &"net308" @WIRE(mode="straight") {#"I1329":6 %p1631};
//   %wire_4168 = &"net308" @WIRE(mode="straight") {%p1629 %p1630};
//   %wire_4169 = &"net475" @WIRE(mode="straight") {#"I1498":1 #"I1495":2};
//   %p1632 = (124, -124);
//   %wire_4170 = &"net391" @WIRE(mode="straight") {#"I854":7 %p1632};
//   %p1633 = (144, -124);
//   %p1634 = (146, -124);
//   %wire_4171 = &"net391" @WIRE(mode="straight") {%p1633 %p1634};
//   %wire_4172 = &"net391" @WIRE(mode="straight") {#"I853":3 %p1633};
//   %wire_4173 = &"net391" @WIRE(mode="straight") {%p1632 %p1633};
//   %wire_4174 = &"net391" @WIRE(mode="straight") {#"I853":6 %p1634};
//   %p1635 = (232, -124);
//   %wire_4175 = &"net392" @WIRE(mode="straight") {#"I850":7 %p1635};
//   %p1636 = (254, -124);
//   %wire_4176 = &"net392" @WIRE(mode="straight") {#"I849":6 %p1636};
//   %p1637 = (252, -124);
//   %wire_4177 = &"net392" @WIRE(mode="straight") {%p1637 %p1636};
//   %wire_4178 = &"net392" @WIRE(mode="straight") {%p1635 %p1637};
//   %wire_4179 = &"net392" @WIRE(mode="straight") {#"I849":3 %p1637};
//   %p1638 = (276, -124);
//   %p1639 = (278, -124);
//   %wire_4180 = &"net393" @WIRE(mode="straight") {%p1638 %p1639};
//   %p1640 = (256, -124);
//   %wire_4181 = &"net393" @WIRE(mode="straight") {%p1640 %p1638};
//   %wire_4182 = &"net393" @WIRE(mode="straight") {#"I868":3 %p1638};
//   %wire_4183 = &"net393" @WIRE(mode="straight") {#"I849":7 %p1640};
//   %wire_4184 = &"net393" @WIRE(mode="straight") {#"I868":6 %p1639};
//   %p1641 = (280, -437);
//   %wire_4185 = &"net309" @WIRE(mode="straight") {#"I1357":7 %p1641};
//   %p1642 = (300, -439);
//   %wire_4186 = &"net309" @WIRE(mode="straight") {#"I1358":3 %p1642};
//   %p1643 = (254, -439);
//   %wire_4187 = &"net309" @WIRE(mode="straight") {%p1643 %p1641};
//   %wire_4188 = &"net309" @WIRE(mode="straight") {%p1642 %p1641};
//   %wire_4189 = &"net309" @WIRE(mode="straight") {#"I1350":6 %p1643};
//   %p1644 = (58, -544);
//   %p1645 = (60, -544);
//   %wire_4190 = &"net395" @WIRE(mode="straight") {%p1644 %p1645};
//   %wire_4191 = &"net395" @WIRE(mode="straight") {#"I1081":6 %p1645};
//   %wire_4192 = &"net395" @WIRE(mode="straight") {#"I1081":3 %p1644};
//   %p1646 = (38, -544);
//   %wire_4193 = &"net395" @WIRE(mode="straight") {#"I1080":7 %p1646};
//   %wire_4194 = &"net395" @WIRE(mode="straight") {%p1646 %p1644};
//   %p1647 = (215, -451);
//   %wire_4195 = &"net310" @WIRE(mode="straight") {%p1647 #"I1355":4};
//   %p1648 = (215, -454);
//   %wire_4196 = &"net310" @WIRE(mode="straight") {%p1648 %p1647};
//   %wire_4197 = &"net310" @WIRE(mode="straight") {%p1647 #"M160":1};
//   %wire_4198 = &"net310" @WIRE(mode="straight") {#"M53":1 %p1648};
//   %wire_4199 = &"net310" @WIRE(mode="straight") {#"I1355":4 #"I1350":4};
//   %wire_4200 = &"net310" @WIRE(mode="straight") {#"I1360":4 #"I1361":4};
//   %wire_4201 = &"net310" @WIRE(mode="straight") {#"I1358":4 #"I1359":4};
//   %wire_4202 = &"net310" @WIRE(mode="straight") {#"I1359":4 #"I1360":4};
//   %wire_4203 = &"net310" @WIRE(mode="straight") {#"I1361":4 #"I1362":4};
//   %wire_4204 = &"net310" @WIRE(mode="straight") {#"I1350":4 #"I1357":4};
//   %wire_4205 = &"net310" @WIRE(mode="straight") {#"I1357":4 #"I1358":4};
//   %wire_4206 = &"net2209" @WIRE(mode="straight") {#"I1494":3 #"M75":2};
//   %p1649 = (-23, -372);
//   %wire_4207 = &"net2209" @WIRE(mode="straight") {%p1649 #"M75":2};
//   %p1650 = (-23, -335);
//   %wire_4208 = &"net2209" @WIRE(mode="straight") {%p1649 %p1650};
//   %wire_4209 = &"net2209" @WIRE(mode="straight") {%p1650 #"I1501":1};
//   %p1651 = (352, -474);
//   %wire_4210 = &"net399" @WIRE(mode="straight") {#"I1065":7 %p1651};
//   %p1652 = (372, -474);
//   %p1653 = (374, -474);
//   %wire_4211 = &"net399" @WIRE(mode="straight") {%p1652 %p1653};
//   %wire_4212 = &"net399" @WIRE(mode="straight") {#"I1064":6 %p1653};
//   %wire_4213 = &"net399" @WIRE(mode="straight") {%p1651 %p1652};
//   %wire_4214 = &"net399" @WIRE(mode="straight") {#"I1064":3 %p1652};
//   %p1654 = (232, -437);
//   %wire_4215 = &"net312" @WIRE(mode="straight") {#"I1355":7 %p1654};
//   %p1655 = (252, -439);
//   %wire_4216 = &"net312" @WIRE(mode="straight") {%p1655 %p1654};
//   %p1656 = (194, -439);
//   %wire_4217 = &"net312" @WIRE(mode="straight") {%p1656 %p1654};
//   %wire_4218 = &"net312" @WIRE(mode="straight") {#"I1350":3 %p1655};
//   %wire_4219 = &"net312" @WIRE(mode="straight") {#"I1354":6 %p1656};
//   %p1657 = (352, -334);
//   %wire_4220 = &"net401" @WIRE(mode="straight") {#"I985":7 %p1657};
//   %p1658 = (372, -334);
//   %p1659 = (374, -334);
//   %wire_4221 = &"net401" @WIRE(mode="straight") {%p1658 %p1659};
//   %wire_4222 = &"net401" @WIRE(mode="straight") {#"I984":6 %p1659};
//   %wire_4223 = &"net401" @WIRE(mode="straight") {#"I984":3 %p1658};
//   %wire_4224 = &"net401" @WIRE(mode="straight") {%p1657 %p1658};
//   %p1660 = (256, -437);
//   %wire_4225 = &"net314" @WIRE(mode="straight") {#"I1350":7 %p1660};
//   %p1661 = (230, -439);
//   %wire_4226 = &"net314" @WIRE(mode="straight") {#"I1355":6 %p1661};
//   %p1662 = (276, -439);
//   %wire_4227 = &"net314" @WIRE(mode="straight") {%p1662 %p1660};
//   %wire_4228 = &"net314" @WIRE(mode="straight") {#"I1357":3 %p1662};
//   %wire_4229 = &"net314" @WIRE(mode="straight") {%p1661 %p1660};
//   %p1663 = (372, -509);
//   %p1664 = (352, -507);
//   %wire_4230 = &"net315" @WIRE(mode="straight") {%p1663 %p1664};
//   %p1665 = (326, -509);
//   %wire_4231 = &"net315" @WIRE(mode="straight") {%p1665 %p1664};
//   %wire_4232 = &"net315" @WIRE(mode="straight") {#"I1377":7 %p1664};
//   %wire_4233 = &"net315" @WIRE(mode="straight") {#"I1376":6 %p1665};
//   %wire_4234 = &"net315" @WIRE(mode="straight") {#"I1378":3 %p1663};
//   %p1666 = (12, -89);
//   %p1667 = (38, -87);
//   %wire_4235 = &"net316" @WIRE(mode="straight") {%p1666 %p1667};
//   %wire_4236 = &"net316" @WIRE(mode="straight") {#"I1263":7 %p1667};
//   %p1668 = (58, -89);
//   %wire_4237 = &"net316" @WIRE(mode="straight") {#"I1262":3 %p1668};
//   %wire_4238 = &"net316" @WIRE(mode="straight") {%p1668 %p1667};
//   %wire_4239 = &"net316" @WIRE(mode="straight") {#"I1264":6 %p1666};
//   %p1669 = (120, -89);
//   %wire_4240 = &"net320" @WIRE(mode="straight") {#"I1266":3 %p1669};
//   %p1670 = (86, -87);
//   %wire_4241 = &"net320" @WIRE(mode="straight") {%p1669 %p1670};
//   %wire_4242 = &"net320" @WIRE(mode="straight") {#"I1261":7 %p1670};
//   %p1671 = (60, -89);
//   %wire_4243 = &"net320" @WIRE(mode="straight") {%p1671 %p1670};
//   %wire_4244 = &"net320" @WIRE(mode="straight") {#"I1262":6 %p1671};
//   %p1672 = (205, -241);
//   %p1673 = (205, -238);
//   %wire_4245 = &"net321" @WIRE(mode="straight") {%p1672 %p1673};
//   %wire_4246 = &"net321" @WIRE(mode="straight") {%p1673 #"M166":3};
//   %wire_4247 = &"net321" @WIRE(mode="straight") {#"I1300":4 #"I1301":4};
//   %wire_4248 = &"net321" @WIRE(mode="straight") {#"I1301":4 #"I1302":4};
//   %p1674 = (107, -241);
//   %wire_4249 = &"net321" @WIRE(mode="straight") {%p1674 #"M136":1};
//   %p1675 = (107, -244);
//   %wire_4250 = &"net321" @WIRE(mode="straight") {#"M29":1 %p1675};
//   %wire_4251 = &"net321" @WIRE(mode="straight") {%p1674 #"I1300":4};
//   %wire_4252 = &"net321" @WIRE(mode="straight") {#"I1302":4 #"I1303":4};
//   %wire_4253 = &"net321" @WIRE(mode="straight") {#"I1303":4 %p1672};
//   %wire_4254 = &"net321" @WIRE(mode="straight") {#"M59":3 %p1672};
//   %wire_4255 = &"net321" @WIRE(mode="straight") {%p1675 %p1674};
//   %p1676 = (372, -124);
//   %wire_4256 = &"net407" @WIRE(mode="straight") {#"I864":3 %p1676};
//   %p1677 = (352, -124);
//   %wire_4257 = &"net407" @WIRE(mode="straight") {%p1677 %p1676};
//   %p1678 = (374, -124);
//   %wire_4258 = &"net407" @WIRE(mode="straight") {%p1676 %p1678};
//   %wire_4259 = &"net407" @WIRE(mode="straight") {#"I865":7 %p1677};
//   %wire_4260 = &"net407" @WIRE(mode="straight") {#"I864":6 %p1678};
//   %p1679 = (146, -229);
//   %p1680 = (172, -227);
//   %wire_4261 = &"net322" @WIRE(mode="straight") {%p1679 %p1680};
//   %wire_4262 = &"net322" @WIRE(mode="straight") {#"I1301":6 %p1679};
//   %wire_4263 = &"net322" @WIRE(mode="straight") {#"I1302":7 %p1680};
//   %p1681 = (192, -229);
//   %wire_4264 = &"net322" @WIRE(mode="straight") {#"I1303":3 %p1681};
//   %wire_4265 = &"net322" @WIRE(mode="straight") {%p1681 %p1680};
//   %p1682 = (170, -229);
//   %wire_4266 = &"net323" @WIRE(mode="straight") {#"I1302":6 %p1682};
//   %p1683 = (228, -229);
//   %wire_4267 = &"net323" @WIRE(mode="straight") {#"I1304":3 %p1683};
//   %p1684 = (196, -227);
//   %wire_4268 = &"net323" @WIRE(mode="straight") {#"I1303":7 %p1684};
//   %wire_4269 = &"net323" @WIRE(mode="straight") {%p1683 %p1684};
//   %wire_4270 = &"net323" @WIRE(mode="straight") {%p1682 %p1684};
//   %p1685 = (400, -437);
//   %wire_4271 = &"net325" @WIRE(mode="straight") {#"I1362":7 %p1685};
//   %p1686 = (374, -439);
//   %wire_4272 = &"net325" @WIRE(mode="straight") {#"I1361":6 %p1686};
//   %wire_4273 = &"net325" @WIRE(mode="straight") {%p1686 %p1685};
//   %p1687 = (86, -124);
//   %p1688 = (120, -124);
//   %wire_4274 = &"net411" @WIRE(mode="straight") {%p1687 %p1688};
//   %wire_4275 = &"net411" @WIRE(mode="straight") {#"I842":7 %p1687};
//   %p1689 = (122, -124);
//   %wire_4276 = &"net411" @WIRE(mode="straight") {#"I854":6 %p1689};
//   %wire_4277 = &"net411" @WIRE(mode="straight") {%p1688 %p1689};
//   %wire_4278 = &"net411" @WIRE(mode="straight") {#"I854":3 %p1688};
//   %p1690 = (196, -124);
//   %wire_4279 = &"net412" @WIRE(mode="straight") {#"I851":7 %p1690};
//   %p1691 = (230, -124);
//   %wire_4280 = &"net412" @WIRE(mode="straight") {#"I850":6 %p1691};
//   %p1692 = (228, -124);
//   %wire_4281 = &"net412" @WIRE(mode="straight") {%p1690 %p1692};
//   %wire_4282 = &"net412" @WIRE(mode="straight") {%p1692 %p1691};
//   %wire_4283 = &"net412" @WIRE(mode="straight") {#"I850":3 %p1692};
//   %p1693 = (372, -439);
//   %wire_4284 = &"net328" @WIRE(mode="straight") {#"I1361":3 %p1693};
//   %p1694 = (326, -439);
//   %wire_4285 = &"net328" @WIRE(mode="straight") {#"I1359":6 %p1694};
//   %p1695 = (352, -437);
//   %wire_4286 = &"net328" @WIRE(mode="straight") {%p1694 %p1695};
//   %wire_4287 = &"net328" @WIRE(mode="straight") {%p1693 %p1695};
//   %wire_4288 = &"net328" @WIRE(mode="straight") {#"I1360":7 %p1695};
//   %p1696 = (-23, -92);
//   %p1697 = (-23, -55);
//   %wire_4289 = &"net2081" @WIRE(mode="straight") {%p1696 %p1697};
//   %wire_4290 = &"net2081" @WIRE(mode="straight") {%p1696 #"M67":2};
//   %wire_4291 = &"net2081" @WIRE(mode="straight") {#"I1462":3 #"M67":2};
//   %wire_4292 = &"net2081" @WIRE(mode="straight") {%p1697 #"I1469":1};
//   %p1698 = (350, -544);
//   %wire_4293 = &"net415" @WIRE(mode="straight") {#"I1105":6 %p1698};
//   %p1699 = (348, -544);
//   %wire_4294 = &"net415" @WIRE(mode="straight") {%p1699 %p1698};
//   %wire_4295 = &"net415" @WIRE(mode="straight") {#"I1105":3 %p1699};
//   %p1700 = (328, -544);
//   %wire_4296 = &"net415" @WIRE(mode="straight") {%p1700 %p1699};
//   %wire_4297 = &"net415" @WIRE(mode="straight") {#"I1106":7 %p1700};
//   %p1701 = (374, -544);
//   %wire_4298 = &"net416" @WIRE(mode="straight") {#"I1104":6 %p1701};
//   %p1702 = (372, -544);
//   %wire_4299 = &"net416" @WIRE(mode="straight") {%p1702 %p1701};
//   %wire_4300 = &"net416" @WIRE(mode="straight") {#"I1104":3 %p1702};
//   %p1703 = (352, -544);
//   %wire_4301 = &"net416" @WIRE(mode="straight") {%p1703 %p1702};
//   %wire_4302 = &"net416" @WIRE(mode="straight") {#"I1105":7 %p1703};
//   %p1704 = (376, -437);
//   %wire_4303 = &"net330" @WIRE(mode="straight") {#"I1361":7 %p1704};
//   %p1705 = (350, -439);
//   %wire_4304 = &"net330" @WIRE(mode="straight") {#"I1360":6 %p1705};
//   %wire_4305 = &"net330" @WIRE(mode="straight") {%p1705 %p1704};
//   %p1706 = (396, -439);
//   %wire_4306 = &"net330" @WIRE(mode="straight") {%p1706 %p1704};
//   %wire_4307 = &"net330" @WIRE(mode="straight") {#"I1362":3 %p1706};
//   %p1707 = (278, -439);
//   %wire_4308 = &"net331" @WIRE(mode="straight") {#"I1357":6 %p1707};
//   %p1708 = (304, -437);
//   %wire_4309 = &"net331" @WIRE(mode="straight") {%p1707 %p1708};
//   %p1709 = (324, -439);
//   %wire_4310 = &"net331" @WIRE(mode="straight") {#"I1359":3 %p1709};
//   %wire_4311 = &"net331" @WIRE(mode="straight") {%p1709 %p1708};
//   %wire_4312 = &"net331" @WIRE(mode="straight") {#"I1358":7 %p1708};
//   %p1710 = (205, -556);
//   %wire_4313 = &"net419" @WIRE(mode="straight") {#"M50":3 %p1710};
//   %p1711 = (205, -553);
//   %wire_4314 = &"net419" @WIRE(mode="straight") {%p1710 %p1711};
//   %wire_4315 = &"net419" @WIRE(mode="straight") {%p1711 #"M157":3};
//   %p1712 = (107, -559);
//   %wire_4316 = &"net419" @WIRE(mode="straight") {#"M38":1 %p1712};
//   %p1713 = (107, -556);
//   %wire_4317 = &"net419" @WIRE(mode="straight") {%p1713 #"I1094":4};
//   %wire_4318 = &"net419" @WIRE(mode="straight") {#"I1092":4 #"I1091":4};
//   %wire_4319 = &"net419" @WIRE(mode="straight") {#"I1091":4 %p1710};
//   %wire_4320 = &"net419" @WIRE(mode="straight") {#"I1094":4 #"I1093":4};
//   %wire_4321 = &"net419" @WIRE(mode="straight") {#"I1093":4 #"I1092":4};
//   %wire_4322 = &"net419" @WIRE(mode="straight") {%p1712 %p1713};
//   %wire_4323 = &"net419" @WIRE(mode="straight") {%p1713 #"M145":1};
//   %p1714 = (232, -544);
//   %wire_4324 = &"net421" @WIRE(mode="straight") {#"I1090":7 %p1714};
//   %p1715 = (252, -544);
//   %wire_4325 = &"net421" @WIRE(mode="straight") {%p1714 %p1715};
//   %p1716 = (254, -544);
//   %wire_4326 = &"net421" @WIRE(mode="straight") {#"I1089":6 %p1716};
//   %wire_4327 = &"net421" @WIRE(mode="straight") {#"I1089":3 %p1715};
//   %wire_4328 = &"net421" @WIRE(mode="straight") {%p1715 %p1716};
//   %p1717 = (256, -544);
//   %wire_4329 = &"net422" @WIRE(mode="straight") {#"I1089":7 %p1717};
//   %p1718 = (276, -544);
//   %wire_4330 = &"net422" @WIRE(mode="straight") {%p1717 %p1718};
//   %p1719 = (278, -544);
//   %wire_4331 = &"net422" @WIRE(mode="straight") {%p1718 %p1719};
//   %wire_4332 = &"net422" @WIRE(mode="straight") {#"I1108":6 %p1719};
//   %wire_4333 = &"net422" @WIRE(mode="straight") {#"I1108":3 %p1718};
//   %p1720 = (228, -439);
//   %wire_4334 = &"net332" @WIRE(mode="straight") {#"I1355":3 %p1720};
//   %p1721 = (196, -437);
//   %wire_4335 = &"net332" @WIRE(mode="straight") {#"I1354":7 %p1721};
//   %p1722 = (170, -439);
//   %wire_4336 = &"net332" @WIRE(mode="straight") {%p1722 %p1721};
//   %wire_4337 = &"net332" @WIRE(mode="straight") {%p1720 %p1721};
//   %wire_4338 = &"net332" @WIRE(mode="straight") {#"I1353":6 %p1722};
//   %p1723 = (376, -647);
//   %wire_4339 = &"net333" @WIRE(mode="straight") {#"I1412":7 %p1723};
//   %p1724 = (396, -649);
//   %wire_4340 = &"net333" @WIRE(mode="straight") {#"I1413":3 %p1724};
//   %p1725 = (350, -649);
//   %wire_4341 = &"net333" @WIRE(mode="straight") {#"I1411":6 %p1725};
//   %wire_4342 = &"net333" @WIRE(mode="straight") {%p1724 %p1723};
//   %wire_4343 = &"net333" @WIRE(mode="straight") {%p1725 %p1723};
//   %p1726 = (328, -334);
//   %wire_4344 = &"net428" @WIRE(mode="straight") {#"I986":7 %p1726};
//   %p1727 = (348, -334);
//   %wire_4345 = &"net428" @WIRE(mode="straight") {#"I985":3 %p1727};
//   %p1728 = (350, -334);
//   %wire_4346 = &"net428" @WIRE(mode="straight") {%p1727 %p1728};
//   %wire_4347 = &"net428" @WIRE(mode="straight") {%p1726 %p1727};
//   %wire_4348 = &"net428" @WIRE(mode="straight") {#"I985":6 %p1728};
//   %p1729 = (215, -661);
//   %wire_4349 = &"net335" @WIRE(mode="straight") {%p1729 #"I1406":4};
//   %p1730 = (215, -664);
//   %wire_4350 = &"net335" @WIRE(mode="straight") {%p1730 %p1729};
//   %wire_4351 = &"net335" @WIRE(mode="straight") {%p1729 #"M153":1};
//   %wire_4352 = &"net335" @WIRE(mode="straight") {#"I1409":4 #"I1410":4};
//   %wire_4353 = &"net335" @WIRE(mode="straight") {#"I1406":4 #"I1401":4};
//   %wire_4354 = &"net335" @WIRE(mode="straight") {#"I1410":4 #"I1411":4};
//   %wire_4355 = &"net335" @WIRE(mode="straight") {#"I1411":4 #"I1412":4};
//   %wire_4356 = &"net335" @WIRE(mode="straight") {#"I1408":4 #"I1409":4};
//   %wire_4357 = &"net335" @WIRE(mode="straight") {#"I1401":4 #"I1408":4};
//   %wire_4358 = &"net335" @WIRE(mode="straight") {#"M46":1 %p1730};
//   %wire_4359 = &"net335" @WIRE(mode="straight") {#"I1412":4 #"I1413":4};
//   %p1731 = (348, -194);
//   %wire_4360 = &"net430" @WIRE(mode="straight") {#"I905":3 %p1731};
//   %p1732 = (350, -194);
//   %wire_4361 = &"net430" @WIRE(mode="straight") {%p1731 %p1732};
//   %wire_4362 = &"net430" @WIRE(mode="straight") {#"I905":6 %p1732};
//   %p1733 = (328, -194);
//   %wire_4363 = &"net430" @WIRE(mode="straight") {%p1733 %p1731};
//   %wire_4364 = &"net430" @WIRE(mode="straight") {#"I906":7 %p1733};
//   %p1734 = (302, -649);
//   %p1735 = (328, -647);
//   %wire_4365 = &"net336" @WIRE(mode="straight") {%p1734 %p1735};
//   %wire_4366 = &"net336" @WIRE(mode="straight") {#"I1409":6 %p1734};
//   %p1736 = (348, -649);
//   %wire_4367 = &"net336" @WIRE(mode="straight") {#"I1411":3 %p1736};
//   %wire_4368 = &"net336" @WIRE(mode="straight") {#"I1410":7 %p1735};
//   %wire_4369 = &"net336" @WIRE(mode="straight") {%p1736 %p1735};
//   %p1737 = (326, -649);
//   %p1738 = (352, -647);
//   %wire_4370 = &"net343" @WIRE(mode="straight") {%p1737 %p1738};
//   %p1739 = (372, -649);
//   %wire_4371 = &"net343" @WIRE(mode="straight") {%p1739 %p1738};
//   %wire_4372 = &"net343" @WIRE(mode="straight") {#"I1412":3 %p1739};
//   %wire_4373 = &"net343" @WIRE(mode="straight") {#"I1410":6 %p1737};
//   %wire_4374 = &"net343" @WIRE(mode="straight") {#"I1411":7 %p1738};
//   %p1740 = (252, -194);
//   %wire_4375 = &"net434" @WIRE(mode="straight") {#"I889":3 %p1740};
//   %p1741 = (232, -194);
//   %wire_4376 = &"net434" @WIRE(mode="straight") {%p1741 %p1740};
//   %p1742 = (254, -194);
//   %wire_4377 = &"net434" @WIRE(mode="straight") {%p1740 %p1742};
//   %wire_4378 = &"net434" @WIRE(mode="straight") {#"I890":7 %p1741};
//   %wire_4379 = &"net434" @WIRE(mode="straight") {#"I889":6 %p1742};
//   %p1743 = (256, -194);
//   %wire_4380 = &"net435" @WIRE(mode="straight") {#"I889":7 %p1743};
//   %p1744 = (276, -194);
//   %wire_4381 = &"net435" @WIRE(mode="straight") {#"I908":3 %p1744};
//   %p1745 = (278, -194);
//   %wire_4382 = &"net435" @WIRE(mode="straight") {%p1744 %p1745};
//   %wire_4383 = &"net435" @WIRE(mode="straight") {#"I908":6 %p1745};
//   %wire_4384 = &"net435" @WIRE(mode="straight") {%p1743 %p1744};
//   %p1746 = (194, -649);
//   %p1747 = (232, -647);
//   %wire_4385 = &"net344" @WIRE(mode="straight") {%p1746 %p1747};
//   %wire_4386 = &"net344" @WIRE(mode="straight") {#"I1405":6 %p1746};
//   %p1748 = (252, -649);
//   %wire_4387 = &"net344" @WIRE(mode="straight") {%p1748 %p1747};
//   %wire_4388 = &"net344" @WIRE(mode="straight") {#"I1401":3 %p1748};
//   %wire_4389 = &"net344" @WIRE(mode="straight") {#"I1406":7 %p1747};
//   %p1749 = (205, -661);
//   %wire_4390 = &"net345" @WIRE(mode="straight") {#"M46":3 %p1749};
//   %p1750 = (205, -658);
//   %wire_4391 = &"net345" @WIRE(mode="straight") {%p1749 %p1750};
//   %wire_4392 = &"net345" @WIRE(mode="straight") {%p1750 #"M153":3};
//   %wire_4393 = &"net345" @WIRE(mode="straight") {#"I1403":4 #"I1404":4};
//   %wire_4394 = &"net345" @WIRE(mode="straight") {#"I1402":4 #"I1403":4};
//   %p1751 = (107, -661);
//   %wire_4395 = &"net345" @WIRE(mode="straight") {%p1751 #"M148":1};
//   %p1752 = (107, -664);
//   %wire_4396 = &"net345" @WIRE(mode="straight") {%p1752 %p1751};
//   %wire_4397 = &"net345" @WIRE(mode="straight") {%p1751 #"I1402":4};
//   %wire_4398 = &"net345" @WIRE(mode="straight") {#"I1405":4 %p1749};
//   %wire_4399 = &"net345" @WIRE(mode="straight") {#"I1404":4 #"I1405":4};
//   %wire_4400 = &"net345" @WIRE(mode="straight") {#"M41":1 %p1752};
//   %p1753 = (146, -649);
//   %wire_4401 = &"net346" @WIRE(mode="straight") {#"I1403":6 %p1753};
//   %p1754 = (192, -649);
//   %wire_4402 = &"net346" @WIRE(mode="straight") {#"I1405":3 %p1754};
//   %p1755 = (172, -647);
//   %wire_4403 = &"net346" @WIRE(mode="straight") {#"I1404":7 %p1755};
//   %wire_4404 = &"net346" @WIRE(mode="straight") {%p1753 %p1755};
//   %wire_4405 = &"net346" @WIRE(mode="straight") {%p1754 %p1755};
//   %p1756 = (230, -19);
//   %wire_4406 = &"net46" @WIRE(mode="straight") {#"I777":6 %p1756};
//   %p1757 = (276, -19);
//   %p1758 = (256, -17);
//   %wire_4407 = &"net46" @WIRE(mode="straight") {%p1757 %p1758};
//   %wire_4408 = &"net46" @WIRE(mode="straight") {%p1756 %p1758};
//   %wire_4409 = &"net46" @WIRE(mode="straight") {#"I776":7 %p1758};
//   %wire_4410 = &"net46" @WIRE(mode="straight") {#"I788":3 %p1757};
//   %p1759 = (170, -649);
//   %p1760 = (196, -647);
//   %wire_4411 = &"net348" @WIRE(mode="straight") {%p1759 %p1760};
//   %wire_4412 = &"net348" @WIRE(mode="straight") {#"I1404":6 %p1759};
//   %wire_4413 = &"net348" @WIRE(mode="straight") {#"I1405":7 %p1760};
//   %p1761 = (228, -649);
//   %wire_4414 = &"net348" @WIRE(mode="straight") {%p1761 %p1760};
//   %wire_4415 = &"net348" @WIRE(mode="straight") {#"I1406":3 %p1761};
//   %p1762 = (324, -54);
//   %wire_4416 = &"net443" @WIRE(mode="straight") {#"I826":3 %p1762};
//   %p1763 = (326, -54);
//   %wire_4417 = &"net443" @WIRE(mode="straight") {%p1762 %p1763};
//   %wire_4418 = &"net443" @WIRE(mode="straight") {#"I826":6 %p1763};
//   %p1764 = (304, -54);
//   %wire_4419 = &"net443" @WIRE(mode="straight") {#"I827":7 %p1764};
//   %wire_4420 = &"net443" @WIRE(mode="straight") {%p1764 %p1762};
//   %p1765 = (215, -66);
//   %wire_4421 = &"net444" @WIRE(mode="straight") {%p1765 #"I810":4};
//   %p1766 = (215, -69);
//   %wire_4422 = &"net444" @WIRE(mode="straight") {%p1766 %p1765};
//   %wire_4423 = &"net444" @WIRE(mode="straight") {%p1765 #"M171":1};
//   %wire_4424 = &"net444" @WIRE(mode="straight") {#"M64":1 %p1766};
//   %wire_4425 = &"net444" @WIRE(mode="straight") {#"I826":4 #"I825":4};
//   %wire_4426 = &"net444" @WIRE(mode="straight") {#"I809":4 #"I828":4};
//   %wire_4427 = &"net444" @WIRE(mode="straight") {#"I825":4 #"I824":4};
//   %wire_4428 = &"net444" @WIRE(mode="straight") {#"I824":4 #"I823":4};
//   %wire_4429 = &"net444" @WIRE(mode="straight") {#"I827":4 #"I826":4};
//   %wire_4430 = &"net444" @WIRE(mode="straight") {#"I828":4 #"I827":4};
//   %wire_4431 = &"net444" @WIRE(mode="straight") {#"I810":4 #"I809":4};
//   %p1767 = (400, -78);
//   %wire_4432 = &"net445" @WIRE(mode="straight") {%p1767 #"I823":5};
//   %p1768 = (376, -78);
//   %wire_4433 = &"net445" @WIRE(mode="straight") {%p1768 %p1767};
//   %p1769 = (232, -78);
//   %wire_4434 = &"net445" @WIRE(mode="straight") {%p1769 #"I810":5};
//   %p1770 = (124, -78);
//   %p1771 = (148, -78);
//   %wire_4435 = &"net445" @WIRE(mode="straight") {%p1770 %p1771};
//   %p1772 = (256, -78);
//   %p1773 = (280, -78);
//   %wire_4436 = &"net445" @WIRE(mode="straight") {%p1772 %p1773};
//   %wire_4437 = &"net445" @WIRE(mode="straight") {%p1768 #"I824":5};
//   %p1774 = (352, -78);
//   %wire_4438 = &"net445" @WIRE(mode="straight") {%p1774 #"I825":5};
//   %p1775 = (-20, -78);
//   %wire_4439 = &"net445" @WIRE(mode="straight") {%p1775 #"I1469":2};
//   %p1776 = (14, -78);
//   %p1777 = (38, -78);
//   %wire_4440 = &"net445" @WIRE(mode="straight") {%p1776 %p1777};
//   %wire_4441 = &"net445" @WIRE(mode="straight") {%p1775 %p1776};
//   %wire_4442 = &"net445" @WIRE(mode="straight") {%p1772 #"I809":5};
//   %p1778 = (328, -78);
//   %wire_4443 = &"net445" @WIRE(mode="straight") {%p1778 #"I826":5};
//   %p1779 = (304, -78);
//   %wire_4444 = &"net445" @WIRE(mode="straight") {%p1779 #"I827":5};
//   %wire_4445 = &"net445" @WIRE(mode="straight") {%p1769 %p1772};
//   %p1780 = (196, -78);
//   %wire_4446 = &"net445" @WIRE(mode="straight") {%p1780 #"I811":5};
//   %p1781 = (86, -78);
//   %wire_4447 = &"net445" @WIRE(mode="straight") {%p1781 #"I802":5};
//   %wire_4448 = &"net445" @WIRE(mode="straight") {%p1773 #"I828":5};
//   %wire_4449 = &"net445" @WIRE(mode="straight") {%p1781 %p1770};
//   %p1782 = (62, -78);
//   %wire_4450 = &"net445" @WIRE(mode="straight") {%p1782 %p1781};
//   %wire_4451 = &"net445" @WIRE(mode="straight") {%p1782 #"I801":5};
//   %wire_4452 = &"net445" @WIRE(mode="straight") {%p1780 %p1769};
//   %p1783 = (172, -78);
//   %wire_4453 = &"net445" @WIRE(mode="straight") {%p1783 #"I812":5};
//   %wire_4454 = &"net445" @WIRE(mode="straight") {%p1783 %p1780};
//   %wire_4455 = &"net445" @WIRE(mode="straight") {%p1773 %p1779};
//   %wire_4456 = &"net445" @WIRE(mode="straight") {%p1771 %p1783};
//   %wire_4457 = &"net445" @WIRE(mode="straight") {%p1777 %p1782};
//   %wire_4458 = &"net445" @WIRE(mode="straight") {%p1771 #"I813":5};
//   %wire_4459 = &"net445" @WIRE(mode="straight") {%p1774 %p1768};
//   %wire_4460 = &"net445" @WIRE(mode="straight") {%p1770 #"I814":5};
//   %wire_4461 = &"net445" @WIRE(mode="straight") {%p1779 %p1778};
//   %wire_4462 = &"net445" @WIRE(mode="straight") {%p1777 #"I800":5};
//   %wire_4463 = &"net445" @WIRE(mode="straight") {%p1776 #"I799":5};
//   %wire_4464 = &"net445" @WIRE(mode="straight") {%p1778 %p1774};
//   %wire_4465 = &"net445" @WIRE(mode="straight") {%p1767 #"I822":2};
//   %p1784 = (328, -54);
//   %wire_4466 = &"net446" @WIRE(mode="straight") {#"I826":7 %p1784};
//   %p1785 = (348, -54);
//   %wire_4467 = &"net446" @WIRE(mode="straight") {%p1784 %p1785};
//   %p1786 = (350, -54);
//   %wire_4468 = &"net446" @WIRE(mode="straight") {%p1785 %p1786};
//   %wire_4469 = &"net446" @WIRE(mode="straight") {#"I825":6 %p1786};
//   %wire_4470 = &"net446" @WIRE(mode="straight") {#"I825":3 %p1785};
//   %p1787 = (298, -50);
//   %wire_4471 = &"net447" @WIRE(mode="straight") {#"I827":9 %p1787};
//   %p1788 = (142, -50);
//   %p1789 = (166, -50);
//   %wire_4472 = &"net447" @WIRE(mode="straight") {%p1788 %p1789};
//   %wire_4473 = &"net447" @WIRE(mode="straight") {#"I812":9 %p1789};
//   %p1790 = (274, -50);
//   %wire_4474 = &"net447" @WIRE(mode="straight") {%p1790 %p1787};
//   %p1791 = (190, -50);
//   %wire_4475 = &"net447" @WIRE(mode="straight") {#"I811":9 %p1791};
//   %p1792 = (8, -50);
//   %wire_4476 = &"net447" @WIRE(mode="straight") {#"I799":9 %p1792};
//   %p1793 = (80, -50);
//   %p1794 = (118, -50);
//   %wire_4477 = &"net447" @WIRE(mode="straight") {%p1793 %p1794};
//   %p1795 = (32, -50);
//   %wire_4478 = &"net447" @WIRE(mode="straight") {#"I800":9 %p1795};
//   %p1796 = (226, -50);
//   %wire_4479 = &"net447" @WIRE(mode="straight") {#"I810":9 %p1796};
//   %wire_4480 = &"net447" @WIRE(mode="straight") {%p1794 %p1788};
//   %wire_4481 = &"net447" @WIRE(mode="straight") {#"I802":9 %p1793};
//   %p1797 = (56, -50);
//   %wire_4482 = &"net447" @WIRE(mode="straight") {%p1795 %p1797};
//   %wire_4483 = &"net447" @WIRE(mode="straight") {#"I801":9 %p1797};
//   %wire_4484 = &"net447" @WIRE(mode="straight") {%p1797 %p1793};
//   %p1798 = (250, -50);
//   %wire_4485 = &"net447" @WIRE(mode="straight") {#"I809":9 %p1798};
//   %p1799 = (322, -50);
//   %p1800 = (346, -50);
//   %wire_4486 = &"net447" @WIRE(mode="straight") {%p1799 %p1800};
//   %p1801 = (10, -50);
//   %wire_4487 = &"net447" @WIRE(mode="straight") {%p1801 %p1795};
//   %wire_4488 = &"net447" @WIRE(mode="straight") {%p1792 %p1801};
//   %wire_4489 = &"net447" @WIRE(mode="straight") {#"I825":9 %p1800};
//   %wire_4490 = &"net447" @WIRE(mode="straight") {#"I813":9 %p1788};
//   %wire_4491 = &"net447" @WIRE(mode="straight") {#"I799":3 %p1801};
//   %p1802 = (370, -50);
//   %p1803 = (394, -50);
//   %wire_4492 = &"net447" @WIRE(mode="straight") {%p1802 %p1803};
//   %wire_4493 = &"net447" @WIRE(mode="straight") {#"I823":9 %p1803};
//   %wire_4494 = &"net447" @WIRE(mode="straight") {%p1798 %p1790};
//   %wire_4495 = &"net447" @WIRE(mode="straight") {%p1791 %p1796};
//   %wire_4496 = &"net447" @WIRE(mode="straight") {#"I824":9 %p1802};
//   %wire_4497 = &"net447" @WIRE(mode="straight") {#"I814":9 %p1794};
//   %wire_4498 = &"net447" @WIRE(mode="straight") {%p1800 %p1802};
//   %wire_4499 = &"net447" @WIRE(mode="straight") {%p1787 %p1799};
//   %wire_4500 = &"net447" @WIRE(mode="straight") {#"I828":9 %p1790};
//   %wire_4501 = &"net447" @WIRE(mode="straight") {#"I826":9 %p1799};
//   %wire_4502 = &"net447" @WIRE(mode="straight") {%p1796 %p1798};
//   %wire_4503 = &"net447" @WIRE(mode="straight") {%p1789 %p1791};
//   %p1804 = (372, -54);
//   %wire_4504 = &"net448" @WIRE(mode="straight") {#"I824":3 %p1804};
//   %p1805 = (352, -54);
//   %wire_4505 = &"net448" @WIRE(mode="straight") {#"I825":7 %p1805};
//   %p1806 = (374, -54);
//   %wire_4506 = &"net448" @WIRE(mode="straight") {#"I824":6 %p1806};
//   %wire_4507 = &"net448" @WIRE(mode="straight") {%p1804 %p1806};
//   %wire_4508 = &"net448" @WIRE(mode="straight") {%p1805 %p1804};
//   %p1807 = (396, -54);
//   %wire_4509 = &"net449" @WIRE(mode="straight") {#"I823":3 %p1807};
//   %p1808 = (398, -54);
//   %wire_4510 = &"net449" @WIRE(mode="straight") {%p1807 %p1808};
//   %wire_4511 = &"net449" @WIRE(mode="straight") {#"I823":6 %p1808};
//   %p1809 = (376, -54);
//   %wire_4512 = &"net449" @WIRE(mode="straight") {%p1809 %p1807};
//   %wire_4513 = &"net449" @WIRE(mode="straight") {#"I824":7 %p1809};
//   %wire_4514 = &"net452" @WIRE(mode="straight") {#"I1264":4 #"I1263":4};
//   %wire_4515 = &"net452" @WIRE(mode="straight") {#"I1263":4 #"I1262":4};
//   %p1810 = (97, -101);
//   %wire_4516 = &"net452" @WIRE(mode="straight") {#"I1261":4 %p1810};
//   %wire_4517 = &"net452" @WIRE(mode="straight") {#"I1262":4 #"I1261":4};
//   %p1811 = (-26, -103);
//   %wire_4518 = &"net452" @WIRE(mode="straight") {#"I1466":2 %p1811};
//   %wire_4519 = &"net452" @WIRE(mode="straight") {#"M25":3 %p1810};
//   %p1812 = (97, -98);
//   %wire_4520 = &"net452" @WIRE(mode="straight") {%p1810 %p1812};
//   %p1813 = (-18, -101);
//   %wire_4521 = &"net452" @WIRE(mode="straight") {%p1813 #"M67":1};
//   %wire_4522 = &"net452" @WIRE(mode="straight") {#"I1463":1 %p1813};
//   %wire_4523 = &"net452" @WIRE(mode="straight") {%p1811 #"I1463":1};
//   %wire_4524 = &"net452" @WIRE(mode="straight") {%p1813 #"I1264":4};
//   %wire_4525 = &"net452" @WIRE(mode="straight") {%p1812 #"M132":3};
//   %p1814 = (168, -229);
//   %wire_4526 = &"net351" @WIRE(mode="straight") {#"I1302":3 %p1814};
//   %p1815 = (148, -227);
//   %wire_4527 = &"net351" @WIRE(mode="straight") {%p1814 %p1815};
//   %wire_4528 = &"net351" @WIRE(mode="straight") {#"I1301":7 %p1815};
//   %p1816 = (122, -229);
//   %wire_4529 = &"net351" @WIRE(mode="straight") {%p1816 %p1815};
//   %wire_4530 = &"net351" @WIRE(mode="straight") {#"I1300":6 %p1816};
//   %p1817 = (348, -439);
//   %wire_4531 = &"net353" @WIRE(mode="straight") {#"I1360":3 %p1817};
//   %p1818 = (328, -437);
//   %wire_4532 = &"net353" @WIRE(mode="straight") {%p1817 %p1818};
//   %p1819 = (302, -439);
//   %wire_4533 = &"net353" @WIRE(mode="straight") {#"I1358":6 %p1819};
//   %wire_4534 = &"net353" @WIRE(mode="straight") {#"I1359":7 %p1818};
//   %wire_4535 = &"net353" @WIRE(mode="straight") {%p1819 %p1818};
//   %p1820 = (400, -647);
//   %wire_4536 = &"net354" @WIRE(mode="straight") {#"I1413":7 %p1820};
//   %p1821 = (374, -649);
//   %wire_4537 = &"net354" @WIRE(mode="straight") {%p1821 %p1820};
//   %wire_4538 = &"net354" @WIRE(mode="straight") {#"I1412":6 %p1821};
//   %p1822 = (278, -649);
//   %wire_4539 = &"net355" @WIRE(mode="straight") {#"I1408":6 %p1822};
//   %p1823 = (324, -649);
//   %p1824 = (304, -647);
//   %wire_4540 = &"net355" @WIRE(mode="straight") {%p1823 %p1824};
//   %wire_4541 = &"net355" @WIRE(mode="straight") {#"I1410":3 %p1823};
//   %wire_4542 = &"net355" @WIRE(mode="straight") {#"I1409":7 %p1824};
//   %wire_4543 = &"net355" @WIRE(mode="straight") {%p1822 %p1824};
//   %p1825 = (230, -649);
//   %p1826 = (256, -647);
//   %wire_4544 = &"net356" @WIRE(mode="straight") {%p1825 %p1826};
//   %p1827 = (276, -649);
//   %wire_4545 = &"net356" @WIRE(mode="straight") {#"I1408":3 %p1827};
//   %wire_4546 = &"net356" @WIRE(mode="straight") {#"I1406":6 %p1825};
//   %wire_4547 = &"net356" @WIRE(mode="straight") {%p1827 %p1826};
//   %wire_4548 = &"net356" @WIRE(mode="straight") {#"I1401":7 %p1826};
//   %p1828 = (-26, -68);
//   %wire_4549 = &"net464" @WIRE(mode="straight") {%p1828 #"I1464":1};
//   %wire_4550 = &"net464" @WIRE(mode="straight") {#"I1468":2 %p1828};
//   %p1829 = (-6, -66);
//   %wire_4551 = &"net464" @WIRE(mode="straight") {%p1829 #"M68":1};
//   %wire_4552 = &"net464" @WIRE(mode="straight") {#"I1464":1 %p1829};
//   %wire_4553 = &"net464" @WIRE(mode="straight") {#"I799":4 #"I800":4};
//   %wire_4554 = &"net464" @WIRE(mode="straight") {%p1829 #"I799":4};
//   %wire_4555 = &"net464" @WIRE(mode="straight") {#"I800":4 #"I801":4};
//   %p1830 = (97, -66);
//   %wire_4556 = &"net464" @WIRE(mode="straight") {#"I802":4 %p1830};
//   %p1831 = (97, -63);
//   %wire_4557 = &"net464" @WIRE(mode="straight") {%p1831 #"M131":3};
//   %wire_4558 = &"net464" @WIRE(mode="straight") {%p1830 %p1831};
//   %wire_4559 = &"net464" @WIRE(mode="straight") {#"M24":3 %p1830};
//   %wire_4560 = &"net464" @WIRE(mode="straight") {#"I801":4 #"I802":4};
//   %p1832 = (36, -54);
//   %wire_4561 = &"net465" @WIRE(mode="straight") {#"I800":6 %p1832};
//   %p1833 = (14, -54);
//   %p1834 = (34, -54);
//   %wire_4562 = &"net465" @WIRE(mode="straight") {%p1833 %p1834};
//   %wire_4563 = &"net465" @WIRE(mode="straight") {#"I800":3 %p1834};
//   %wire_4564 = &"net465" @WIRE(mode="straight") {%p1834 %p1832};
//   %wire_4565 = &"net465" @WIRE(mode="straight") {#"I799":7 %p1833};
//   %p1835 = (38, -54);
//   %wire_4566 = &"net466" @WIRE(mode="straight") {#"I800":7 %p1835};
//   %p1836 = (58, -54);
//   %p1837 = (60, -54);
//   %wire_4567 = &"net466" @WIRE(mode="straight") {%p1836 %p1837};
//   %wire_4568 = &"net466" @WIRE(mode="straight") {#"I801":6 %p1837};
//   %wire_4569 = &"net466" @WIRE(mode="straight") {%p1835 %p1836};
//   %wire_4570 = &"net466" @WIRE(mode="straight") {#"I801":3 %p1836};
//   %p1838 = (84, -54);
//   %wire_4571 = &"net467" @WIRE(mode="straight") {#"I802":6 %p1838};
//   %p1839 = (82, -54);
//   %wire_4572 = &"net467" @WIRE(mode="straight") {#"I802":3 %p1839};
//   %p1840 = (62, -54);
//   %wire_4573 = &"net467" @WIRE(mode="straight") {%p1840 %p1839};
//   %wire_4574 = &"net467" @WIRE(mode="straight") {#"I801":7 %p1840};
//   %wire_4575 = &"net467" @WIRE(mode="straight") {%p1839 %p1838};
//   %p1841 = (86, -54);
//   %p1842 = (120, -54);
//   %wire_4576 = &"net468" @WIRE(mode="straight") {%p1841 %p1842};
//   %p1843 = (122, -54);
//   %wire_4577 = &"net468" @WIRE(mode="straight") {#"I814":6 %p1843};
//   %wire_4578 = &"net468" @WIRE(mode="straight") {#"I814":3 %p1842};
//   %wire_4579 = &"net468" @WIRE(mode="straight") {#"I802":7 %p1841};
//   %wire_4580 = &"net468" @WIRE(mode="straight") {%p1842 %p1843};
//   %p1844 = (254, -649);
//   %p1845 = (280, -647);
//   %wire_4581 = &"net357" @WIRE(mode="straight") {%p1844 %p1845};
//   %wire_4582 = &"net357" @WIRE(mode="straight") {#"I1401":6 %p1844};
//   %p1846 = (300, -649);
//   %wire_4583 = &"net357" @WIRE(mode="straight") {#"I1409":3 %p1846};
//   %wire_4584 = &"net357" @WIRE(mode="straight") {#"I1408":7 %p1845};
//   %wire_4585 = &"net357" @WIRE(mode="straight") {%p1846 %p1845};
//   %p1847 = (144, -509);
//   %wire_4586 = &"net358" @WIRE(mode="straight") {#"I1369":3 %p1847};
//   %p1848 = (124, -507);
//   %wire_4587 = &"net358" @WIRE(mode="straight") {%p1847 %p1848};
//   %wire_4588 = &"net358" @WIRE(mode="straight") {#"I1368":7 %p1848};
//   %p1849 = (84, -509);
//   %wire_4589 = &"net358" @WIRE(mode="straight") {%p1848 %p1849};
//   %wire_4590 = &"net358" @WIRE(mode="straight") {#"I1363":6 %p1849};
//   %p1850 = (36, -509);
//   %p1851 = (62, -507);
//   %wire_4591 = &"net359" @WIRE(mode="straight") {%p1850 %p1851};
//   %wire_4592 = &"net359" @WIRE(mode="straight") {#"I1365":6 %p1850};
//   %p1852 = (82, -509);
//   %wire_4593 = &"net359" @WIRE(mode="straight") {%p1852 %p1851};
//   %wire_4594 = &"net359" @WIRE(mode="straight") {#"I1364":7 %p1851};
//   %wire_4595 = &"net359" @WIRE(mode="straight") {#"I1363":3 %p1852};
//   %p1853 = (120, -509);
//   %p1854 = (86, -507);
//   %wire_4596 = &"net362" @WIRE(mode="straight") {%p1853 %p1854};
//   %p1855 = (60, -509);
//   %wire_4597 = &"net362" @WIRE(mode="straight") {%p1855 %p1854};
//   %wire_4598 = &"net362" @WIRE(mode="straight") {#"I1364":6 %p1855};
//   %wire_4599 = &"net362" @WIRE(mode="straight") {#"I1363":7 %p1854};
//   %wire_4600 = &"net362" @WIRE(mode="straight") {#"I1368":3 %p1853};
//   %p1856 = (205, -451);
//   %p1857 = (205, -448);
//   %wire_4601 = &"net367" @WIRE(mode="straight") {%p1856 %p1857};
//   %wire_4602 = &"net367" @WIRE(mode="straight") {#"M53":3 %p1856};
//   %wire_4603 = &"net367" @WIRE(mode="straight") {%p1857 #"M160":3};
//   %wire_4604 = &"net367" @WIRE(mode="straight") {#"I1353":4 #"I1354":4};
//   %p1858 = (107, -454);
//   %wire_4605 = &"net367" @WIRE(mode="straight") {#"M35":1 %p1858};
//   %wire_4606 = &"net367" @WIRE(mode="straight") {#"I1352":4 #"I1353":4};
//   %p1859 = (107, -451);
//   %wire_4607 = &"net367" @WIRE(mode="straight") {%p1859 #"I1351":4};
//   %wire_4608 = &"net367" @WIRE(mode="straight") {%p1859 #"M142":1};
//   %wire_4609 = &"net367" @WIRE(mode="straight") {%p1858 %p1859};
//   %wire_4610 = &"net367" @WIRE(mode="straight") {#"I1351":4 #"I1352":4};
//   %wire_4611 = &"net367" @WIRE(mode="straight") {#"I1354":4 %p1856};
//   %p1860 = (168, -439);
//   %p1861 = (148, -437);
//   %wire_4612 = &"net369" @WIRE(mode="straight") {%p1860 %p1861};
//   %p1862 = (122, -439);
//   %wire_4613 = &"net369" @WIRE(mode="straight") {#"I1351":6 %p1862};
//   %wire_4614 = &"net369" @WIRE(mode="straight") {#"I1352":7 %p1861};
//   %wire_4615 = &"net369" @WIRE(mode="straight") {#"I1353":3 %p1860};
//   %wire_4616 = &"net369" @WIRE(mode="straight") {%p1862 %p1861};
//   %p1863 = (172, -437);
//   %wire_4617 = &"net370" @WIRE(mode="straight") {#"I1353":7 %p1863};
//   %p1864 = (146, -439);
//   %wire_4618 = &"net370" @WIRE(mode="straight") {#"I1352":6 %p1864};
//   %p1865 = (192, -439);
//   %wire_4619 = &"net370" @WIRE(mode="straight") {#"I1354":3 %p1865};
//   %wire_4620 = &"net370" @WIRE(mode="straight") {%p1864 %p1863};
//   %wire_4621 = &"net370" @WIRE(mode="straight") {%p1865 %p1863};
//   %p1866 = (300, -54);
//   %p1867 = (302, -54);
//   %wire_4622 = &"net476" @WIRE(mode="straight") {%p1866 %p1867};
//   %wire_4623 = &"net476" @WIRE(mode="straight") {#"I827":6 %p1867};
//   %p1868 = (280, -54);
//   %wire_4624 = &"net476" @WIRE(mode="straight") {%p1868 %p1866};
//   %wire_4625 = &"net476" @WIRE(mode="straight") {#"I827":3 %p1866};
//   %wire_4626 = &"net476" @WIRE(mode="straight") {#"I828":7 %p1868};
//   %p1869 = (256, -54);
//   %wire_4627 = &"net477" @WIRE(mode="straight") {#"I809":7 %p1869};
//   %p1870 = (276, -54);
//   %wire_4628 = &"net477" @WIRE(mode="straight") {#"I828":3 %p1870};
//   %wire_4629 = &"net477" @WIRE(mode="straight") {%p1869 %p1870};
//   %p1871 = (278, -54);
//   %wire_4630 = &"net477" @WIRE(mode="straight") {%p1870 %p1871};
//   %wire_4631 = &"net477" @WIRE(mode="straight") {#"I828":6 %p1871};
//   %p1872 = (398, -260);
//   %p1873 = (400, -260);
//   %wire_4632 = &"net376" @WIRE(mode="straight") {%p1872 %p1873};
//   %wire_4633 = &"net376" @WIRE(mode="straight") {%p1872 #"I1311":6};
//   %wire_4634 = &"net376" @WIRE(mode="straight") {#"I943":7 %p1873};
//   %p1874 = (350, -229);
//   %wire_4635 = &"net379" @WIRE(mode="straight") {#"I1309":6 %p1874};
//   %p1875 = (396, -229);
//   %p1876 = (376, -227);
//   %wire_4636 = &"net379" @WIRE(mode="straight") {%p1875 %p1876};
//   %wire_4637 = &"net379" @WIRE(mode="straight") {%p1874 %p1876};
//   %wire_4638 = &"net379" @WIRE(mode="straight") {#"I1311":3 %p1875};
//   %wire_4639 = &"net379" @WIRE(mode="straight") {#"I1310":7 %p1876};
//   %p1877 = (374, -229);
//   %p1878 = (400, -227);
//   %wire_4640 = &"net382" @WIRE(mode="straight") {%p1877 %p1878};
//   %wire_4641 = &"net382" @WIRE(mode="straight") {#"I1311":7 %p1878};
//   %wire_4642 = &"net382" @WIRE(mode="straight") {#"I1310":6 %p1877};
//   %p1879 = (34, -159);
//   %wire_4643 = &"net485" @WIRE(mode="straight") {#"I1280":3 %p1879};
//   %p1880 = (14, -157);
//   %wire_4644 = &"net485" @WIRE(mode="straight") {%p1879 %p1880};
//   %wire_4645 = &"net485" @WIRE(mode="straight") {#"I1281":7 %p1880};
//   %p1881 = (-4, -157);
//   %wire_4646 = &"net485" @WIRE(mode="straight") {#"I1470":1 %p1881};
//   %wire_4647 = &"net485" @WIRE(mode="straight") {%p1881 %p1880};
//   %p1882 = (-6, -136);
//   %wire_4648 = &"net489" @WIRE(mode="straight") {%p1882 #"I839":4};
//   %p1883 = (-26, -138);
//   %wire_4649 = &"net489" @WIRE(mode="straight") {%p1883 #"I1472":1};
//   %wire_4650 = &"net489" @WIRE(mode="straight") {#"I1476":2 %p1883};
//   %wire_4651 = &"net489" @WIRE(mode="straight") {#"I840":4 #"I841":4};
//   %wire_4652 = &"net489" @WIRE(mode="straight") {#"I841":4 #"I842":4};
//   %p1884 = (97, -133);
//   %wire_4653 = &"net489" @WIRE(mode="straight") {%p1884 #"M133":3};
//   %wire_4654 = &"net489" @WIRE(mode="straight") {#"I1472":1 %p1882};
//   %p1885 = (97, -136);
//   %wire_4655 = &"net489" @WIRE(mode="straight") {#"M26":3 %p1885};
//   %wire_4656 = &"net489" @WIRE(mode="straight") {#"I839":4 #"I840":4};
//   %wire_4657 = &"net489" @WIRE(mode="straight") {%p1885 %p1884};
//   %wire_4658 = &"net489" @WIRE(mode="straight") {#"I842":4 %p1885};
//   %wire_4659 = &"net489" @WIRE(mode="straight") {%p1882 #"M70":1};
//   %p1886 = (36, -124);
//   %wire_4660 = &"net490" @WIRE(mode="straight") {#"I840":6 %p1886};
//   %p1887 = (14, -124);
//   %p1888 = (34, -124);
//   %wire_4661 = &"net490" @WIRE(mode="straight") {%p1887 %p1888};
//   %wire_4662 = &"net490" @WIRE(mode="straight") {#"I840":3 %p1888};
//   %wire_4663 = &"net490" @WIRE(mode="straight") {%p1888 %p1886};
//   %wire_4664 = &"net490" @WIRE(mode="straight") {#"I839":7 %p1887};
//   %p1889 = (38, -124);
//   %wire_4665 = &"net491" @WIRE(mode="straight") {#"I840":7 %p1889};
//   %p1890 = (58, -124);
//   %wire_4666 = &"net491" @WIRE(mode="straight") {#"I841":3 %p1890};
//   %wire_4667 = &"net491" @WIRE(mode="straight") {%p1889 %p1890};
//   %p1891 = (60, -124);
//   %wire_4668 = &"net491" @WIRE(mode="straight") {%p1890 %p1891};
//   %wire_4669 = &"net491" @WIRE(mode="straight") {#"I841":6 %p1891};
//   %p1892 = (84, -124);
//   %wire_4670 = &"net492" @WIRE(mode="straight") {#"I842":6 %p1892};
//   %p1893 = (62, -124);
//   %p1894 = (82, -124);
//   %wire_4671 = &"net492" @WIRE(mode="straight") {%p1893 %p1894};
//   %wire_4672 = &"net492" @WIRE(mode="straight") {#"I842":3 %p1894};
//   %wire_4673 = &"net492" @WIRE(mode="straight") {#"I841":7 %p1893};
//   %wire_4674 = &"net492" @WIRE(mode="straight") {%p1894 %p1892};
//   %p1895 = (58, -509);
//   %p1896 = (38, -507);
//   %wire_4675 = &"net383" @WIRE(mode="straight") {%p1895 %p1896};
//   %p1897 = (12, -509);
//   %wire_4676 = &"net383" @WIRE(mode="straight") {%p1897 %p1896};
//   %wire_4677 = &"net383" @WIRE(mode="straight") {#"I1364":3 %p1895};
//   %wire_4678 = &"net383" @WIRE(mode="straight") {#"I1365":7 %p1896};
//   %wire_4679 = &"net383" @WIRE(mode="straight") {#"I1366":6 %p1897};
//   %p1898 = (400, -610);
//   %wire_4680 = &"net389" @WIRE(mode="straight") {#"I1143":7 %p1898};
//   %p1899 = (398, -610);
//   %wire_4681 = &"net389" @WIRE(mode="straight") {%p1899 %p1898};
//   %wire_4682 = &"net389" @WIRE(mode="straight") {%p1899 #"I1396":6};
//   %p1900 = (34, -544);
//   %p1901 = (36, -544);
//   %wire_4683 = &"net495" @WIRE(mode="straight") {%p1900 %p1901};
//   %p1902 = (14, -544);
//   %wire_4684 = &"net495" @WIRE(mode="straight") {#"I1079":7 %p1902};
//   %wire_4685 = &"net495" @WIRE(mode="straight") {#"I1080":3 %p1900};
//   %wire_4686 = &"net495" @WIRE(mode="straight") {#"I1080":6 %p1901};
//   %wire_4687 = &"net495" @WIRE(mode="straight") {%p1902 %p1900};
//   %p1903 = (396, -579);
//   %wire_4688 = &"net390" @WIRE(mode="straight") {#"I1396":3 %p1903};
//   %p1904 = (376, -577);
//   %wire_4689 = &"net390" @WIRE(mode="straight") {#"I1395":7 %p1904};
//   %p1905 = (350, -579);
//   %wire_4690 = &"net390" @WIRE(mode="straight") {#"I1394":6 %p1905};
//   %wire_4691 = &"net390" @WIRE(mode="straight") {%p1903 %p1904};
//   %wire_4692 = &"net390" @WIRE(mode="straight") {%p1905 %p1904};
//   %p1906 = (374, -579);
//   %wire_4693 = &"net394" @WIRE(mode="straight") {#"I1395":6 %p1906};
//   %p1907 = (400, -577);
//   %wire_4694 = &"net394" @WIRE(mode="straight") {#"I1396":7 %p1907};
//   %wire_4695 = &"net394" @WIRE(mode="straight") {%p1906 %p1907};
//   %p1908 = (194, -19);
//   %wire_4696 = &"net45" @WIRE(mode="straight") {#"I778":6 %p1908};
//   %p1909 = (232, -17);
//   %wire_4697 = &"net45" @WIRE(mode="straight") {%p1908 %p1909};
//   %p1910 = (252, -19);
//   %wire_4698 = &"net45" @WIRE(mode="straight") {#"I776":3 %p1910};
//   %wire_4699 = &"net45" @WIRE(mode="straight") {#"I777":7 %p1909};
//   %wire_4700 = &"net45" @WIRE(mode="straight") {%p1910 %p1909};
//   %p1911 = (228, -334);
//   %wire_4701 = &"net500" @WIRE(mode="straight") {#"I970":3 %p1911};
//   %p1912 = (230, -334);
//   %wire_4702 = &"net500" @WIRE(mode="straight") {%p1911 %p1912};
//   %wire_4703 = &"net500" @WIRE(mode="straight") {#"I970":6 %p1912};
//   %p1913 = (196, -334);
//   %wire_4704 = &"net500" @WIRE(mode="straight") {%p1913 %p1911};
//   %wire_4705 = &"net500" @WIRE(mode="straight") {#"I971":7 %p1913};
//   %p1914 = (58, -334);
//   %p1915 = (60, -334);
//   %wire_4706 = &"net502" @WIRE(mode="straight") {%p1914 %p1915};
//   %wire_4707 = &"net502" @WIRE(mode="straight") {#"I961":6 %p1915};
//   %p1916 = (38, -334);
//   %wire_4708 = &"net502" @WIRE(mode="straight") {%p1916 %p1914};
//   %wire_4709 = &"net502" @WIRE(mode="straight") {#"I960":7 %p1916};
//   %wire_4710 = &"net502" @WIRE(mode="straight") {#"I961":3 %p1914};
//   %p1917 = (62, -334);
//   %p1918 = (82, -334);
//   %wire_4711 = &"net503" @WIRE(mode="straight") {%p1917 %p1918};
//   %p1919 = (84, -334);
//   %wire_4712 = &"net503" @WIRE(mode="straight") {#"I962":6 %p1919};
//   %wire_4713 = &"net503" @WIRE(mode="straight") {#"I962":3 %p1918};
//   %wire_4714 = &"net503" @WIRE(mode="straight") {#"I961":7 %p1917};
//   %wire_4715 = &"net503" @WIRE(mode="straight") {%p1918 %p1919};
//   %p1920 = (12, -57);
//   %wire_4716 = &"net2093" @WIRE(mode="straight") {#"I799":6 %p1920};
//   %wire_4717 = &"net2093" @WIRE(mode="straight") {#"I1469":3 #"M68":2};
//   %wire_4718 = &"net2093" @WIRE(mode="straight") {#"M68":2 %p1920};
//   %p1921 = (146, -579);
//   %p1922 = (172, -577);
//   %wire_4719 = &"net397" @WIRE(mode="straight") {%p1921 %p1922};
//   %p1923 = (192, -579);
//   %wire_4720 = &"net397" @WIRE(mode="straight") {%p1923 %p1922};
//   %wire_4721 = &"net397" @WIRE(mode="straight") {#"I1387":7 %p1922};
//   %wire_4722 = &"net397" @WIRE(mode="straight") {#"I1388":3 %p1923};
//   %wire_4723 = &"net397" @WIRE(mode="straight") {#"I1386":6 %p1921};
//   %p1924 = (36, -299);
//   %wire_4724 = &"net398" @WIRE(mode="straight") {#"I1314":6 %p1924};
//   %p1925 = (62, -297);
//   %wire_4725 = &"net398" @WIRE(mode="straight") {%p1924 %p1925};
//   %p1926 = (82, -299);
//   %wire_4726 = &"net398" @WIRE(mode="straight") {%p1926 %p1925};
//   %wire_4727 = &"net398" @WIRE(mode="straight") {#"I1313":7 %p1925};
//   %wire_4728 = &"net398" @WIRE(mode="straight") {#"I1312":3 %p1926};
//   %p1927 = (60, -299);
//   %wire_4729 = &"net400" @WIRE(mode="straight") {#"I1313":6 %p1927};
//   %p1928 = (120, -299);
//   %p1929 = (86, -297);
//   %wire_4730 = &"net400" @WIRE(mode="straight") {%p1928 %p1929};
//   %wire_4731 = &"net400" @WIRE(mode="straight") {%p1927 %p1929};
//   %wire_4732 = &"net400" @WIRE(mode="straight") {#"I1312":7 %p1929};
//   %wire_4733 = &"net400" @WIRE(mode="straight") {#"I1317":3 %p1928};
//   %p1930 = (230, -369);
//   %wire_4734 = &"net402" @WIRE(mode="straight") {#"I1338":6 %p1930};
//   %p1931 = (276, -369);
//   %wire_4735 = &"net402" @WIRE(mode="straight") {#"I1340":3 %p1931};
//   %p1932 = (256, -367);
//   %wire_4736 = &"net402" @WIRE(mode="straight") {%p1931 %p1932};
//   %wire_4737 = &"net402" @WIRE(mode="straight") {%p1930 %p1932};
//   %wire_4738 = &"net402" @WIRE(mode="straight") {#"I1333":7 %p1932};
//   %p1933 = (252, -54);
//   %wire_4739 = &"net513" @WIRE(mode="straight") {#"I809":3 %p1933};
//   %p1934 = (232, -54);
//   %wire_4740 = &"net513" @WIRE(mode="straight") {%p1934 %p1933};
//   %wire_4741 = &"net513" @WIRE(mode="straight") {#"I810":7 %p1934};
//   %p1935 = (254, -54);
//   %wire_4742 = &"net513" @WIRE(mode="straight") {%p1933 %p1935};
//   %wire_4743 = &"net513" @WIRE(mode="straight") {#"I809":6 %p1935};
//   %p1936 = (196, -54);
//   %p1937 = (228, -54);
//   %wire_4744 = &"net514" @WIRE(mode="straight") {%p1936 %p1937};
//   %wire_4745 = &"net514" @WIRE(mode="straight") {#"I811":7 %p1936};
//   %p1938 = (230, -54);
//   %wire_4746 = &"net514" @WIRE(mode="straight") {%p1937 %p1938};
//   %wire_4747 = &"net514" @WIRE(mode="straight") {#"I810":6 %p1938};
//   %wire_4748 = &"net514" @WIRE(mode="straight") {#"I810":3 %p1937};
//   %p1939 = (192, -54);
//   %p1940 = (194, -54);
//   %wire_4749 = &"net515" @WIRE(mode="straight") {%p1939 %p1940};
//   %wire_4750 = &"net515" @WIRE(mode="straight") {#"I811":6 %p1940};
//   %wire_4751 = &"net515" @WIRE(mode="straight") {#"I811":3 %p1939};
//   %p1941 = (172, -54);
//   %wire_4752 = &"net515" @WIRE(mode="straight") {#"I812":7 %p1941};
//   %wire_4753 = &"net515" @WIRE(mode="straight") {%p1941 %p1939};
//   %p1942 = (205, -66);
//   %wire_4754 = &"net516" @WIRE(mode="straight") {#"M64":3 %p1942};
//   %p1943 = (205, -63);
//   %wire_4755 = &"net516" @WIRE(mode="straight") {%p1943 #"M171":3};
//   %p1944 = (107, -66);
//   %wire_4756 = &"net516" @WIRE(mode="straight") {%p1944 #"M131":1};
//   %wire_4757 = &"net516" @WIRE(mode="straight") {#"I813":4 #"I812":4};
//   %wire_4758 = &"net516" @WIRE(mode="straight") {#"I811":4 %p1942};
//   %wire_4759 = &"net516" @WIRE(mode="straight") {#"I812":4 #"I811":4};
//   %wire_4760 = &"net516" @WIRE(mode="straight") {#"I814":4 #"I813":4};
//   %wire_4761 = &"net516" @WIRE(mode="straight") {%p1942 %p1943};
//   %p1945 = (107, -69);
//   %wire_4762 = &"net516" @WIRE(mode="straight") {#"M24":1 %p1945};
//   %wire_4763 = &"net516" @WIRE(mode="straight") {%p1944 #"I814":4};
//   %wire_4764 = &"net516" @WIRE(mode="straight") {%p1945 %p1944};
//   %p1946 = (168, -54);
//   %p1947 = (170, -54);
//   %wire_4765 = &"net517" @WIRE(mode="straight") {%p1946 %p1947};
//   %wire_4766 = &"net517" @WIRE(mode="straight") {#"I812":6 %p1947};
//   %p1948 = (148, -54);
//   %wire_4767 = &"net517" @WIRE(mode="straight") {%p1948 %p1946};
//   %wire_4768 = &"net517" @WIRE(mode="straight") {#"I812":3 %p1946};
//   %wire_4769 = &"net517" @WIRE(mode="straight") {#"I813":7 %p1948};
//   %p1949 = (144, -54);
//   %wire_4770 = &"net518" @WIRE(mode="straight") {#"I813":3 %p1949};
//   %p1950 = (124, -54);
//   %wire_4771 = &"net518" @WIRE(mode="straight") {#"I814":7 %p1950};
//   %p1951 = (146, -54);
//   %wire_4772 = &"net518" @WIRE(mode="straight") {#"I813":6 %p1951};
//   %wire_4773 = &"net518" @WIRE(mode="straight") {%p1949 %p1951};
//   %wire_4774 = &"net518" @WIRE(mode="straight") {%p1950 %p1949};
//   %p1952 = (300, -19);
//   %wire_4775 = &"net27" @WIRE(mode="straight") {#"I787":3 %p1952};
//   %p1953 = (280, -17);
//   %wire_4776 = &"net27" @WIRE(mode="straight") {#"I788":7 %p1953};
//   %p1954 = (254, -19);
//   %wire_4777 = &"net27" @WIRE(mode="straight") {#"I776":6 %p1954};
//   %wire_4778 = &"net27" @WIRE(mode="straight") {%p1954 %p1953};
//   %wire_4779 = &"net27" @WIRE(mode="straight") {%p1952 %p1953};
//   %wire_4780 = &"net478" @WIRE(mode="straight") {#"I1466":1 #"I1463":2};
//   %p1955 = (280, -367);
//   %wire_4781 = &"net403" @WIRE(mode="straight") {#"I1340":7 %p1955};
//   %p1956 = (300, -369);
//   %wire_4782 = &"net403" @WIRE(mode="straight") {#"I1341":3 %p1956};
//   %p1957 = (254, -369);
//   %wire_4783 = &"net403" @WIRE(mode="straight") {%p1957 %p1955};
//   %wire_4784 = &"net403" @WIRE(mode="straight") {%p1956 %p1955};
//   %wire_4785 = &"net403" @WIRE(mode="straight") {#"I1333":6 %p1957};
//   %p1958 = (122, -369);
//   %p1959 = (148, -367);
//   %wire_4786 = &"net404" @WIRE(mode="straight") {%p1958 %p1959};
//   %wire_4787 = &"net404" @WIRE(mode="straight") {#"I1334":6 %p1958};
//   %p1960 = (168, -369);
//   %wire_4788 = &"net404" @WIRE(mode="straight") {#"I1336":3 %p1960};
//   %wire_4789 = &"net404" @WIRE(mode="straight") {%p1960 %p1959};
//   %wire_4790 = &"net404" @WIRE(mode="straight") {#"I1335":7 %p1959};
//   %p1961 = (144, -649);
//   %wire_4791 = &"net405" @WIRE(mode="straight") {#"I1403":3 %p1961};
//   %p1962 = (124, -647);
//   %wire_4792 = &"net405" @WIRE(mode="straight") {#"I1402":7 %p1962};
//   %p1963 = (84, -649);
//   %wire_4793 = &"net405" @WIRE(mode="straight") {#"I1397":6 %p1963};
//   %wire_4794 = &"net405" @WIRE(mode="straight") {%p1961 %p1962};
//   %wire_4795 = &"net405" @WIRE(mode="straight") {%p1962 %p1963};
//   %p1964 = (38, -717);
//   %wire_4796 = &"net406" @WIRE(mode="straight") {#"I1416":7 %p1964};
//   %p1965 = (12, -719);
//   %wire_4797 = &"net406" @WIRE(mode="straight") {%p1965 %p1964};
//   %wire_4798 = &"net406" @WIRE(mode="straight") {#"I1417":6 %p1965};
//   %p1966 = (58, -719);
//   %wire_4799 = &"net406" @WIRE(mode="straight") {%p1966 %p1964};
//   %wire_4800 = &"net406" @WIRE(mode="straight") {#"I1415":3 %p1966};
//   %p1967 = (-4, -743);
//   %p1968 = (14, -743);
//   %wire_4801 = &"net408" @WIRE(mode="straight") {%p1967 %p1968};
//   %wire_4802 = &"net408" @WIRE(mode="straight") {%p1967 #"I1534":2};
//   %p1969 = (400, -743);
//   %wire_4803 = &"net408" @WIRE(mode="straight") {%p1969 #"I1424":2};
//   %p1970 = (232, -743);
//   %p1971 = (256, -743);
//   %wire_4804 = &"net408" @WIRE(mode="straight") {%p1970 %p1971};
//   %p1972 = (38, -743);
//   %wire_4805 = &"net408" @WIRE(mode="straight") {%p1972 #"I1416":5};
//   %p1973 = (148, -743);
//   %p1974 = (172, -743);
//   %wire_4806 = &"net408" @WIRE(mode="straight") {%p1973 %p1974};
//   %wire_4807 = &"net408" @WIRE(mode="straight") {%p1970 #"I1423":5};
//   %p1975 = (280, -743);
//   %wire_4808 = &"net408" @WIRE(mode="straight") {%p1971 %p1975};
//   %p1976 = (196, -743);
//   %wire_4809 = &"net408" @WIRE(mode="straight") {%p1976 %p1970};
//   %wire_4810 = &"net408" @WIRE(mode="straight") {%p1974 #"I1421":5};
//   %wire_4811 = &"net408" @WIRE(mode="straight") {%p1974 %p1976};
//   %p1977 = (124, -743);
//   %wire_4812 = &"net408" @WIRE(mode="straight") {%p1977 %p1973};
//   %wire_4813 = &"net408" @WIRE(mode="straight") {%p1975 #"I1425":5};
//   %p1978 = (86, -743);
//   %wire_4814 = &"net408" @WIRE(mode="straight") {%p1978 #"I1414":5};
//   %wire_4815 = &"net408" @WIRE(mode="straight") {%p1968 #"I1417":5};
//   %p1979 = (328, -743);
//   %p1980 = (352, -743);
//   %wire_4816 = &"net408" @WIRE(mode="straight") {%p1979 %p1980};
//   %p1981 = (304, -743);
//   %wire_4817 = &"net408" @WIRE(mode="straight") {%p1981 #"I1426":5};
//   %wire_4818 = &"net408" @WIRE(mode="straight") {%p1979 #"I1427":5};
//   %wire_4819 = &"net408" @WIRE(mode="straight") {%p1968 %p1972};
//   %p1982 = (376, -743);
//   %wire_4820 = &"net408" @WIRE(mode="straight") {%p1982 %p1969};
//   %wire_4821 = &"net408" @WIRE(mode="straight") {%p1971 #"I1418":5};
//   %wire_4822 = &"net408" @WIRE(mode="straight") {%p1975 %p1981};
//   %wire_4823 = &"net408" @WIRE(mode="straight") {%p1976 #"I1422":5};
//   %wire_4824 = &"net408" @WIRE(mode="straight") {%p1982 #"I1429":5};
//   %wire_4825 = &"net408" @WIRE(mode="straight") {%p1973 #"I1420":5};
//   %wire_4826 = &"net408" @WIRE(mode="straight") {%p1980 %p1982};
//   %p1983 = (62, -743);
//   %wire_4827 = &"net408" @WIRE(mode="straight") {%p1983 %p1978};
//   %wire_4828 = &"net408" @WIRE(mode="straight") {%p1983 #"I1415":5};
//   %wire_4829 = &"net408" @WIRE(mode="straight") {%p1981 %p1979};
//   %wire_4830 = &"net408" @WIRE(mode="straight") {%p1969 #"I1430":5};
//   %wire_4831 = &"net408" @WIRE(mode="straight") {%p1972 %p1983};
//   %wire_4832 = &"net408" @WIRE(mode="straight") {%p1977 #"I1419":5};
//   %wire_4833 = &"net408" @WIRE(mode="straight") {%p1978 %p1977};
//   %wire_4834 = &"net408" @WIRE(mode="straight") {%p1980 #"I1428":5};
//   %p1984 = (226, -715);
//   %wire_4835 = &"net409" @WIRE(mode="straight") {#"I1423":9 %p1984};
//   %p1985 = (166, -715);
//   %p1986 = (190, -715);
//   %wire_4836 = &"net409" @WIRE(mode="straight") {%p1985 %p1986};
//   %p1987 = (322, -715);
//   %p1988 = (346, -715);
//   %wire_4837 = &"net409" @WIRE(mode="straight") {%p1987 %p1988};
//   %wire_4838 = &"net409" @WIRE(mode="straight") {#"I1427":9 %p1987};
//   %wire_4839 = &"net409" @WIRE(mode="straight") {#"I1428":9 %p1988};
//   %p1989 = (118, -715);
//   %p1990 = (142, -715);
//   %wire_4840 = &"net409" @WIRE(mode="straight") {%p1989 %p1990};
//   %p1991 = (10, -715);
//   %p1992 = (32, -715);
//   %wire_4841 = &"net409" @WIRE(mode="straight") {%p1991 %p1992};
//   %p1993 = (8, -715);
//   %wire_4842 = &"net409" @WIRE(mode="straight") {#"I1417":9 %p1993};
//   %p1994 = (370, -715);
//   %wire_4843 = &"net409" @WIRE(mode="straight") {%p1988 %p1994};
//   %p1995 = (274, -715);
//   %p1996 = (298, -715);
//   %wire_4844 = &"net409" @WIRE(mode="straight") {%p1995 %p1996};
//   %wire_4845 = &"net409" @WIRE(mode="straight") {#"I1426":9 %p1996};
//   %p1997 = (250, -715);
//   %wire_4846 = &"net409" @WIRE(mode="straight") {#"I1418":9 %p1997};
//   %wire_4847 = &"net409" @WIRE(mode="straight") {%p1986 %p1984};
//   %wire_4848 = &"net409" @WIRE(mode="straight") {#"I1425":9 %p1995};
//   %wire_4849 = &"net409" @WIRE(mode="straight") {#"I1416":9 %p1992};
//   %p1998 = (394, -715);
//   %wire_4850 = &"net409" @WIRE(mode="straight") {#"I1430":9 %p1998};
//   %p1999 = (80, -715);
//   %wire_4851 = &"net409" @WIRE(mode="straight") {%p1999 %p1989};
//   %p2000 = (56, -715);
//   %wire_4852 = &"net409" @WIRE(mode="straight") {%p1992 %p2000};
//   %wire_4853 = &"net409" @WIRE(mode="straight") {#"I1415":9 %p2000};
//   %wire_4854 = &"net409" @WIRE(mode="straight") {#"I1422":9 %p1986};
//   %wire_4855 = &"net409" @WIRE(mode="straight") {%p1997 %p1995};
//   %wire_4856 = &"net409" @WIRE(mode="straight") {#"I1429":9 %p1994};
//   %wire_4857 = &"net409" @WIRE(mode="straight") {%p1990 %p1985};
//   %wire_4858 = &"net409" @WIRE(mode="straight") {#"I1420":9 %p1990};
//   %wire_4859 = &"net409" @WIRE(mode="straight") {%p1984 %p1997};
//   %wire_4860 = &"net409" @WIRE(mode="straight") {%p1994 %p1998};
//   %wire_4861 = &"net409" @WIRE(mode="straight") {%p1996 %p1987};
//   %wire_4862 = &"net409" @WIRE(mode="straight") {%p1993 %p1991};
//   %wire_4863 = &"net409" @WIRE(mode="straight") {#"I1419":9 %p1989};
//   %wire_4864 = &"net409" @WIRE(mode="straight") {#"I1421":9 %p1985};
//   %wire_4865 = &"net409" @WIRE(mode="straight") {%p2000 %p1999};
//   %wire_4866 = &"net409" @WIRE(mode="straight") {#"I1414":9 %p1999};
//   %wire_4867 = &"net409" @WIRE(mode="straight") {#"I1417":3 %p1991};
//   %wire_4868 = &"net479" @WIRE(mode="straight") {#"I1465":1 #"I1466":3};
//   %p2001 = (36, -719);
//   %p2002 = (62, -717);
//   %wire_4869 = &"net410" @WIRE(mode="straight") {%p2001 %p2002};
//   %wire_4870 = &"net410" @WIRE(mode="straight") {#"I1415":7 %p2002};
//   %p2003 = (82, -719);
//   %wire_4871 = &"net410" @WIRE(mode="straight") {#"I1414":3 %p2003};
//   %wire_4872 = &"net410" @WIRE(mode="straight") {#"I1416":6 %p2001};
//   %wire_4873 = &"net410" @WIRE(mode="straight") {%p2003 %p2002};
//   %p2004 = (60, -719);
//   %wire_4874 = &"net413" @WIRE(mode="straight") {#"I1415":6 %p2004};
//   %p2005 = (86, -717);
//   %wire_4875 = &"net413" @WIRE(mode="straight") {%p2004 %p2005};
//   %p2006 = (120, -719);
//   %wire_4876 = &"net413" @WIRE(mode="straight") {%p2006 %p2005};
//   %wire_4877 = &"net413" @WIRE(mode="straight") {#"I1414":7 %p2005};
//   %wire_4878 = &"net413" @WIRE(mode="straight") {#"I1419":3 %p2006};
//   %p2007 = (36, -89);
//   %wire_4879 = &"net417" @WIRE(mode="straight") {#"I1263":6 %p2007};
//   %p2008 = (82, -89);
//   %wire_4880 = &"net417" @WIRE(mode="straight") {#"I1261":3 %p2008};
//   %p2009 = (62, -87);
//   %wire_4881 = &"net417" @WIRE(mode="straight") {%p2008 %p2009};
//   %wire_4882 = &"net417" @WIRE(mode="straight") {#"I1262":7 %p2009};
//   %wire_4883 = &"net417" @WIRE(mode="straight") {%p2007 %p2009};
//   %p2010 = (252, -334);
//   %p2011 = (254, -334);
//   %wire_4884 = &"net532" @WIRE(mode="straight") {%p2010 %p2011};
//   %p2012 = (232, -334);
//   %wire_4885 = &"net532" @WIRE(mode="straight") {%p2012 %p2010};
//   %wire_4886 = &"net532" @WIRE(mode="straight") {#"I969":3 %p2010};
//   %wire_4887 = &"net532" @WIRE(mode="straight") {#"I970":7 %p2012};
//   %wire_4888 = &"net532" @WIRE(mode="straight") {#"I969":6 %p2011};
//   %p2013 = (276, -334);
//   %p2014 = (278, -334);
//   %wire_4889 = &"net533" @WIRE(mode="straight") {%p2013 %p2014};
//   %wire_4890 = &"net533" @WIRE(mode="straight") {#"I988":3 %p2013};
//   %p2015 = (256, -334);
//   %wire_4891 = &"net533" @WIRE(mode="straight") {%p2015 %p2013};
//   %wire_4892 = &"net533" @WIRE(mode="straight") {#"I988":6 %p2014};
//   %wire_4893 = &"net533" @WIRE(mode="straight") {#"I969":7 %p2015};
//   %p2016 = (124, -544);
//   %p2017 = (144, -544);
//   %wire_4894 = &"net534" @WIRE(mode="straight") {%p2016 %p2017};
//   %p2018 = (146, -544);
//   %wire_4895 = &"net534" @WIRE(mode="straight") {%p2017 %p2018};
//   %wire_4896 = &"net534" @WIRE(mode="straight") {#"I1093":6 %p2018};
//   %wire_4897 = &"net534" @WIRE(mode="straight") {#"I1093":3 %p2017};
//   %wire_4898 = &"net534" @WIRE(mode="straight") {#"I1094":7 %p2016};
//   %p2019 = (148, -544);
//   %p2020 = (168, -544);
//   %wire_4899 = &"net535" @WIRE(mode="straight") {%p2019 %p2020};
//   %wire_4900 = &"net535" @WIRE(mode="straight") {#"I1092":3 %p2020};
//   %p2021 = (170, -544);
//   %wire_4901 = &"net535" @WIRE(mode="straight") {#"I1092":6 %p2021};
//   %wire_4902 = &"net535" @WIRE(mode="straight") {#"I1093":7 %p2019};
//   %wire_4903 = &"net535" @WIRE(mode="straight") {%p2020 %p2021};
//   %p2022 = (300, -719);
//   %wire_4904 = &"net418" @WIRE(mode="straight") {#"I1426":3 %p2022};
//   %p2023 = (254, -719);
//   %p2024 = (280, -717);
//   %wire_4905 = &"net418" @WIRE(mode="straight") {%p2023 %p2024};
//   %wire_4906 = &"net418" @WIRE(mode="straight") {#"I1418":6 %p2023};
//   %wire_4907 = &"net418" @WIRE(mode="straight") {#"I1425":7 %p2024};
//   %wire_4908 = &"net418" @WIRE(mode="straight") {%p2022 %p2024};
//   %wire_4909 = &"net420" @WIRE(mode="straight") {#"I1428":4 #"I1429":4};
//   %wire_4910 = &"net420" @WIRE(mode="straight") {#"I1423":4 #"I1418":4};
//   %wire_4911 = &"net420" @WIRE(mode="straight") {#"I1426":4 #"I1427":4};
//   %wire_4912 = &"net420" @WIRE(mode="straight") {#"I1427":4 #"I1428":4};
//   %wire_4913 = &"net420" @WIRE(mode="straight") {#"I1425":4 #"I1426":4};
//   %wire_4914 = &"net420" @WIRE(mode="straight") {#"I1418":4 #"I1425":4};
//   %p2025 = (215, -734);
//   %wire_4915 = &"net420" @WIRE(mode="straight") {#"M49":1 %p2025};
//   %p2026 = (215, -731);
//   %wire_4916 = &"net420" @WIRE(mode="straight") {%p2026 #"M151":1};
//   %wire_4917 = &"net420" @WIRE(mode="straight") {#"I1429":4 #"I1430":4};
//   %wire_4918 = &"net420" @WIRE(mode="straight") {%p2025 %p2026};
//   %wire_4919 = &"net420" @WIRE(mode="straight") {%p2026 #"I1423":4};
//   %p2027 = (398, -544);
//   %wire_4920 = &"net538" @WIRE(mode="straight") {#"I1103":6 %p2027};
//   %p2028 = (396, -544);
//   %wire_4921 = &"net538" @WIRE(mode="straight") {%p2028 %p2027};
//   %wire_4922 = &"net538" @WIRE(mode="straight") {#"I1103":3 %p2028};
//   %p2029 = (376, -544);
//   %wire_4923 = &"net538" @WIRE(mode="straight") {%p2029 %p2028};
//   %wire_4924 = &"net538" @WIRE(mode="straight") {#"I1104":7 %p2029};
//   %p2030 = (400, -540);
//   %wire_4925 = &"net539" @WIRE(mode="straight") {#"I1103":7 %p2030};
//   %p2031 = (398, -540);
//   %wire_4926 = &"net539" @WIRE(mode="straight") {%p2031 %p2030};
//   %wire_4927 = &"net539" @WIRE(mode="straight") {%p2031 #"I1379":6};
//   %p2032 = (194, -719);
//   %wire_4928 = &"net423" @WIRE(mode="straight") {#"I1422":6 %p2032};
//   %p2033 = (252, -719);
//   %p2034 = (232, -717);
//   %wire_4929 = &"net423" @WIRE(mode="straight") {%p2033 %p2034};
//   %wire_4930 = &"net423" @WIRE(mode="straight") {#"I1423":7 %p2034};
//   %wire_4931 = &"net423" @WIRE(mode="straight") {#"I1418":3 %p2033};
//   %wire_4932 = &"net423" @WIRE(mode="straight") {%p2032 %p2034};
//   %p2035 = (396, -404);
//   %p2036 = (398, -404);
//   %wire_4933 = &"net547" @WIRE(mode="straight") {%p2035 %p2036};
//   %wire_4934 = &"net547" @WIRE(mode="straight") {#"I1023":6 %p2036};
//   %p2037 = (376, -404);
//   %wire_4935 = &"net547" @WIRE(mode="straight") {#"I1024":7 %p2037};
//   %wire_4936 = &"net547" @WIRE(mode="straight") {%p2037 %p2035};
//   %wire_4937 = &"net547" @WIRE(mode="straight") {#"I1023":3 %p2035};
//   %p2038 = (12, -337);
//   %wire_4938 = &"net548" @WIRE(mode="straight") {#"I959":6 %p2038};
//   %wire_4939 = &"net548" @WIRE(mode="straight") {#"M76":2 %p2038};
//   %wire_4940 = &"net548" @WIRE(mode="straight") {#"I1501":3 #"M76":2};
//   %p2039 = (396, -264);
//   %p2040 = (398, -264);
//   %wire_4941 = &"net551" @WIRE(mode="straight") {%p2039 %p2040};
//   %wire_4942 = &"net551" @WIRE(mode="straight") {#"I943":6 %p2040};
//   %p2041 = (376, -264);
//   %wire_4943 = &"net551" @WIRE(mode="straight") {#"I944":7 %p2041};
//   %wire_4944 = &"net551" @WIRE(mode="straight") {%p2041 %p2039};
//   %wire_4945 = &"net551" @WIRE(mode="straight") {#"I943":3 %p2039};
//   %p2042 = (422, 27);
//   %p2043 = (422, 62);
//   %wire_4946 = &"net352" @WIRE(mode="straight") {%p2042 %p2043};
//   %wire_4947 = &"net352" @WIRE(mode="straight") {#"I1596":1 %p2042};
//   %wire_4948 = &"net352" @WIRE(mode="straight") {#"I1602":1 %p2043};
//   %p2044 = (422, -8);
//   %wire_4949 = &"net352" @WIRE(mode="straight") {%p2044 %p2042};
//   %p2045 = (422, -743);
//   %wire_4950 = &"net352" @WIRE(mode="straight") {%p2045 #"I1224":2};
//   %p2046 = (422, -43);
//   %wire_4951 = &"net352" @WIRE(mode="straight") {%p2046 %p2044};
//   %p2047 = (422, -78);
//   %wire_4952 = &"net352" @WIRE(mode="straight") {%p2047 %p2046};
//   %p2048 = (422, -148);
//   %p2049 = (422, -113);
//   %wire_4953 = &"net352" @WIRE(mode="straight") {%p2048 %p2049};
//   %p2050 = (422, -218);
//   %p2051 = (422, -183);
//   %wire_4954 = &"net352" @WIRE(mode="straight") {%p2050 %p2051};
//   %p2052 = (422, -288);
//   %p2053 = (422, -253);
//   %wire_4955 = &"net352" @WIRE(mode="straight") {%p2052 %p2053};
//   %p2054 = (422, -358);
//   %p2055 = (422, -323);
//   %wire_4956 = &"net352" @WIRE(mode="straight") {%p2054 %p2055};
//   %p2056 = (422, -428);
//   %p2057 = (422, -393);
//   %wire_4957 = &"net352" @WIRE(mode="straight") {%p2056 %p2057};
//   %p2058 = (422, -498);
//   %p2059 = (422, -463);
//   %wire_4958 = &"net352" @WIRE(mode="straight") {%p2058 %p2059};
//   %p2060 = (422, -568);
//   %p2061 = (422, -533);
//   %wire_4959 = &"net352" @WIRE(mode="straight") {%p2060 %p2061};
//   %p2062 = (422, -638);
//   %p2063 = (422, -603);
//   %wire_4960 = &"net352" @WIRE(mode="straight") {%p2062 %p2063};
//   %p2064 = (422, -708);
//   %p2065 = (422, -673);
//   %wire_4961 = &"net352" @WIRE(mode="straight") {%p2064 %p2065};
//   %p2066 = (422, -732);
//   %wire_4962 = &"net352" @WIRE(mode="straight") {%p2045 %p2066};
//   %wire_4963 = &"net352" @WIRE(mode="straight") {#"I1424":1 %p2045};
//   %wire_4964 = &"net352" @WIRE(mode="straight") {#"I1182":1 %p2064};
//   %wire_4965 = &"net352" @WIRE(mode="straight") {%p2051 %p2048};
//   %wire_4966 = &"net352" @WIRE(mode="straight") {#"I1271":1 %p2049};
//   %wire_4967 = &"net352" @WIRE(mode="straight") {#"I1142":1 %p2062};
//   %wire_4968 = &"net352" @WIRE(mode="straight") {#"I1288":1 %p2051};
//   %wire_4969 = &"net352" @WIRE(mode="straight") {#"I1102":1 %p2060};
//   %wire_4970 = &"net352" @WIRE(mode="straight") {#"I902":1 %p2050};
//   %wire_4971 = &"net352" @WIRE(mode="straight") {#"I1305":1 %p2053};
//   %wire_4972 = &"net352" @WIRE(mode="straight") {%p2053 %p2050};
//   %wire_4973 = &"net352" @WIRE(mode="straight") {%p2061 %p2058};
//   %wire_4974 = &"net352" @WIRE(mode="straight") {#"I1373":1 %p2061};
//   %wire_4975 = &"net352" @WIRE(mode="straight") {%p2066 %p2064};
//   %wire_4976 = &"net352" @WIRE(mode="straight") {%p2059 %p2056};
//   %wire_4977 = &"net352" @WIRE(mode="straight") {#"I1356":1 %p2059};
//   %wire_4978 = &"net352" @WIRE(mode="straight") {#"I768":1 %p2044};
//   %wire_4979 = &"net352" @WIRE(mode="straight") {#"I1062":1 %p2058};
//   %wire_4980 = &"net352" @WIRE(mode="straight") {%p2049 %p2047};
//   %wire_4981 = &"net352" @WIRE(mode="straight") {#"I782":1 %p2046};
//   %wire_4982 = &"net352" @WIRE(mode="straight") {%p2063 %p2060};
//   %wire_4983 = &"net352" @WIRE(mode="straight") {#"I982":1 %p2054};
//   %wire_4984 = &"net352" @WIRE(mode="straight") {#"I1390":1 %p2063};
//   %wire_4985 = &"net352" @WIRE(mode="straight") {%p2055 %p2052};
//   %wire_4986 = &"net352" @WIRE(mode="straight") {%p2065 %p2062};
//   %wire_4987 = &"net352" @WIRE(mode="straight") {#"I1407":1 %p2065};
//   %wire_4988 = &"net352" @WIRE(mode="straight") {#"I942":1 %p2052};
//   %wire_4989 = &"net352" @WIRE(mode="straight") {#"I822":1 %p2047};
//   %wire_4990 = &"net352" @WIRE(mode="straight") {#"I862":1 %p2048};
//   %wire_4991 = &"net352" @WIRE(mode="straight") {#"I1339":1 %p2057};
//   %wire_4992 = &"net352" @WIRE(mode="straight") {%p2057 %p2054};
//   %wire_4993 = &"net352" @WIRE(mode="straight") {#"I1022":1 %p2056};
//   %wire_4994 = &"net352" @WIRE(mode="straight") {%p2066 #"I1431":1};
//   %wire_4995 = &"net352" @WIRE(mode="straight") {#"I1322":1 %p2055};
//   %p2067 = (348, -124);
//   %p2068 = (350, -124);
//   %wire_4996 = &"net554" @WIRE(mode="straight") {%p2067 %p2068};
//   %p2069 = (328, -124);
//   %wire_4997 = &"net554" @WIRE(mode="straight") {%p2069 %p2067};
//   %wire_4998 = &"net554" @WIRE(mode="straight") {#"I866":7 %p2069};
//   %wire_4999 = &"net554" @WIRE(mode="straight") {#"I865":6 %p2068};
//   %wire_5000 = &"net554" @WIRE(mode="straight") {#"I865":3 %p2067};
//   %p2070 = (120, -334);
//   %wire_5001 = &"net556" @WIRE(mode="straight") {#"I974":3 %p2070};
//   %p2071 = (86, -334);
//   %wire_5002 = &"net556" @WIRE(mode="straight") {%p2071 %p2070};
//   %p2072 = (122, -334);
//   %wire_5003 = &"net556" @WIRE(mode="straight") {#"I974":6 %p2072};
//   %wire_5004 = &"net556" @WIRE(mode="straight") {%p2070 %p2072};
//   %wire_5005 = &"net556" @WIRE(mode="straight") {#"I962":7 %p2071};
//   %p2073 = (276, -719);
//   %p2074 = (256, -717);
//   %wire_5006 = &"net424" @WIRE(mode="straight") {%p2073 %p2074};
//   %p2075 = (230, -719);
//   %wire_5007 = &"net424" @WIRE(mode="straight") {#"I1423":6 %p2075};
//   %wire_5008 = &"net424" @WIRE(mode="straight") {#"I1425":3 %p2073};
//   %wire_5009 = &"net424" @WIRE(mode="straight") {#"I1418":7 %p2074};
//   %wire_5010 = &"net424" @WIRE(mode="straight") {%p2075 %p2074};
//   %p2076 = (170, -719);
//   %wire_5011 = &"net429" @WIRE(mode="straight") {#"I1421":6 %p2076};
//   %p2077 = (228, -719);
//   %wire_5012 = &"net429" @WIRE(mode="straight") {#"I1423":3 %p2077};
//   %p2078 = (196, -717);
//   %wire_5013 = &"net429" @WIRE(mode="straight") {%p2077 %p2078};
//   %wire_5014 = &"net429" @WIRE(mode="straight") {%p2076 %p2078};
//   %wire_5015 = &"net429" @WIRE(mode="straight") {#"I1422":7 %p2078};
//   %p2079 = (168, -194);
//   %wire_5016 = &"net560" @WIRE(mode="straight") {#"I892":3 %p2079};
//   %p2080 = (148, -194);
//   %wire_5017 = &"net560" @WIRE(mode="straight") {%p2080 %p2079};
//   %p2081 = (170, -194);
//   %wire_5018 = &"net560" @WIRE(mode="straight") {#"I892":6 %p2081};
//   %wire_5019 = &"net560" @WIRE(mode="straight") {#"I893":7 %p2080};
//   %wire_5020 = &"net560" @WIRE(mode="straight") {%p2079 %p2081};
//   %p2082 = (205, -731);
//   %p2083 = (205, -728);
//   %wire_5021 = &"net431" @WIRE(mode="straight") {%p2082 %p2083};
//   %wire_5022 = &"net431" @WIRE(mode="straight") {#"M49":3 %p2082};
//   %p2084 = (107, -734);
//   %p2085 = (107, -731);
//   %wire_5023 = &"net431" @WIRE(mode="straight") {%p2084 %p2085};
//   %wire_5024 = &"net431" @WIRE(mode="straight") {#"I1422":4 %p2082};
//   %wire_5025 = &"net431" @WIRE(mode="straight") {#"I1421":4 #"I1422":4};
//   %wire_5026 = &"net431" @WIRE(mode="straight") {%p2085 #"I1419":4};
//   %wire_5027 = &"net431" @WIRE(mode="straight") {#"I1419":4 #"I1420":4};
//   %wire_5028 = &"net431" @WIRE(mode="straight") {#"M43":1 %p2084};
//   %wire_5029 = &"net431" @WIRE(mode="straight") {%p2083 #"M151":3};
//   %wire_5030 = &"net431" @WIRE(mode="straight") {#"I1420":4 #"I1421":4};
//   %wire_5031 = &"net431" @WIRE(mode="straight") {%p2085 #"M150":1};
//   %p2086 = (14, -507);
//   %wire_5032 = &"net562" @WIRE(mode="straight") {#"I1366":7 %p2086};
//   %p2087 = (-4, -507);
//   %wire_5033 = &"net562" @WIRE(mode="straight") {#"I1510":1 %p2087};
//   %p2088 = (34, -509);
//   %wire_5034 = &"net562" @WIRE(mode="straight") {%p2088 %p2086};
//   %wire_5035 = &"net562" @WIRE(mode="straight") {%p2087 %p2086};
//   %wire_5036 = &"net562" @WIRE(mode="straight") {#"I1365":3 %p2088};
//   %p2089 = (58, -474);
//   %p2090 = (60, -474);
//   %wire_5037 = &"net563" @WIRE(mode="straight") {%p2089 %p2090};
//   %wire_5038 = &"net563" @WIRE(mode="straight") {#"I1041":6 %p2090};
//   %p2091 = (38, -474);
//   %wire_5039 = &"net563" @WIRE(mode="straight") {#"I1040":7 %p2091};
//   %wire_5040 = &"net563" @WIRE(mode="straight") {#"I1041":3 %p2089};
//   %wire_5041 = &"net563" @WIRE(mode="straight") {%p2091 %p2089};
//   %p2092 = (82, -474);
//   %p2093 = (84, -474);
//   %wire_5042 = &"net564" @WIRE(mode="straight") {%p2092 %p2093};
//   %p2094 = (62, -474);
//   %wire_5043 = &"net564" @WIRE(mode="straight") {%p2094 %p2092};
//   %wire_5044 = &"net564" @WIRE(mode="straight") {#"I1042":3 %p2092};
//   %wire_5045 = &"net564" @WIRE(mode="straight") {#"I1041":7 %p2094};
//   %wire_5046 = &"net564" @WIRE(mode="straight") {#"I1042":6 %p2093};
//   %p2095 = (146, -719);
//   %p2096 = (172, -717);
//   %wire_5047 = &"net432" @WIRE(mode="straight") {%p2095 %p2096};
//   %p2097 = (192, -719);
//   %wire_5048 = &"net432" @WIRE(mode="straight") {%p2097 %p2096};
//   %wire_5049 = &"net432" @WIRE(mode="straight") {#"I1422":3 %p2097};
//   %wire_5050 = &"net432" @WIRE(mode="straight") {#"I1421":7 %p2096};
//   %wire_5051 = &"net432" @WIRE(mode="straight") {#"I1420":6 %p2095};
//   %p2098 = (168, -649);
//   %p2099 = (148, -647);
//   %wire_5052 = &"net433" @WIRE(mode="straight") {%p2098 %p2099};
//   %wire_5053 = &"net433" @WIRE(mode="straight") {#"I1403":7 %p2099};
//   %p2100 = (122, -649);
//   %wire_5054 = &"net433" @WIRE(mode="straight") {#"I1402":6 %p2100};
//   %wire_5055 = &"net433" @WIRE(mode="straight") {#"I1404":3 %p2098};
//   %wire_5056 = &"net433" @WIRE(mode="straight") {%p2100 %p2099};
//   %p2101 = (192, -474);
//   %p2102 = (194, -474);
//   %wire_5057 = &"net567" @WIRE(mode="straight") {%p2101 %p2102};
//   %wire_5058 = &"net567" @WIRE(mode="straight") {#"I1051":6 %p2102};
//   %p2103 = (172, -474);
//   %wire_5059 = &"net567" @WIRE(mode="straight") {%p2103 %p2101};
//   %wire_5060 = &"net567" @WIRE(mode="straight") {#"I1051":3 %p2101};
//   %wire_5061 = &"net567" @WIRE(mode="straight") {#"I1052":7 %p2103};
//   %p2104 = (196, -474);
//   %p2105 = (228, -474);
//   %wire_5062 = &"net568" @WIRE(mode="straight") {%p2104 %p2105};
//   %wire_5063 = &"net568" @WIRE(mode="straight") {#"I1051":7 %p2104};
//   %wire_5064 = &"net568" @WIRE(mode="straight") {#"I1050":3 %p2105};
//   %p2106 = (230, -474);
//   %wire_5065 = &"net568" @WIRE(mode="straight") {%p2105 %p2106};
//   %wire_5066 = &"net568" @WIRE(mode="straight") {#"I1050":6 %p2106};
//   %wire_5067 = &"net480" @WIRE(mode="straight") {#"I1521":1 #"I1522":3};
//   %p2107 = (60, -19);
//   %wire_5068 = &"net8" @WIRE(mode="straight") {#"I772":6 %p2107};
//   %p2108 = (86, -17);
//   %wire_5069 = &"net8" @WIRE(mode="straight") {%p2107 %p2108};
//   %p2109 = (120, -19);
//   %wire_5070 = &"net8" @WIRE(mode="straight") {#"I781":3 %p2109};
//   %wire_5071 = &"net8" @WIRE(mode="straight") {%p2109 %p2108};
//   %wire_5072 = &"net8" @WIRE(mode="straight") {#"I773":7 %p2108};
//   %p2110 = (148, -717);
//   %wire_5073 = &"net436" @WIRE(mode="straight") {#"I1420":7 %p2110};
//   %p2111 = (168, -719);
//   %wire_5074 = &"net436" @WIRE(mode="straight") {#"I1421":3 %p2111};
//   %p2112 = (122, -719);
//   %wire_5075 = &"net436" @WIRE(mode="straight") {#"I1419":6 %p2112};
//   %wire_5076 = &"net436" @WIRE(mode="straight") {%p2112 %p2110};
//   %wire_5077 = &"net436" @WIRE(mode="straight") {%p2111 %p2110};
//   %p2113 = (38, -404);
//   %p2114 = (58, -404);
//   %wire_5078 = &"net572" @WIRE(mode="straight") {%p2113 %p2114};
//   %wire_5079 = &"net572" @WIRE(mode="straight") {#"I1001":3 %p2114};
//   %wire_5080 = &"net572" @WIRE(mode="straight") {#"I1000":7 %p2113};
//   %p2115 = (60, -404);
//   %wire_5081 = &"net572" @WIRE(mode="straight") {%p2114 %p2115};
//   %wire_5082 = &"net572" @WIRE(mode="straight") {#"I1001":6 %p2115};
//   %p2116 = (84, -719);
//   %wire_5083 = &"net437" @WIRE(mode="straight") {#"I1414":6 %p2116};
//   %p2117 = (144, -719);
//   %wire_5084 = &"net437" @WIRE(mode="straight") {#"I1420":3 %p2117};
//   %p2118 = (124, -717);
//   %wire_5085 = &"net437" @WIRE(mode="straight") {%p2118 %p2116};
//   %wire_5086 = &"net437" @WIRE(mode="straight") {%p2117 %p2118};
//   %wire_5087 = &"net437" @WIRE(mode="straight") {#"I1419":7 %p2118};
//   %p2119 = (196, -404);
//   %p2120 = (228, -404);
//   %wire_5088 = &"net574" @WIRE(mode="straight") {%p2119 %p2120};
//   %p2121 = (230, -404);
//   %wire_5089 = &"net574" @WIRE(mode="straight") {%p2120 %p2121};
//   %wire_5090 = &"net574" @WIRE(mode="straight") {#"I1011":7 %p2119};
//   %wire_5091 = &"net574" @WIRE(mode="straight") {#"I1010":3 %p2120};
//   %wire_5092 = &"net574" @WIRE(mode="straight") {#"I1010":6 %p2121};
//   %p2122 = (376, -717);
//   %wire_5093 = &"net438" @WIRE(mode="straight") {#"I1429":7 %p2122};
//   %p2123 = (350, -719);
//   %wire_5094 = &"net438" @WIRE(mode="straight") {#"I1428":6 %p2123};
//   %p2124 = (396, -719);
//   %wire_5095 = &"net438" @WIRE(mode="straight") {%p2124 %p2122};
//   %wire_5096 = &"net438" @WIRE(mode="straight") {#"I1430":3 %p2124};
//   %wire_5097 = &"net438" @WIRE(mode="straight") {%p2123 %p2122};
//   %p2125 = (400, -717);
//   %wire_5098 = &"net439" @WIRE(mode="straight") {#"I1430":7 %p2125};
//   %p2126 = (374, -719);
//   %wire_5099 = &"net439" @WIRE(mode="straight") {%p2126 %p2125};
//   %wire_5100 = &"net439" @WIRE(mode="straight") {#"I1429":6 %p2126};
//   %p2127 = (192, -544);
//   %p2128 = (194, -544);
//   %wire_5101 = &"net578" @WIRE(mode="straight") {%p2127 %p2128};
//   %wire_5102 = &"net578" @WIRE(mode="straight") {#"I1091":6 %p2128};
//   %p2129 = (172, -544);
//   %wire_5103 = &"net578" @WIRE(mode="straight") {%p2129 %p2127};
//   %wire_5104 = &"net578" @WIRE(mode="straight") {#"I1091":3 %p2127};
//   %wire_5105 = &"net578" @WIRE(mode="straight") {#"I1092":7 %p2129};
//   %p2130 = (146, -614);
//   %wire_5106 = &"net579" @WIRE(mode="straight") {#"I1133":6 %p2130};
//   %p2131 = (144, -614);
//   %wire_5107 = &"net579" @WIRE(mode="straight") {%p2131 %p2130};
//   %wire_5108 = &"net579" @WIRE(mode="straight") {#"I1133":3 %p2131};
//   %p2132 = (124, -614);
//   %wire_5109 = &"net579" @WIRE(mode="straight") {%p2132 %p2131};
//   %wire_5110 = &"net579" @WIRE(mode="straight") {#"I1134":7 %p2132};
//   %p2133 = (372, -719);
//   %p2134 = (352, -717);
//   %wire_5111 = &"net440" @WIRE(mode="straight") {%p2133 %p2134};
//   %p2135 = (326, -719);
//   %wire_5112 = &"net440" @WIRE(mode="straight") {#"I1427":6 %p2135};
//   %wire_5113 = &"net440" @WIRE(mode="straight") {%p2135 %p2134};
//   %wire_5114 = &"net440" @WIRE(mode="straight") {#"I1429":3 %p2133};
//   %wire_5115 = &"net440" @WIRE(mode="straight") {#"I1428":7 %p2134};
//   %wire_5116 = &"net426" @WIRE(mode="straight") {#"I1491":1 #"I1492":3};
//   %p2136 = (348, -719);
//   %wire_5117 = &"net441" @WIRE(mode="straight") {#"I1428":3 %p2136};
//   %p2137 = (328, -717);
//   %wire_5118 = &"net441" @WIRE(mode="straight") {%p2136 %p2137};
//   %wire_5119 = &"net441" @WIRE(mode="straight") {#"I1427":7 %p2137};
//   %p2138 = (302, -719);
//   %wire_5120 = &"net441" @WIRE(mode="straight") {%p2138 %p2137};
//   %wire_5121 = &"net441" @WIRE(mode="straight") {#"I1426":6 %p2138};
//   %p2139 = (324, -719);
//   %p2140 = (304, -717);
//   %wire_5122 = &"net442" @WIRE(mode="straight") {%p2139 %p2140};
//   %p2141 = (278, -719);
//   %wire_5123 = &"net442" @WIRE(mode="straight") {%p2141 %p2140};
//   %wire_5124 = &"net442" @WIRE(mode="straight") {#"I1426":7 %p2140};
//   %wire_5125 = &"net442" @WIRE(mode="straight") {#"I1427":3 %p2139};
//   %wire_5126 = &"net442" @WIRE(mode="straight") {#"I1425":6 %p2141};
//   %p2142 = (148, -404);
//   %p2143 = (168, -404);
//   %wire_5127 = &"net587" @WIRE(mode="straight") {%p2142 %p2143};
//   %wire_5128 = &"net587" @WIRE(mode="straight") {#"I1012":3 %p2143};
//   %p2144 = (170, -404);
//   %wire_5129 = &"net587" @WIRE(mode="straight") {%p2143 %p2144};
//   %wire_5130 = &"net587" @WIRE(mode="straight") {#"I1013":7 %p2142};
//   %wire_5131 = &"net587" @WIRE(mode="straight") {#"I1012":6 %p2144};
//   %p2145 = (348, -229);
//   %wire_5132 = &"net450" @WIRE(mode="straight") {#"I1309":3 %p2145};
//   %p2146 = (328, -227);
//   %wire_5133 = &"net450" @WIRE(mode="straight") {%p2145 %p2146};
//   %wire_5134 = &"net450" @WIRE(mode="straight") {#"I1308":7 %p2146};
//   %p2147 = (302, -229);
//   %wire_5135 = &"net450" @WIRE(mode="straight") {%p2147 %p2146};
//   %wire_5136 = &"net450" @WIRE(mode="straight") {#"I1307":6 %p2147};
//   %p2148 = (304, -404);
//   %wire_5137 = &"net589" @WIRE(mode="straight") {#"I1027":7 %p2148};
//   %p2149 = (324, -404);
//   %wire_5138 = &"net589" @WIRE(mode="straight") {#"I1026":3 %p2149};
//   %p2150 = (326, -404);
//   %wire_5139 = &"net589" @WIRE(mode="straight") {%p2149 %p2150};
//   %wire_5140 = &"net589" @WIRE(mode="straight") {#"I1026":6 %p2150};
//   %wire_5141 = &"net589" @WIRE(mode="straight") {%p2148 %p2149};
//   %p2151 = (352, -264);
//   %wire_5142 = &"net590" @WIRE(mode="straight") {#"I945":7 %p2151};
//   %p2152 = (372, -264);
//   %wire_5143 = &"net590" @WIRE(mode="straight") {%p2151 %p2152};
//   %p2153 = (374, -264);
//   %wire_5144 = &"net590" @WIRE(mode="straight") {#"I944":6 %p2153};
//   %wire_5145 = &"net590" @WIRE(mode="straight") {#"I944":3 %p2152};
//   %wire_5146 = &"net590" @WIRE(mode="straight") {%p2152 %p2153};
//   %p2154 = (172, -404);
//   %wire_5147 = &"net592" @WIRE(mode="straight") {#"I1012":7 %p2154};
//   %p2155 = (192, -404);
//   %wire_5148 = &"net592" @WIRE(mode="straight") {%p2154 %p2155};
//   %wire_5149 = &"net592" @WIRE(mode="straight") {#"I1011":3 %p2155};
//   %p2156 = (194, -404);
//   %wire_5150 = &"net592" @WIRE(mode="straight") {#"I1011":6 %p2156};
//   %wire_5151 = &"net592" @WIRE(mode="straight") {%p2155 %p2156};
//   %p2157 = (124, -194);
//   %p2158 = (144, -194);
//   %wire_5152 = &"net594" @WIRE(mode="straight") {%p2157 %p2158};
//   %wire_5153 = &"net594" @WIRE(mode="straight") {#"I894":7 %p2157};
//   %wire_5154 = &"net594" @WIRE(mode="straight") {#"I893":3 %p2158};
//   %p2159 = (146, -194);
//   %wire_5155 = &"net594" @WIRE(mode="straight") {%p2158 %p2159};
//   %wire_5156 = &"net594" @WIRE(mode="straight") {#"I893":6 %p2159};
//   %p2160 = (82, -404);
//   %p2161 = (84, -404);
//   %wire_5157 = &"net595" @WIRE(mode="straight") {%p2160 %p2161};
//   %wire_5158 = &"net595" @WIRE(mode="straight") {#"I1002":6 %p2161};
//   %wire_5159 = &"net595" @WIRE(mode="straight") {#"I1002":3 %p2160};
//   %p2162 = (62, -404);
//   %wire_5160 = &"net595" @WIRE(mode="straight") {%p2162 %p2160};
//   %wire_5161 = &"net595" @WIRE(mode="straight") {#"I1001":7 %p2162};
//   %p2163 = (326, -229);
//   %p2164 = (352, -227);
//   %wire_5162 = &"net454" @WIRE(mode="straight") {%p2163 %p2164};
//   %wire_5163 = &"net454" @WIRE(mode="straight") {#"I1308":6 %p2163};
//   %p2165 = (372, -229);
//   %wire_5164 = &"net454" @WIRE(mode="straight") {%p2165 %p2164};
//   %wire_5165 = &"net454" @WIRE(mode="straight") {#"I1309":7 %p2164};
//   %wire_5166 = &"net454" @WIRE(mode="straight") {#"I1310":3 %p2165};
//   %p2166 = (36, -474);
//   %wire_5167 = &"net599" @WIRE(mode="straight") {#"I1040":6 %p2166};
//   %p2167 = (34, -474);
//   %wire_5168 = &"net599" @WIRE(mode="straight") {#"I1040":3 %p2167};
//   %p2168 = (14, -474);
//   %wire_5169 = &"net599" @WIRE(mode="straight") {#"I1039":7 %p2168};
//   %wire_5170 = &"net599" @WIRE(mode="straight") {%p2167 %p2166};
//   %wire_5171 = &"net599" @WIRE(mode="straight") {%p2168 %p2167};
//   %p2169 = (146, -684);
//   %wire_5172 = &"net600" @WIRE(mode="straight") {#"I1173":6 %p2169};
//   %p2170 = (144, -684);
//   %wire_5173 = &"net600" @WIRE(mode="straight") {%p2170 %p2169};
//   %wire_5174 = &"net600" @WIRE(mode="straight") {#"I1173":3 %p2170};
//   %p2171 = (124, -684);
//   %wire_5175 = &"net600" @WIRE(mode="straight") {%p2171 %p2170};
//   %wire_5176 = &"net600" @WIRE(mode="straight") {#"I1174":7 %p2171};
//   %p2172 = (84, -19);
//   %wire_5177 = &"net5" @WIRE(mode="straight") {#"I773":6 %p2172};
//   %p2173 = (124, -17);
//   %wire_5178 = &"net5" @WIRE(mode="straight") {#"I781":7 %p2173};
//   %p2174 = (144, -19);
//   %wire_5179 = &"net5" @WIRE(mode="straight") {#"I780":3 %p2174};
//   %wire_5180 = &"net5" @WIRE(mode="straight") {%p2174 %p2173};
//   %wire_5181 = &"net5" @WIRE(mode="straight") {%p2173 %p2172};
//   %p2175 = (146, -159);
//   %wire_5182 = &"net455" @WIRE(mode="straight") {#"I1284":6 %p2175};
//   %p2176 = (192, -159);
//   %wire_5183 = &"net455" @WIRE(mode="straight") {#"I1286":3 %p2176};
//   %p2177 = (172, -157);
//   %wire_5184 = &"net455" @WIRE(mode="straight") {%p2176 %p2177};
//   %wire_5185 = &"net455" @WIRE(mode="straight") {#"I1285":7 %p2177};
//   %wire_5186 = &"net455" @WIRE(mode="straight") {%p2175 %p2177};
//   %p2178 = (34, -334);
//   %p2179 = (36, -334);
//   %wire_5187 = &"net607" @WIRE(mode="straight") {%p2178 %p2179};
//   %p2180 = (14, -334);
//   %wire_5188 = &"net607" @WIRE(mode="straight") {#"I959":7 %p2180};
//   %wire_5189 = &"net607" @WIRE(mode="straight") {%p2180 %p2178};
//   %wire_5190 = &"net607" @WIRE(mode="straight") {#"I960":6 %p2179};
//   %wire_5191 = &"net607" @WIRE(mode="straight") {#"I960":3 %p2178};
//   %p2181 = (122, -159);
//   %wire_5192 = &"net456" @WIRE(mode="straight") {#"I1283":6 %p2181};
//   %p2182 = (168, -159);
//   %wire_5193 = &"net456" @WIRE(mode="straight") {#"I1285":3 %p2182};
//   %p2183 = (148, -157);
//   %wire_5194 = &"net456" @WIRE(mode="straight") {%p2182 %p2183};
//   %wire_5195 = &"net456" @WIRE(mode="straight") {#"I1284":7 %p2183};
//   %wire_5196 = &"net456" @WIRE(mode="straight") {%p2181 %p2183};
//   %p2184 = (398, -614);
//   %wire_5197 = &"net613" @WIRE(mode="straight") {#"I1143":6 %p2184};
//   %p2185 = (396, -614);
//   %wire_5198 = &"net613" @WIRE(mode="straight") {%p2185 %p2184};
//   %wire_5199 = &"net613" @WIRE(mode="straight") {#"I1143":3 %p2185};
//   %p2186 = (376, -614);
//   %wire_5200 = &"net613" @WIRE(mode="straight") {%p2186 %p2185};
//   %wire_5201 = &"net613" @WIRE(mode="straight") {#"I1144":7 %p2186};
//   %p2187 = (146, -264);
//   %wire_5202 = &"net616" @WIRE(mode="straight") {#"I933":6 %p2187};
//   %p2188 = (144, -264);
//   %wire_5203 = &"net616" @WIRE(mode="straight") {%p2188 %p2187};
//   %p2189 = (124, -264);
//   %wire_5204 = &"net616" @WIRE(mode="straight") {#"I934":7 %p2189};
//   %wire_5205 = &"net616" @WIRE(mode="straight") {#"I933":3 %p2188};
//   %wire_5206 = &"net616" @WIRE(mode="straight") {%p2189 %p2188};
//   %p2190 = (372, -579);
//   %wire_5207 = &"net457" @WIRE(mode="straight") {#"I1395":3 %p2190};
//   %p2191 = (352, -577);
//   %wire_5208 = &"net457" @WIRE(mode="straight") {#"I1394":7 %p2191};
//   %p2192 = (326, -579);
//   %wire_5209 = &"net457" @WIRE(mode="straight") {#"I1393":6 %p2192};
//   %wire_5210 = &"net457" @WIRE(mode="straight") {%p2192 %p2191};
//   %wire_5211 = &"net457" @WIRE(mode="straight") {%p2190 %p2191};
//   %p2193 = (196, -544);
//   %wire_5212 = &"net618" @WIRE(mode="straight") {#"I1091":7 %p2193};
//   %p2194 = (230, -544);
//   %wire_5213 = &"net618" @WIRE(mode="straight") {#"I1090":6 %p2194};
//   %p2195 = (228, -544);
//   %wire_5214 = &"net618" @WIRE(mode="straight") {%p2193 %p2195};
//   %wire_5215 = &"net618" @WIRE(mode="straight") {%p2195 %p2194};
//   %wire_5216 = &"net618" @WIRE(mode="straight") {#"I1090":3 %p2195};
//   %wire_5217 = &"net481" @WIRE(mode="straight") {#"I1523":1 #"I1524":3};
//   %p2196 = (58, -299);
//   %p2197 = (38, -297);
//   %wire_5218 = &"net458" @WIRE(mode="straight") {%p2196 %p2197};
//   %p2198 = (12, -299);
//   %wire_5219 = &"net458" @WIRE(mode="straight") {%p2198 %p2197};
//   %wire_5220 = &"net458" @WIRE(mode="straight") {#"I1314":7 %p2197};
//   %wire_5221 = &"net458" @WIRE(mode="straight") {#"I1313":3 %p2196};
//   %wire_5222 = &"net458" @WIRE(mode="straight") {#"I1315":6 %p2198};
//   %p2199 = (122, -404);
//   %wire_5223 = &"net623" @WIRE(mode="straight") {#"I1014":6 %p2199};
//   %p2200 = (120, -404);
//   %wire_5224 = &"net623" @WIRE(mode="straight") {#"I1014":3 %p2200};
//   %wire_5225 = &"net623" @WIRE(mode="straight") {%p2200 %p2199};
//   %p2201 = (86, -404);
//   %wire_5226 = &"net623" @WIRE(mode="straight") {#"I1002":7 %p2201};
//   %wire_5227 = &"net623" @WIRE(mode="straight") {%p2201 %p2200};
//   %p2202 = (324, -229);
//   %wire_5228 = &"net459" @WIRE(mode="straight") {#"I1308":3 %p2202};
//   %p2203 = (304, -227);
//   %wire_5229 = &"net459" @WIRE(mode="straight") {%p2202 %p2203};
//   %p2204 = (278, -229);
//   %wire_5230 = &"net459" @WIRE(mode="straight") {%p2204 %p2203};
//   %wire_5231 = &"net459" @WIRE(mode="straight") {#"I1306":6 %p2204};
//   %wire_5232 = &"net459" @WIRE(mode="straight") {#"I1307":7 %p2203};
//   %p2205 = (398, -400);
//   %wire_5233 = &"net626" @WIRE(mode="straight") {%p2205 #"I1345":6};
//   %p2206 = (400, -400);
//   %wire_5234 = &"net626" @WIRE(mode="straight") {%p2205 %p2206};
//   %wire_5235 = &"net626" @WIRE(mode="straight") {#"I1023":7 %p2206};
//   %p2207 = (228, -159);
//   %wire_5236 = &"net462" @WIRE(mode="straight") {#"I1287":3 %p2207};
//   %p2208 = (196, -157);
//   %wire_5237 = &"net462" @WIRE(mode="straight") {%p2207 %p2208};
//   %wire_5238 = &"net462" @WIRE(mode="straight") {#"I1286":7 %p2208};
//   %p2209 = (170, -159);
//   %wire_5239 = &"net462" @WIRE(mode="straight") {%p2209 %p2208};
//   %wire_5240 = &"net462" @WIRE(mode="straight") {#"I1285":6 %p2209};
//   %p2210 = (144, -404);
//   %wire_5241 = &"net628" @WIRE(mode="straight") {#"I1013":3 %p2210};
//   %p2211 = (124, -404);
//   %wire_5242 = &"net628" @WIRE(mode="straight") {%p2211 %p2210};
//   %wire_5243 = &"net628" @WIRE(mode="straight") {#"I1014":7 %p2211};
//   %p2212 = (146, -404);
//   %wire_5244 = &"net628" @WIRE(mode="straight") {#"I1013":6 %p2212};
//   %wire_5245 = &"net628" @WIRE(mode="straight") {%p2210 %p2212};
//   %p2213 = (252, -159);
//   %p2214 = (232, -157);
//   %wire_5246 = &"net469" @WIRE(mode="straight") {%p2213 %p2214};
//   %wire_5247 = &"net469" @WIRE(mode="straight") {#"I1282":3 %p2213};
//   %wire_5248 = &"net469" @WIRE(mode="straight") {#"I1287":7 %p2214};
//   %p2215 = (194, -159);
//   %wire_5249 = &"net469" @WIRE(mode="straight") {%p2215 %p2214};
//   %wire_5250 = &"net469" @WIRE(mode="straight") {#"I1286":6 %p2215};
//   %p2216 = (-23, -302);
//   %wire_5251 = &"net2177" @WIRE(mode="straight") {%p2216 #"M73":2};
//   %p2217 = (-23, -265);
//   %wire_5252 = &"net2177" @WIRE(mode="straight") {%p2216 %p2217};
//   %wire_5253 = &"net2177" @WIRE(mode="straight") {#"I1486":3 #"M73":2};
//   %wire_5254 = &"net2177" @WIRE(mode="straight") {%p2217 #"I1493":1};
//   %wire_5255 = &"net482" @WIRE(mode="straight") {#"I1467":1 #"I1468":3};
//   %wire_5256 = &"net507" @WIRE(mode="straight") {#"I1529":1 #"I1530":3};
//   %wire_5257 = &"net506" @WIRE(mode="straight") {#"I1530":1 #"I1527":2};
//   %p2218 = (12, -407);
//   %wire_5258 = &"net2253" @WIRE(mode="straight") {#"I999":6 %p2218};
//   %wire_5259 = &"net2253" @WIRE(mode="straight") {#"I1509":3 #"M78":2};
//   %wire_5260 = &"net2253" @WIRE(mode="straight") {#"M78":2 %p2218};
//   %wire_5261 = &"net505" @WIRE(mode="straight") {#"I1531":1 #"I1532":3};
//   %p2219 = (82, -194);
//   %wire_5262 = &"net19" @WIRE(mode="straight") {#"I882":3 %p2219};
//   %p2220 = (84, -194);
//   %wire_5263 = &"net19" @WIRE(mode="straight") {%p2219 %p2220};
//   %wire_5264 = &"net19" @WIRE(mode="straight") {#"I882":6 %p2220};
//   %p2221 = (62, -194);
//   %wire_5265 = &"net19" @WIRE(mode="straight") {%p2221 %p2219};
//   %wire_5266 = &"net19" @WIRE(mode="straight") {#"I881":7 %p2221};
//   %p2222 = (51, -773);
//   %wire_5267 = &"FRAME_2" @WIRE(mode="straight") {%p2222 #"I1193":1};
//   %wire_5267 @TEXT("FRAME\_2", size=1, halign="middle", valign="baseline", rotate=90) => @PLACE(50.3, -768);
//   %p2223 = (27, -773);
//   %wire_5268 = &"FRAME_1" @WIRE(mode="straight") {%p2223 #"I1191":1};
//   %wire_5268 @TEXT("FRAME\_1", size=1, halign="middle", valign="baseline", rotate=90) => @PLACE(26.3, -768);
//   %wire_5269 = &"net504" @WIRE(mode="straight") {#"I1532":1 #"I1528":2};
//   %wire_5270 = &"net501" @WIRE(mode="straight") {#"I1537":1 #"I1538":3};
//   %wire_5271 = &"net499" @WIRE(mode="straight") {#"I1538":1 #"I1535":2};
//   %wire_5272 = &"net498" @WIRE(mode="straight") {#"I1539":1 #"I1540":3};
//   %wire_5273 = &"net497" @WIRE(mode="straight") {#"I1540":1 #"I1536":2};
//   %wire_5274 = &"net496" @WIRE(mode="straight") {#"I1516":1 #"I1512":2};
//   %wire_5275 = &"net494" @WIRE(mode="straight") {#"I1522":1 #"I1519":2};
//   %wire_5276 = &"net493" @WIRE(mode="straight") {#"I1524":1 #"I1520":2};
//   %wire_5277 = &"net488" @WIRE(mode="straight") {#"I1482":1 #"I1479":2};
//   %wire_5278 = &"net487" @WIRE(mode="straight") {#"I1481":1 #"I1482":3};
//   %wire_5279 = &"net486" @WIRE(mode="straight") {#"I1507":1 #"I1508":3};
//   %wire_5280 = &"net484" @WIRE(mode="straight") {#"I1468":1 #"I1464":2};
//   %wire_5281 = &"net483" @WIRE(mode="straight") {#"I1515":1 #"I1516":3};
//   %p2224 = (396, -194);
//   %wire_5282 = &"net85" @WIRE(mode="straight") {#"I903":3 %p2224};
//   %p2225 = (376, -194);
//   %wire_5283 = &"net85" @WIRE(mode="straight") {%p2225 %p2224};
//   %p2226 = (398, -194);
//   %wire_5284 = &"net85" @WIRE(mode="straight") {%p2224 %p2226};
//   %wire_5285 = &"net85" @WIRE(mode="straight") {#"I903":6 %p2226};
//   %wire_5286 = &"net85" @WIRE(mode="straight") {#"I904":7 %p2225};
//   %wire_5287 = &"net247" @WIRE(mode="straight") {#"I1505":1 #"I1506":3};
//   %p2227 = (62, -773);
//   %wire_5288 = &"REPET_2" @WIRE(mode="straight") {%p2227 #"I1622":1};
//   %wire_5288 @TEXT("REPET\_2", size=1, halign="middle", valign="baseline", rotate=90) => @PLACE(61.3, -768);
//   %p2228 = (86, -773);
//   %wire_5289 = &"REPET_3" @WIRE(mode="straight") {%p2228 #"I1623":1};
//   %wire_5289 @TEXT("REPET\_3", size=1, halign="middle", valign="baseline", rotate=90) => @PLACE(85.3, -768);
//   %p2229 = (104, -794);
//   %wire_5290 = &"REPET_4" @WIRE(mode="straight") {%p2229 #"I1221":1};
//   %wire_5290 @TEXT("REPET\_4", size=1, halign="middle", valign="baseline", rotate=90) => @PLACE(103.3, -794);
//   %p2230 = (124, -773);
//   %wire_5291 = &"REPET_5" @WIRE(mode="straight") {%p2230 #"I1624":1};
//   %wire_5291 @TEXT("REPET\_5", size=1, halign="middle", valign="baseline", rotate=90) => @PLACE(123.3, -768);
//   %p2231 = (148, -773);
//   %wire_5292 = &"REPET_6" @WIRE(mode="straight") {%p2231 #"I1625":1};
//   %wire_5292 @TEXT("REPET\_6", size=1, halign="middle", valign="baseline", rotate=90) => @PLACE(147.3, -768);
//   %p2232 = (172, -773);
//   %wire_5293 = &"REPET_7" @WIRE(mode="straight") {%p2232 #"I1635":1};
//   %wire_5293 @TEXT("REPET\_7", size=1, halign="middle", valign="baseline", rotate=90) => @PLACE(171.3, -768);
//   %p2233 = (196, -773);
//   %wire_5294 = &"REPET_8" @WIRE(mode="straight") {%p2233 #"I1626":1};
//   %wire_5294 @TEXT("REPET\_8", size=1, halign="middle", valign="baseline", rotate=90) => @PLACE(195.3, -768);
//   %p2234 = (212, -794);
//   %wire_5295 = &"REPET_9" @WIRE(mode="straight") {%p2234 #"I1456":1};
//   %wire_5295 @TEXT("REPET\_9", size=1, halign="middle", valign="baseline", rotate=90) => @PLACE(211.3, -794);
//   %p2235 = (232, -773);
//   %wire_5296 = &"REPET_10" @WIRE(mode="straight") {%p2235 #"I1627":1};
//   %wire_5296 @TEXT("REPET\_10", size=1, halign="middle", valign="baseline", rotate=90) => @PLACE(231.3, -768);
//   %p2236 = (256, -773);
//   %wire_5297 = &"REPET_11" @WIRE(mode="straight") {%p2236 #"I1628":1};
//   %wire_5297 @TEXT("REPET\_11", size=1, halign="middle", valign="baseline", rotate=90) => @PLACE(255.3, -768);
//   %p2237 = (280, -773);
//   %wire_5298 = &"REPET_12" @WIRE(mode="straight") {%p2237 #"I1629":1};
//   %wire_5298 @TEXT("REPET\_12", size=1, halign="middle", valign="baseline", rotate=90) => @PLACE(279.3, -768);
//   %p2238 = (304, -773);
//   %wire_5299 = &"REPET_13" @WIRE(mode="straight") {%p2238 #"I1630":1};
//   %wire_5299 @TEXT("REPET\_13", size=1, halign="middle", valign="baseline", rotate=90) => @PLACE(303.3, -768);
//   %p2239 = (328, -773);
//   %wire_5300 = &"REPET_14" @WIRE(mode="straight") {%p2239 #"I1631":1};
//   %wire_5300 @TEXT("REPET\_14", size=1, halign="middle", valign="baseline", rotate=90) => @PLACE(327.3, -768);
//   %p2240 = (352, -773);
//   %wire_5301 = &"REPET_15" @WIRE(mode="straight") {%p2240 #"I1632":1};
//   %wire_5301 @TEXT("REPET\_15", size=1, halign="middle", valign="baseline", rotate=90) => @PLACE(351.3, -768);
//   %p2241 = (-68, -732);
//   %wire_5302 = &"OUT_0" @WIRE(mode="straight") {%p2241 #"I1537":2};
//   %wire_5302 @TEXT("OUT\_0", size=1, halign="middle", valign="baseline") => @PLACE(-65, -731.3);
//   %p2242 = (38, -773);
//   %wire_5303 = &"REPET_1" @WIRE(mode="straight") {%p2242 #"I1621":1};
//   %wire_5303 @TEXT("REPET\_1", size=1, halign="middle", valign="baseline", rotate=90) => @PLACE(37.3, -768);
//   %p2243 = (448, 86);
//   %wire_5304 = &"SDO" @WIRE(mode="straight") {#"I1608":2 %p2243};
//   %wire_5304 @TEXT("SDO", size=1, halign="middle", valign="baseline") => @PLACE(445, 86.7);
//   %p2244 = (447, -717);
//   %wire_5305 = &"SDI" @WIRE(mode="straight") {#"I1260":1 %p2244};
//   %wire_5305 @TEXT("SDI", size=1, halign="middle", valign="baseline") => @PLACE(444, -716.3);
//   %p2245 = (-68, -172);
//   %wire_5306 = &"OUT_16" @WIRE(mode="straight") {%p2245 #"I1473":2};
//   %wire_5306 @TEXT("OUT\_16", size=1, halign="middle", valign="baseline") => @PLACE(-65, -171.3);
//   %p2246 = (-68, -207);
//   %wire_5307 = &"OUT_15" @WIRE(mode="straight") {%p2246 #"I1483":2};
//   %wire_5307 @TEXT("OUT\_15", size=1, halign="middle", valign="baseline") => @PLACE(-65, -206.3);
//   %p2247 = (-68, -242);
//   %wire_5308 = &"OUT_14" @WIRE(mode="straight") {%p2247 #"I1481":2};
//   %wire_5308 @TEXT("OUT\_14", size=1, halign="middle", valign="baseline") => @PLACE(-65, -241.3);
//   %p2248 = (-68, -277);
//   %wire_5309 = &"OUT_13" @WIRE(mode="straight") {%p2248 #"I1491":2};
//   %wire_5309 @TEXT("OUT\_13", size=1, halign="middle", valign="baseline") => @PLACE(-65, -276.3);
//   %p2249 = (-68, -312);
//   %wire_5310 = &"OUT_12" @WIRE(mode="straight") {%p2249 #"I1489":2};
//   %wire_5310 @TEXT("OUT\_12", size=1, halign="middle", valign="baseline") => @PLACE(-65, -311.3);
//   %p2250 = (-68, -347);
//   %wire_5311 = &"OUT_11" @WIRE(mode="straight") {%p2250 #"I1499":2};
//   %wire_5311 @TEXT("OUT\_11", size=1, halign="middle", valign="baseline") => @PLACE(-65, -346.3);
//   %p2251 = (-68, -382);
//   %wire_5312 = &"OUT_10" @WIRE(mode="straight") {%p2251 #"I1497":2};
//   %wire_5312 @TEXT("OUT\_10", size=1, halign="middle", valign="baseline") => @PLACE(-65, -381.3);
//   %p2252 = (-68, -417);
//   %wire_5313 = &"OUT_9" @WIRE(mode="straight") {%p2252 #"I1507":2};
//   %wire_5313 @TEXT("OUT\_9", size=1, halign="middle", valign="baseline") => @PLACE(-65, -416.3);
//   %p2253 = (-68, -452);
//   %wire_5314 = &"OUT_8" @WIRE(mode="straight") {%p2253 #"I1505":2};
//   %wire_5314 @TEXT("OUT\_8", size=1, halign="middle", valign="baseline") => @PLACE(-65, -451.3);
//   %p2254 = (-68, -487);
//   %wire_5315 = &"OUT_7" @WIRE(mode="straight") {%p2254 #"I1515":2};
//   %wire_5315 @TEXT("OUT\_7", size=1, halign="middle", valign="baseline") => @PLACE(-65, -486.3);
//   %p2255 = (-68, -522);
//   %wire_5316 = &"OUT_6" @WIRE(mode="straight") {%p2255 #"I1513":2};
//   %wire_5316 @TEXT("OUT\_6", size=1, halign="middle", valign="baseline") => @PLACE(-65, -521.3);
//   %p2256 = (-68, -557);
//   %wire_5317 = &"OUT_5" @WIRE(mode="straight") {%p2256 #"I1523":2};
//   %wire_5317 @TEXT("OUT\_5", size=1, halign="middle", valign="baseline") => @PLACE(-65, -556.3);
//   %p2257 = (-68, -592);
//   %wire_5318 = &"OUT_4" @WIRE(mode="straight") {%p2257 #"I1521":2};
//   %wire_5318 @TEXT("OUT\_4", size=1, halign="middle", valign="baseline") => @PLACE(-65, -591.3);
//   %p2258 = (-68, -627);
//   %wire_5319 = &"OUT_3" @WIRE(mode="straight") {%p2258 #"I1531":2};
//   %wire_5319 @TEXT("OUT\_3", size=1, halign="middle", valign="baseline") => @PLACE(-65, -626.3);
//   %p2259 = (-68, -662);
//   %wire_5320 = &"OUT_2" @WIRE(mode="straight") {%p2259 #"I1529":2};
//   %wire_5320 @TEXT("OUT\_2", size=1, halign="middle", valign="baseline") => @PLACE(-65, -661.3);
//   %p2260 = (-68, -697);
//   %wire_5321 = &"OUT_1" @WIRE(mode="straight") {%p2260 #"I1539":2};
//   %wire_5321 @TEXT("OUT\_1", size=1, halign="middle", valign="baseline") => @PLACE(-65, -696.3);
//   %p2261 = (185, -773);
//   %wire_5322 = &"FRAME_7" @WIRE(mode="straight") {%p2261 #"I1199":1};
//   %wire_5322 @TEXT("FRAME\_7", size=1, halign="middle", valign="baseline", rotate=90) => @PLACE(184.3, -768);
//   %p2262 = (161, -773);
//   %wire_5323 = &"FRAME_6" @WIRE(mode="straight") {%p2262 #"I1204":1};
//   %wire_5323 @TEXT("FRAME\_6", size=1, halign="middle", valign="baseline", rotate=90) => @PLACE(160.3, -768);
//   %p2263 = (221, -773);
//   %wire_5324 = &"FRAME_8" @WIRE(mode="straight") {%p2263 #"I1212":1};
//   %wire_5324 @TEXT("FRAME\_8", size=1, halign="middle", valign="baseline", rotate=90) => @PLACE(220.3, -768);
//   %p2264 = (365, -773);
//   %wire_5325 = &"FRAME_14" @WIRE(mode="straight") {%p2264 #"I1220":1};
//   %wire_5325 @TEXT("FRAME\_14", size=1, halign="middle", valign="baseline", rotate=90) => @PLACE(364.3, -768);
//   %p2265 = (341, -773);
//   %wire_5326 = &"FRAME_13" @WIRE(mode="straight") {%p2265 #"I1218":1};
//   %wire_5326 @TEXT("FRAME\_13", size=1, halign="middle", valign="baseline", rotate=90) => @PLACE(340.3, -768);
//   %p2266 = (269, -773);
//   %wire_5327 = &"FRAME_10" @WIRE(mode="straight") {%p2266 #"I1205":1};
//   %wire_5327 @TEXT("FRAME\_10", size=1, halign="middle", valign="baseline", rotate=90) => @PLACE(268.3, -768);
//   %p2267 = (245, -773);
//   %wire_5328 = &"FRAME_9" @WIRE(mode="straight") {%p2267 #"I1207":1};
//   %wire_5328 @TEXT("FRAME\_9", size=1, halign="middle", valign="baseline", rotate=90) => @PLACE(244.3, -768);
//   %p2268 = (293, -773);
//   %wire_5329 = &"FRAME_11" @WIRE(mode="straight") {%p2268 #"I1210":1};
//   %wire_5329 @TEXT("FRAME\_11", size=1, halign="middle", valign="baseline", rotate=90) => @PLACE(292.3, -768);
//   %p2269 = (317, -773);
//   %wire_5330 = &"FRAME_12" @WIRE(mode="straight") {%p2269 #"I1213":1};
//   %wire_5330 @TEXT("FRAME\_12", size=1, halign="middle", valign="baseline", rotate=90) => @PLACE(316.3, -768);
//   %p2270 = (389, -773);
//   %wire_5331 = &"FRAME_15" @WIRE(mode="straight") {%p2270 #"I1215":1};
//   %wire_5331 @TEXT("FRAME\_15", size=1, halign="middle", valign="baseline", rotate=90) => @PLACE(388.3, -768);
//   %p2271 = (-68, 3);
//   %wire_5332 = &"OUT_21" @WIRE(mode="straight") {%p2271 #"I767":2};
//   %wire_5332 @TEXT("OUT\_21", size=1, halign="middle", valign="baseline") => @PLACE(-65, 3.7);
//   %p2272 = (-68, -32);
//   %wire_5333 = &"OUT_20" @WIRE(mode="straight") {%p2272 #"I774":2};
//   %wire_5333 @TEXT("OUT\_20", size=1, halign="middle", valign="baseline") => @PLACE(-65, -31.3);
//   %p2273 = (-68, -67);
//   %wire_5334 = &"OUT_19" @WIRE(mode="straight") {%p2273 #"I1467":2};
//   %wire_5334 @TEXT("OUT\_19", size=1, halign="middle", valign="baseline") => @PLACE(-65, -66.3);
//   %p2274 = (-68, -102);
//   %wire_5335 = &"OUT_18" @WIRE(mode="straight") {%p2274 #"I1465":2};
//   %wire_5335 @TEXT("OUT\_18", size=1, halign="middle", valign="baseline") => @PLACE(-65, -101.3);
//   %p2275 = (-68, -137);
//   %wire_5336 = &"OUT_17" @WIRE(mode="straight") {%p2275 #"I1475":2};
//   %wire_5336 @TEXT("OUT\_17", size=1, halign="middle", valign="baseline") => @PLACE(-65, -136.3);
//   %p2276 = (456, -746);
//   %wire_5337 = &"GND" @WIRE(mode="straight") {#"I108":4 %p2276};
//   %p2277 = (471, -746);
//   %wire_5338 = &"GND" @WIRE(mode="straight") {#"I130":4 %p2277};
//   %p2278 = (447, -762);
//   %wire_5339 = &"GND" @WIRE(mode="straight") {#"I109":4 %p2278};
//   %p2279 = (-98, 26);
//   %wire_5340 = &"GND" @WIRE(mode="straight") {%bundle_0:2 %p2279};
//   %wire_5341 = &"GND" @WIRE(mode="straight") {%bundle_4:2 #"I1642":2};
//   %wire_5342 = &"GND" @WIRE(mode="straight") {%bundle_2:2 %bundle_1:2};
//   %wire_5343 = &"GND" @WIRE(mode="straight") {%bundle_3:2 %bundle_2:2};
//   %wire_5344 = &"GND" @WIRE(mode="straight") {%bundle_1:2 %bundle_4:2};
//   %p2280 = (142, -757);
//   %wire_5345 = &"GND" @WIRE(mode="straight") {%p2280 #"I1202":5};
//   %p2281 = (433, 80);
//   %wire_5346 = &"GND" @WIRE(mode="straight") {%p2281 #"I1608":4};
//   %wire_5347 = &"GND" @WIRE(mode="straight") {#"I415":10 #"I1545":10};
//   %p2282 = (414, 22);
//   %wire_5348 = &"GND" @WIRE(mode="straight") {%p2282 #"I1596":4};
//   %p2283 = (414, 55);
//   %wire_5349 = &"GND" @WIRE(mode="straight") {%p2283 #"I1602":4};
//   %p2284 = (402, 29);
//   %wire_5350 = &"GND" @WIRE(mode="straight") {%p2284 #"I1597":2};
//   %p2285 = (402, 64);
//   %wire_5351 = &"GND" @WIRE(mode="straight") {%p2285 #"I1607":2};
//   %p2286 = (378, 29);
//   %wire_5352 = &"GND" @WIRE(mode="straight") {%p2286 #"I1598":2};
//   %p2287 = (378, 64);
//   %wire_5353 = &"GND" @WIRE(mode="straight") {%p2287 #"I1606":2};
//   %p2288 = (354, 64);
//   %wire_5354 = &"GND" @WIRE(mode="straight") {%p2288 #"I1605":2};
//   %p2289 = (354, 29);
//   %wire_5355 = &"GND" @WIRE(mode="straight") {%p2289 #"I1599":2};
//   %p2290 = (330, 29);
//   %wire_5356 = &"GND" @WIRE(mode="straight") {%p2290 #"I1600":2};
//   %p2291 = (330, 64);
//   %wire_5357 = &"GND" @WIRE(mode="straight") {%p2291 #"I1604":2};
//   %p2292 = (306, 64);
//   %wire_5358 = &"GND" @WIRE(mode="straight") {%p2292 #"I1603":2};
//   %p2293 = (306, 29);
//   %wire_5359 = &"GND" @WIRE(mode="straight") {%p2293 #"I1601":2};
//   %p2294 = (282, 64);
//   %wire_5360 = &"GND" @WIRE(mode="straight") {%p2294 #"I1573":2};
//   %p2295 = (282, 29);
//   %wire_5361 = &"GND" @WIRE(mode="straight") {%p2295 #"I1566":2};
//   %p2296 = (258, 29);
//   %wire_5362 = &"GND" @WIRE(mode="straight") {%p2296 #"I1567":2};
//   %p2297 = (258, 64);
//   %wire_5363 = &"GND" @WIRE(mode="straight") {%p2297 #"I1579":2};
//   %p2298 = (234, 64);
//   %wire_5364 = &"GND" @WIRE(mode="straight") {%p2298 #"I1574":2};
//   %p2299 = (234, 29);
//   %wire_5365 = &"GND" @WIRE(mode="straight") {%p2299 #"I1568":2};
//   %p2300 = (211, 39);
//   %wire_5366 = &"GND" @WIRE(mode="straight") {%p2300 #"M173":4};
//   %p2301 = (211, 74);
//   %wire_5367 = &"GND" @WIRE(mode="straight") {%p2301 #"M175":4};
//   %p2302 = (198, 64);
//   %wire_5368 = &"GND" @WIRE(mode="straight") {%p2302 #"I1578":2};
//   %p2303 = (198, 29);
//   %wire_5369 = &"GND" @WIRE(mode="straight") {%p2303 #"I1569":2};
//   %p2304 = (174, 29);
//   %wire_5370 = &"GND" @WIRE(mode="straight") {%p2304 #"I1570":2};
//   %p2305 = (174, 64);
//   %wire_5371 = &"GND" @WIRE(mode="straight") {%p2305 #"I1577":2};
//   %p2306 = (150, 29);
//   %wire_5372 = &"GND" @WIRE(mode="straight") {%p2306 #"I1571":2};
//   %p2307 = (150, 64);
//   %wire_5373 = &"GND" @WIRE(mode="straight") {%p2307 #"I1576":2};
//   %p2308 = (126, 29);
//   %wire_5374 = &"GND" @WIRE(mode="straight") {%p2308 #"I1572":2};
//   %p2309 = (126, 64);
//   %wire_5375 = &"GND" @WIRE(mode="straight") {%p2309 #"I1575":2};
//   %p2310 = (103, 39);
//   %wire_5376 = &"GND" @WIRE(mode="straight") {%p2310 #"M174":4};
//   %p2311 = (103, 74);
//   %wire_5377 = &"GND" @WIRE(mode="straight") {%p2311 #"M176":4};
//   %p2312 = (88, 29);
//   %wire_5378 = &"GND" @WIRE(mode="straight") {%p2312 #"I1548":2};
//   %p2313 = (88, 64);
//   %wire_5379 = &"GND" @WIRE(mode="straight") {%p2313 #"I1556":2};
//   %p2314 = (64, 64);
//   %wire_5380 = &"GND" @WIRE(mode="straight") {%p2314 #"I1555":2};
//   %p2315 = (64, 29);
//   %wire_5381 = &"GND" @WIRE(mode="straight") {%p2315 #"I1547":2};
//   %p2316 = (40, 29);
//   %wire_5382 = &"GND" @WIRE(mode="straight") {%p2316 #"I1546":2};
//   %p2317 = (40, 64);
//   %wire_5383 = &"GND" @WIRE(mode="straight") {%p2317 #"I1554":2};
//   %p2318 = (16, 29);
//   %wire_5384 = &"GND" @WIRE(mode="straight") {%p2318 #"I1545":2};
//   %p2319 = (16, 64);
//   %wire_5385 = &"GND" @WIRE(mode="straight") {%p2319 #"I1553":2};
//   %wire_5386 = &"GND" @WIRE(mode="straight") {#"I1553":10 %marker_76};
//   %wire_5387 = &"GND" @WIRE(mode="straight") {#"I1545":10 #"I1553":10};
//   %p2320 = (-8, 41);
//   %wire_5388 = &"GND" @WIRE(mode="straight") {%p2320 #"I1549":5};
//   %p2321 = (-16, 76);
//   %wire_5389 = &"GND" @WIRE(mode="straight") {%p2321 #"I1557":5};
//   %p2322 = (-32, 30);
//   %wire_5390 = &"GND" @WIRE(mode="straight") {%p2322 #"I1544":4};
//   %p2323 = (-16, -694);
//   %wire_5391 = &"GND" @WIRE(mode="straight") {%p2323 #"I1541":5};
//   %p2324 = (-8, -729);
//   %wire_5392 = &"GND" @WIRE(mode="straight") {%p2324 #"I1534":5};
//   %p2325 = (-32, -705);
//   %wire_5393 = &"GND" @WIRE(mode="straight") {%p2325 #"I1536":4};
//   %p2326 = (-32, -740);
//   %wire_5394 = &"GND" @WIRE(mode="straight") {%p2326 #"I1535":4};
//   %p2327 = (-44, -705);
//   %wire_5395 = &"GND" @WIRE(mode="straight") {%p2327 #"I1540":5};
//   %p2328 = (-44, -740);
//   %wire_5396 = &"GND" @WIRE(mode="straight") {%p2328 #"I1538":5};
//   %p2329 = (-55, -705);
//   %wire_5397 = &"GND" @WIRE(mode="straight") {%p2329 #"I1539":4};
//   %p2330 = (-55, -740);
//   %wire_5398 = &"GND" @WIRE(mode="straight") {%p2330 #"I1537":4};
//   %p2331 = (-16, -624);
//   %wire_5399 = &"GND" @WIRE(mode="straight") {%p2331 #"I1533":5};
//   %p2332 = (-8, -659);
//   %wire_5400 = &"GND" @WIRE(mode="straight") {%p2332 #"I1526":5};
//   %p2333 = (-32, -635);
//   %wire_5401 = &"GND" @WIRE(mode="straight") {%p2333 #"I1528":4};
//   %p2334 = (-32, -670);
//   %wire_5402 = &"GND" @WIRE(mode="straight") {%p2334 #"I1527":4};
//   %p2335 = (-44, -635);
//   %wire_5403 = &"GND" @WIRE(mode="straight") {%p2335 #"I1532":5};
//   %p2336 = (-44, -670);
//   %wire_5404 = &"GND" @WIRE(mode="straight") {%p2336 #"I1530":5};
//   %p2337 = (-55, -635);
//   %wire_5405 = &"GND" @WIRE(mode="straight") {%p2337 #"I1531":4};
//   %p2338 = (-55, -670);
//   %wire_5406 = &"GND" @WIRE(mode="straight") {%p2338 #"I1529":4};
//   %p2339 = (-16, -554);
//   %wire_5407 = &"GND" @WIRE(mode="straight") {%p2339 #"I1525":5};
//   %p2340 = (-8, -589);
//   %wire_5408 = &"GND" @WIRE(mode="straight") {%p2340 #"I1518":5};
//   %p2341 = (-8, -99);
//   %wire_5409 = &"GND" @WIRE(mode="straight") {%p2341 #"I1462":5};
//   %p2342 = (-44, -320);
//   %wire_5410 = &"GND" @WIRE(mode="straight") {%p2342 #"I1490":5};
//   %p2343 = (-8, -29);
//   %wire_5411 = &"GND" @WIRE(mode="straight") {%p2343 #"I1461":5};
//   %p2344 = (-44, -285);
//   %wire_5412 = &"GND" @WIRE(mode="straight") {%p2344 #"I1492":5};
//   %p2345 = (211, 4);
//   %wire_5413 = &"GND" @WIRE(mode="straight") {%p2345 #"M168":4};
//   %p2346 = (211, -31);
//   %wire_5414 = &"GND" @WIRE(mode="straight") {%p2346 #"M172":4};
//   %p2347 = (211, -66);
//   %wire_5415 = &"GND" @WIRE(mode="straight") {%p2347 #"M171":4};
//   %p2348 = (211, -101);
//   %wire_5416 = &"GND" @WIRE(mode="straight") {%p2348 #"M170":4};
//   %p2349 = (211, -136);
//   %wire_5417 = &"GND" @WIRE(mode="straight") {%p2349 #"M169":4};
//   %p2350 = (-32, -600);
//   %wire_5418 = &"GND" @WIRE(mode="straight") {%p2350 #"I1519":4};
//   %p2351 = (-32, -565);
//   %wire_5419 = &"GND" @WIRE(mode="straight") {%p2351 #"I1520":4};
//   %p2352 = (211, -171);
//   %wire_5420 = &"GND" @WIRE(mode="straight") {%p2352 #"M162":4};
//   %p2353 = (211, -206);
//   %wire_5421 = &"GND" @WIRE(mode="straight") {%p2353 #"M167":4};
//   %p2354 = (211, -241);
//   %wire_5422 = &"GND" @WIRE(mode="straight") {%p2354 #"M166":4};
//   %p2355 = (211, -276);
//   %wire_5423 = &"GND" @WIRE(mode="straight") {%p2355 #"M165":4};
//   %p2356 = (211, -311);
//   %wire_5424 = &"GND" @WIRE(mode="straight") {%p2356 #"M164":4};
//   %p2357 = (211, -346);
//   %wire_5425 = &"GND" @WIRE(mode="straight") {%p2357 #"M163":4};
//   %p2358 = (211, -381);
//   %wire_5426 = &"GND" @WIRE(mode="straight") {%p2358 #"M155":4};
//   %p2359 = (211, -416);
//   %wire_5427 = &"GND" @WIRE(mode="straight") {%p2359 #"M161":4};
//   %p2360 = (211, -451);
//   %wire_5428 = &"GND" @WIRE(mode="straight") {%p2360 #"M160":4};
//   %p2361 = (211, -486);
//   %wire_5429 = &"GND" @WIRE(mode="straight") {%p2361 #"M159":4};
//   %p2362 = (211, -521);
//   %wire_5430 = &"GND" @WIRE(mode="straight") {%p2362 #"M158":4};
//   %p2363 = (211, -556);
//   %wire_5431 = &"GND" @WIRE(mode="straight") {%p2363 #"M157":4};
//   %p2364 = (211, -591);
//   %wire_5432 = &"GND" @WIRE(mode="straight") {%p2364 #"M156":4};
//   %p2365 = (107, -779);
//   %wire_5433 = &"GND" @WIRE(mode="straight") {%p2365 #"I1454":4};
//   %p2366 = (437, -748);
//   %wire_5434 = &"GND" @WIRE(mode="straight") {%p2366 #"I1224":4};
//   %p2367 = (416, -765);
//   %wire_5435 = &"GND" @WIRE(mode="straight") {%p2367 #"I1223":4};
//   %p2368 = (67, -757);
//   %wire_5436 = &"GND" @WIRE(mode="straight") {%p2368 #"I1622":5};
//   %p2369 = (429, -737);
//   %wire_5437 = &"GND" @WIRE(mode="straight") {%p2369 #"I1431":4};
//   %p2370 = (129, -757);
//   %wire_5438 = &"GND" @WIRE(mode="straight") {%p2370 #"I1624":5};
//   %p2371 = (91, -757);
//   %wire_5439 = &"GND" @WIRE(mode="straight") {%p2371 #"I1623":5};
//   %p2372 = (346, -757);
//   %wire_5440 = &"GND" @WIRE(mode="straight") {%p2372 #"I1218":5};
//   %p2373 = (370, -757);
//   %wire_5441 = &"GND" @WIRE(mode="straight") {%p2373 #"I1220":5};
//   %p2374 = (394, -757);
//   %wire_5442 = &"GND" @WIRE(mode="straight") {%p2374 #"I1215":5};
//   %p2375 = (322, -757);
//   %wire_5443 = &"GND" @WIRE(mode="straight") {%p2375 #"I1213":5};
//   %p2376 = (153, -757);
//   %wire_5444 = &"GND" @WIRE(mode="straight") {%p2376 #"I1625":5};
//   %p2377 = (309, -757);
//   %wire_5445 = &"GND" @WIRE(mode="straight") {%p2377 #"I1630":5};
//   %p2378 = (226, -757);
//   %wire_5446 = &"GND" @WIRE(mode="straight") {%p2378 #"I1212":5};
//   %p2379 = (298, -757);
//   %wire_5447 = &"GND" @WIRE(mode="straight") {%p2379 #"I1210":5};
//   %p2380 = (201, -757);
//   %wire_5448 = &"GND" @WIRE(mode="straight") {%p2380 #"I1626":5};
//   %p2381 = (274, -757);
//   %wire_5449 = &"GND" @WIRE(mode="straight") {%p2381 #"I1205":5};
//   %p2382 = (261, -757);
//   %wire_5450 = &"GND" @WIRE(mode="straight") {%p2382 #"I1628":5};
//   %p2383 = (237, -757);
//   %wire_5451 = &"GND" @WIRE(mode="straight") {%p2383 #"I1627":5};
//   %p2384 = (250, -757);
//   %wire_5452 = &"GND" @WIRE(mode="straight") {%p2384 #"I1207":5};
//   %p2385 = (285, -757);
//   %wire_5453 = &"GND" @WIRE(mode="straight") {%p2385 #"I1629":5};
//   %p2386 = (357, -757);
//   %wire_5454 = &"GND" @WIRE(mode="straight") {%p2386 #"I1632":5};
//   %p2387 = (333, -757);
//   %wire_5455 = &"GND" @WIRE(mode="straight") {%p2387 #"I1631":5};
//   %p2388 = (405, -757);
//   %wire_5456 = &"GND" @WIRE(mode="straight") {%p2388 #"I1634":5};
//   %p2389 = (381, -757);
//   %wire_5457 = &"GND" @WIRE(mode="straight") {%p2389 #"I1633":5};
//   %p2390 = (166, -757);
//   %wire_5458 = &"GND" @WIRE(mode="straight") {%p2390 #"I1204":5};
//   %p2391 = (190, -757);
//   %wire_5459 = &"GND" @WIRE(mode="straight") {%p2391 #"I1199":5};
//   %p2392 = (118, -757);
//   %wire_5460 = &"GND" @WIRE(mode="straight") {%p2392 #"I1197":5};
//   %p2393 = (414, -715);
//   %wire_5461 = &"GND" @WIRE(mode="straight") {%p2393 #"I1182":4};
//   %p2394 = (402, -706);
//   %wire_5462 = &"GND" @WIRE(mode="straight") {%p2394 #"I1183":2};
//   %p2395 = (64, -181);
//   %wire_5463 = &"GND" @WIRE(mode="straight") {%p2395 #"I1279":2};
//   %p2396 = (16, -111);
//   %wire_5464 = &"GND" @WIRE(mode="straight") {%p2396 #"I1264":2};
//   %p2397 = (40, -181);
//   %wire_5465 = &"GND" @WIRE(mode="straight") {%p2397 #"I1280":2};
//   %p2398 = (378, -706);
//   %wire_5466 = &"GND" @WIRE(mode="straight") {%p2398 #"I1184":2};
//   %p2399 = (-32, 65);
//   %wire_5467 = &"GND" @WIRE(mode="straight") {%p2399 #"I1552":4};
//   %p2400 = (354, -706);
//   %wire_5468 = &"GND" @WIRE(mode="straight") {%p2400 #"I1185":2};
//   %p2401 = (16, -181);
//   %wire_5469 = &"GND" @WIRE(mode="straight") {%p2401 #"I1281":2};
//   %p2402 = (330, -706);
//   %wire_5470 = &"GND" @WIRE(mode="straight") {%p2402 #"I1186":2};
//   %p2403 = (414, -118);
//   %wire_5471 = &"GND" @WIRE(mode="straight") {%p2403 #"I1271":4};
//   %p2404 = (402, -111);
//   %wire_5472 = &"GND" @WIRE(mode="straight") {%p2404 #"I1277":2};
//   %p2405 = (306, -706);
//   %wire_5473 = &"GND" @WIRE(mode="straight") {%p2405 #"I1187":2};
//   %p2406 = (378, -111);
//   %wire_5474 = &"GND" @WIRE(mode="straight") {%p2406 #"I1276":2};
//   %p2407 = (282, -706);
//   %wire_5475 = &"GND" @WIRE(mode="straight") {%p2407 #"I1188":2};
//   %p2408 = (354, -111);
//   %wire_5476 = &"GND" @WIRE(mode="straight") {%p2408 #"I1275":2};
//   %p2409 = (258, -706);
//   %wire_5477 = &"GND" @WIRE(mode="straight") {%p2409 #"I1169":2};
//   %p2410 = (330, -111);
//   %wire_5478 = &"GND" @WIRE(mode="straight") {%p2410 #"I1274":2};
//   %p2411 = (234, -706);
//   %wire_5479 = &"GND" @WIRE(mode="straight") {%p2411 #"I1170":2};
//   %p2412 = (306, -111);
//   %wire_5480 = &"GND" @WIRE(mode="straight") {%p2412 #"I1273":2};
//   %p2413 = (215, -779);
//   %wire_5481 = &"GND" @WIRE(mode="straight") {%p2413 #"I1455":4};
//   %p2414 = (198, -706);
//   %wire_5482 = &"GND" @WIRE(mode="straight") {%p2414 #"I1171":2};
//   %p2415 = (282, -111);
//   %wire_5483 = &"GND" @WIRE(mode="straight") {%p2415 #"I1272":2};
//   %p2416 = (258, -111);
//   %wire_5484 = &"GND" @WIRE(mode="straight") {%p2416 #"I1265":2};
//   %p2417 = (174, -706);
//   %wire_5485 = &"GND" @WIRE(mode="straight") {%p2417 #"I1172":2};
//   %p2418 = (234, -111);
//   %wire_5486 = &"GND" @WIRE(mode="straight") {%p2418 #"I1270":2};
//   %p2419 = (150, -706);
//   %wire_5487 = &"GND" @WIRE(mode="straight") {%p2419 #"I1173":2};
//   %p2420 = (198, -111);
//   %wire_5488 = &"GND" @WIRE(mode="straight") {%p2420 #"I1269":2};
//   %p2421 = (126, -706);
//   %wire_5489 = &"GND" @WIRE(mode="straight") {%p2421 #"I1174":2};
//   %p2422 = (174, -111);
//   %wire_5490 = &"GND" @WIRE(mode="straight") {%p2422 #"I1268":2};
//   %p2423 = (40, -111);
//   %wire_5491 = &"GND" @WIRE(mode="straight") {%p2423 #"I1263":2};
//   %p2424 = (88, -706);
//   %wire_5492 = &"GND" @WIRE(mode="straight") {%p2424 #"I1162":2};
//   %p2425 = (150, -111);
//   %wire_5493 = &"GND" @WIRE(mode="straight") {%p2425 #"I1267":2};
//   %p2426 = (64, -706);
//   %wire_5494 = &"GND" @WIRE(mode="straight") {%p2426 #"I1161":2};
//   %p2427 = (126, -111);
//   %wire_5495 = &"GND" @WIRE(mode="straight") {%p2427 #"I1266":2};
//   %p2428 = (40, -706);
//   %wire_5496 = &"GND" @WIRE(mode="straight") {%p2428 #"I1160":2};
//   %p2429 = (103, -136);
//   %wire_5497 = &"GND" @WIRE(mode="straight") {%p2429 #"M133":4};
//   %p2430 = (88, -111);
//   %wire_5498 = &"GND" @WIRE(mode="straight") {%p2430 #"I1261":2};
//   %p2431 = (16, -706);
//   %wire_5499 = &"GND" @WIRE(mode="straight") {%p2431 #"I1159":2};
//   %p2432 = (150, -251);
//   %wire_5500 = &"GND" @WIRE(mode="straight") {%p2432 #"I1301":2};
//   %p2433 = (6, -741);
//   %wire_5501 = &"GND" @WIRE(mode="straight") {%p2433 #"I1417":10};
//   %p2434 = (-32, -75);
//   %wire_5502 = &"GND" @WIRE(mode="straight") {%p2434 #"I1464":4};
//   %p2435 = (-32, -110);
//   %wire_5503 = &"GND" @WIRE(mode="straight") {%p2435 #"I1463":4};
//   %p2436 = (-55, -75);
//   %wire_5504 = &"GND" @WIRE(mode="straight") {%p2436 #"I1467":4};
//   %p2437 = (-55, -110);
//   %wire_5505 = &"GND" @WIRE(mode="straight") {%p2437 #"I1465":4};
//   %p2438 = (414, -645);
//   %wire_5506 = &"GND" @WIRE(mode="straight") {%p2438 #"I1142":4};
//   %p2439 = (402, -636);
//   %wire_5507 = &"GND" @WIRE(mode="straight") {%p2439 #"I1143":2};
//   %p2440 = (378, -636);
//   %wire_5508 = &"GND" @WIRE(mode="straight") {%p2440 #"I1144":2};
//   %p2441 = (126, -251);
//   %wire_5509 = &"GND" @WIRE(mode="straight") {%p2441 #"I1300":2};
//   %p2442 = (354, -636);
//   %wire_5510 = &"GND" @WIRE(mode="straight") {%p2442 #"I1145":2};
//   %p2443 = (88, -251);
//   %wire_5511 = &"GND" @WIRE(mode="straight") {%p2443 #"I1295":2};
//   %p2444 = (64, -111);
//   %wire_5512 = &"GND" @WIRE(mode="straight") {%p2444 #"I1262":2};
//   %p2445 = (330, -636);
//   %wire_5513 = &"GND" @WIRE(mode="straight") {%p2445 #"I1146":2};
//   %p2446 = (64, -251);
//   %wire_5514 = &"GND" @WIRE(mode="straight") {%p2446 #"I1296":2};
//   %p2447 = (306, -636);
//   %wire_5515 = &"GND" @WIRE(mode="straight") {%p2447 #"I1147":2};
//   %p2448 = (40, -251);
//   %wire_5516 = &"GND" @WIRE(mode="straight") {%p2448 #"I1297":2};
//   %p2449 = (88, -181);
//   %wire_5517 = &"GND" @WIRE(mode="straight") {%p2449 #"I1278":2};
//   %p2450 = (16, -251);
//   %wire_5518 = &"GND" @WIRE(mode="straight") {%p2450 #"I1298":2};
//   %p2451 = (282, -636);
//   %wire_5519 = &"GND" @WIRE(mode="straight") {%p2451 #"I1148":2};
//   %p2452 = (-44, 65);
//   %wire_5520 = &"GND" @WIRE(mode="straight") {%p2452 #"I1551":5};
//   %p2453 = (258, -636);
//   %wire_5521 = &"GND" @WIRE(mode="straight") {%p2453 #"I1129":2};
//   %p2454 = (414, -188);
//   %wire_5522 = &"GND" @WIRE(mode="straight") {%p2454 #"I1288":4};
//   %p2455 = (402, -181);
//   %wire_5523 = &"GND" @WIRE(mode="straight") {%p2455 #"I1294":2};
//   %p2456 = (234, -636);
//   %wire_5524 = &"GND" @WIRE(mode="straight") {%p2456 #"I1130":2};
//   %p2457 = (378, -181);
//   %wire_5525 = &"GND" @WIRE(mode="straight") {%p2457 #"I1293":2};
//   %p2458 = (211, -731);
//   %wire_5526 = &"GND" @WIRE(mode="straight") {%p2458 #"M151":4};
//   %p2459 = (198, -636);
//   %wire_5527 = &"GND" @WIRE(mode="straight") {%p2459 #"I1131":2};
//   %p2460 = (354, -181);
//   %wire_5528 = &"GND" @WIRE(mode="straight") {%p2460 #"I1292":2};
//   %p2461 = (330, -181);
//   %wire_5529 = &"GND" @WIRE(mode="straight") {%p2461 #"I1291":2};
//   %p2462 = (174, -636);
//   %wire_5530 = &"GND" @WIRE(mode="straight") {%p2462 #"I1132":2};
//   %p2463 = (306, -181);
//   %wire_5531 = &"GND" @WIRE(mode="straight") {%p2463 #"I1290":2};
//   %p2464 = (150, -636);
//   %wire_5532 = &"GND" @WIRE(mode="straight") {%p2464 #"I1133":2};
//   %p2465 = (282, -181);
//   %wire_5533 = &"GND" @WIRE(mode="straight") {%p2465 #"I1289":2};
//   %p2466 = (126, -636);
//   %wire_5534 = &"GND" @WIRE(mode="straight") {%p2466 #"I1134":2};
//   %p2467 = (258, -181);
//   %wire_5535 = &"GND" @WIRE(mode="straight") {%p2467 #"I1282":2};
//   %p2468 = (126, -181);
//   %wire_5536 = &"GND" @WIRE(mode="straight") {%p2468 #"I1283":2};
//   %p2469 = (88, -636);
//   %wire_5537 = &"GND" @WIRE(mode="straight") {%p2469 #"I1122":2};
//   %p2470 = (211, -626);
//   %wire_5538 = &"GND" @WIRE(mode="straight") {%p2470 #"M154":4};
//   %p2471 = (64, -636);
//   %wire_5539 = &"GND" @WIRE(mode="straight") {%p2471 #"I1121":2};
//   %p2472 = (198, -181);
//   %wire_5540 = &"GND" @WIRE(mode="straight") {%p2472 #"I1286":2};
//   %p2473 = (40, -636);
//   %wire_5541 = &"GND" @WIRE(mode="straight") {%p2473 #"I1120":2};
//   %p2474 = (174, -181);
//   %wire_5542 = &"GND" @WIRE(mode="straight") {%p2474 #"I1285":2};
//   %p2475 = (88, -321);
//   %wire_5543 = &"GND" @WIRE(mode="straight") {%p2475 #"I1312":2};
//   %p2476 = (16, -636);
//   %wire_5544 = &"GND" @WIRE(mode="straight") {%p2476 #"I1119":2};
//   %p2477 = (150, -181);
//   %wire_5545 = &"GND" @WIRE(mode="straight") {%p2477 #"I1284":2};
//   %p2478 = (234, -181);
//   %wire_5546 = &"GND" @WIRE(mode="straight") {%p2478 #"I1287":2};
//   %wire_5547 = &"GND" @WIRE(mode="straight") {#"I1159":10 #"I1400":10};
//   %p2479 = (-32, -145);
//   %wire_5548 = &"GND" @WIRE(mode="straight") {%p2479 #"I1472":4};
//   %p2480 = (-44, -180);
//   %wire_5549 = &"GND" @WIRE(mode="straight") {%p2480 #"I1474":5};
//   %p2481 = (-55, -180);
//   %wire_5550 = &"GND" @WIRE(mode="straight") {%p2481 #"I1473":4};
//   %p2482 = (-16, -64);
//   %wire_5551 = &"GND" @WIRE(mode="straight") {%p2482 #"I1469":5};
//   %p2483 = (414, -575);
//   %wire_5552 = &"GND" @WIRE(mode="straight") {%p2483 #"I1102":4};
//   %p2484 = (402, -566);
//   %wire_5553 = &"GND" @WIRE(mode="straight") {%p2484 #"I1103":2};
//   %p2485 = (378, -566);
//   %wire_5554 = &"GND" @WIRE(mode="straight") {%p2485 #"I1104":2};
//   %p2486 = (330, -251);
//   %wire_5555 = &"GND" @WIRE(mode="straight") {%p2486 #"I1308":2};
//   %p2487 = (234, -321);
//   %wire_5556 = &"GND" @WIRE(mode="straight") {%p2487 #"I1321":2};
//   %p2488 = (354, -566);
//   %wire_5557 = &"GND" @WIRE(mode="straight") {%p2488 #"I1105":2};
//   %p2489 = (198, -321);
//   %wire_5558 = &"GND" @WIRE(mode="straight") {%p2489 #"I1320":2};
//   %p2490 = (330, -566);
//   %wire_5559 = &"GND" @WIRE(mode="straight") {%p2490 #"I1106":2};
//   %p2491 = (174, -251);
//   %wire_5560 = &"GND" @WIRE(mode="straight") {%p2491 #"I1302":2};
//   %p2492 = (174, -321);
//   %wire_5561 = &"GND" @WIRE(mode="straight") {%p2492 #"I1319":2};
//   %p2493 = (-55, -600);
//   %wire_5562 = &"GND" @WIRE(mode="straight") {%p2493 #"I1521":4};
//   %p2494 = (215, -790);
//   %wire_5563 = &"GND" @WIRE(mode="straight") {%p2494 #"I1456":4};
//   %p2495 = (258, -6);
//   %wire_5564 = &"GND" @WIRE(mode="straight") {%p2495 #"I613":2};
//   %p2496 = (64, -146);
//   %wire_5565 = &"GND" @WIRE(mode="straight") {%p2496 #"I841":2};
//   %p2497 = (378, -146);
//   %wire_5566 = &"GND" @WIRE(mode="straight") {%p2497 #"I864":2};
//   %p2498 = (-16, -484);
//   %wire_5567 = &"GND" @WIRE(mode="straight") {%p2498 #"I1517":5};
//   %p2499 = (234, -671);
//   %wire_5568 = &"GND" @WIRE(mode="straight") {%p2499 #"I1406":2};
//   %p2500 = (40, -671);
//   %wire_5569 = &"GND" @WIRE(mode="straight") {%p2500 #"I1399":2};
//   %p2501 = (378, -216);
//   %wire_5570 = &"GND" @WIRE(mode="straight") {%p2501 #"I904":2};
//   %p2502 = (258, -601);
//   %wire_5571 = &"GND" @WIRE(mode="straight") {%p2502 #"I1384":2};
//   %p2503 = (-16, -344);
//   %wire_5572 = &"GND" @WIRE(mode="straight") {%p2503 #"I1501":5};
//   %p2504 = (64, -671);
//   %wire_5573 = &"GND" @WIRE(mode="straight") {%p2504 #"I1398":2};
//   %p2505 = (80, -757);
//   %wire_5574 = &"GND" @WIRE(mode="straight") {%p2505 #"I1195":5};
//   %p2506 = (258, -391);
//   %wire_5575 = &"GND" @WIRE(mode="straight") {%p2506 #"I1333":2};
//   %wire_5576 = &"GND" @WIRE(mode="straight") {#"I999":10 #"I1332":10};
//   %p2507 = (40, -146);
//   %wire_5577 = &"GND" @WIRE(mode="straight") {%p2507 #"I840":2};
//   %p2508 = (150, -356);
//   %wire_5578 = &"GND" @WIRE(mode="straight") {%p2508 #"I973":2};
//   %p2509 = (126, -601);
//   %wire_5579 = &"GND" @WIRE(mode="straight") {%p2509 #"I1385":2};
//   %p2510 = (107, -790);
//   %wire_5580 = &"GND" @WIRE(mode="straight") {%p2510 #"I1221":4};
//   %p2511 = (306, -41);
//   %wire_5581 = &"GND" @WIRE(mode="straight") {%p2511 #"I787":2};
//   %p2512 = (402, -356);
//   %wire_5582 = &"GND" @WIRE(mode="straight") {%p2512 #"I983":2};
//   %p2513 = (16, -426);
//   %wire_5583 = &"GND" @WIRE(mode="straight") {%p2513 #"I999":2};
//   %p2514 = (103, 4);
//   %wire_5584 = &"GND" @WIRE(mode="straight") {%p2514 #"M44":4};
//   %p2515 = (174, -356);
//   %wire_5585 = &"GND" @WIRE(mode="straight") {%p2515 #"I972":2};
//   %p2516 = (32, -757);
//   %wire_5586 = &"GND" @WIRE(mode="straight") {%p2516 #"I1191":5};
//   %p2517 = (88, -356);
//   %wire_5587 = &"GND" @WIRE(mode="straight") {%p2517 #"I962":2};
//   %p2518 = (126, -356);
//   %wire_5588 = &"GND" @WIRE(mode="straight") {%p2518 #"I974":2};
//   %p2519 = (402, -461);
//   %wire_5589 = &"GND" @WIRE(mode="straight") {%p2519 #"I1362":2};
//   %p2520 = (150, -531);
//   %wire_5590 = &"GND" @WIRE(mode="straight") {%p2520 #"I1369":2};
//   %p2521 = (126, -286);
//   %wire_5591 = &"GND" @WIRE(mode="straight") {%p2521 #"I934":2};
//   %p2522 = (414, -678);
//   %wire_5592 = &"GND" @WIRE(mode="straight") {%p2522 #"I1407":4};
//   %p2523 = (103, -731);
//   %wire_5593 = &"GND" @WIRE(mode="straight") {%p2523 #"M150":4};
//   %p2524 = (56, -757);
//   %wire_5594 = &"GND" @WIRE(mode="straight") {%p2524 #"I1193":5};
//   %p2525 = (-55, -250);
//   %wire_5595 = &"GND" @WIRE(mode="straight") {%p2525 #"I1481":4};
//   %p2526 = (16, -391);
//   %wire_5596 = &"GND" @WIRE(mode="straight") {%p2526 #"I1332":2};
//   %p2527 = (306, -321);
//   %wire_5597 = &"GND" @WIRE(mode="straight") {%p2527 #"I1324":2};
//   %p2528 = (-8, -309);
//   %wire_5598 = &"GND" @WIRE(mode="straight") {%p2528 #"I1486":5};
//   %p2529 = (414, -435);
//   %wire_5599 = &"GND" @WIRE(mode="straight") {%p2529 #"I1022":4};
//   %p2530 = (88, -461);
//   %wire_5600 = &"GND" @WIRE(mode="straight") {%p2530 #"I1346":2};
//   %p2531 = (150, -461);
//   %wire_5601 = &"GND" @WIRE(mode="straight") {%p2531 #"I1352":2};
//   %p2532 = (-55, -320);
//   %wire_5602 = &"GND" @WIRE(mode="straight") {%p2532 #"I1489":4};
//   %p2533 = (282, -356);
//   %wire_5603 = &"GND" @WIRE(mode="straight") {%p2533 #"I988":2};
//   %p2534 = (306, -531);
//   %wire_5604 = &"GND" @WIRE(mode="straight") {%p2534 #"I1375":2};
//   %p2535 = (416, -781);
//   %wire_5605 = &"GND" @WIRE(mode="straight") {%p2535 #"I1637":4};
//   %p2536 = (150, -286);
//   %wire_5606 = &"GND" @WIRE(mode="straight") {%p2536 #"I933":2};
//   %p2537 = (64, -286);
//   %wire_5607 = &"GND" @WIRE(mode="straight") {%p2537 #"I921":2};
//   %p2538 = (282, -76);
//   %wire_5608 = &"GND" @WIRE(mode="straight") {%p2538 #"I828":2};
//   %p2539 = (-44, -40);
//   %wire_5609 = &"GND" @WIRE(mode="straight") {%p2539 #"I1432":5};
//   %p2540 = (-44, -5);
//   %wire_5610 = &"GND" @WIRE(mode="straight") {%p2540 #"I411":5};
//   %p2541 = (-32, -5);
//   %wire_5611 = &"GND" @WIRE(mode="straight") {%p2541 #"I412":4};
//   %p2542 = (-55, -5);
//   %wire_5612 = &"GND" @WIRE(mode="straight") {%p2542 #"I767":4};
//   %p2543 = (198, -41);
//   %wire_5613 = &"GND" @WIRE(mode="straight") {%p2543 #"I778":2};
//   %p2544 = (258, -251);
//   %wire_5614 = &"GND" @WIRE(mode="straight") {%p2544 #"I1299":2};
//   %p2545 = (198, -6);
//   %wire_5615 = &"GND" @WIRE(mode="straight") {%p2545 #"I569":2};
//   %p2546 = (126, -6);
//   %wire_5616 = &"GND" @WIRE(mode="straight") {%p2546 #"I503":2};
//   %p2547 = (88, -6);
//   %wire_5617 = &"GND" @WIRE(mode="straight") {%p2547 #"I481":2};
//   %p2548 = (174, -6);
//   %wire_5618 = &"GND" @WIRE(mode="straight") {%p2548 #"I547":2};
//   %p2549 = (150, -6);
//   %wire_5619 = &"GND" @WIRE(mode="straight") {%p2549 #"I525":2};
//   %p2550 = (354, -41);
//   %wire_5620 = &"GND" @WIRE(mode="straight") {%p2550 #"I785":2};
//   %p2551 = (402, -76);
//   %wire_5621 = &"GND" @WIRE(mode="straight") {%p2551 #"I823":2};
//   %p2552 = (103, -556);
//   %wire_5622 = &"GND" @WIRE(mode="straight") {%p2552 #"M145":4};
//   %wire_5623 = &"GND" @WIRE(mode="straight") {#"I1366":10 #"I1039":10};
//   %wire_5624 = &"GND" @WIRE(mode="straight") {#"I1383":10 #"I1079":10};
//   %p2553 = (354, -426);
//   %wire_5625 = &"GND" @WIRE(mode="straight") {%p2553 #"I1025":2};
//   %p2554 = (258, -496);
//   %wire_5626 = &"GND" @WIRE(mode="straight") {%p2554 #"I1049":2};
//   %p2555 = (198, -601);
//   %wire_5627 = &"GND" @WIRE(mode="straight") {%p2555 #"I1388":2};
//   %p2556 = (8, -757);
//   %wire_5628 = &"GND" @WIRE(mode="straight") {%p2556 #"I1189":5};
//   %p2557 = (306, -216);
//   %wire_5629 = &"GND" @WIRE(mode="straight") {%p2557 #"I907":2};
//   %p2558 = (414, -223);
//   %wire_5630 = &"GND" @WIRE(mode="straight") {%p2558 #"I902":4};
//   %p2559 = (306, -76);
//   %wire_5631 = &"GND" @WIRE(mode="straight") {%p2559 #"I827":2};
//   %p2560 = (414, -153);
//   %wire_5632 = &"GND" @WIRE(mode="straight") {%p2560 #"I862":4};
//   %p2561 = (16, -6);
//   %wire_5633 = &"GND" @WIRE(mode="straight") {%p2561 #"I415":2};
//   %p2562 = (354, -146);
//   %wire_5634 = &"GND" @WIRE(mode="straight") {%p2562 #"I865":2};
//   %p2563 = (234, -41);
//   %wire_5635 = &"GND" @WIRE(mode="straight") {%p2563 #"I777":2};
//   %p2564 = (-32, -530);
//   %wire_5636 = &"GND" @WIRE(mode="straight") {%p2564 #"I1511":4};
//   %p2565 = (177, -757);
//   %wire_5637 = &"GND" @WIRE(mode="straight") {%p2565 #"I1635":5};
//   %p2566 = (402, -6);
//   %wire_5638 = &"GND" @WIRE(mode="straight") {%p2566 #"I745":2};
//   %wire_5639 = &"GND" @WIRE(mode="straight") {#"I1281":10 #"I839":10};
//   %p2567 = (103, -311);
//   %wire_5640 = &"GND" @WIRE(mode="straight") {%p2567 #"M138":4};
//   %wire_5641 = &"GND" @WIRE(mode="straight") {#"I1349":10 #"I999":10};
//   %p2568 = (-44, -425);
//   %wire_5642 = &"GND" @WIRE(mode="straight") {%p2568 #"I1508":5};
//   %p2569 = (234, -741);
//   %wire_5643 = &"GND" @WIRE(mode="straight") {%p2569 #"I1423":2};
//   %p2570 = (126, -146);
//   %wire_5644 = &"GND" @WIRE(mode="straight") {%p2570 #"I854":2};
//   %p2571 = (-32, -425);
//   %wire_5645 = &"GND" @WIRE(mode="straight") {%p2571 #"I1504":4};
//   %p2572 = (16, -671);
//   %wire_5646 = &"GND" @WIRE(mode="straight") {%p2572 #"I1400":2};
//   %p2573 = (378, -601);
//   %wire_5647 = &"GND" @WIRE(mode="straight") {%p2573 #"I1395":2};
//   %p2574 = (330, -601);
//   %wire_5648 = &"GND" @WIRE(mode="straight") {%p2574 #"I1393":2};
//   %p2575 = (-16, 6);
//   %wire_5649 = &"GND" @WIRE(mode="straight") {%p2575 #"I1460":5};
//   %p2576 = (174, -531);
//   %wire_5650 = &"GND" @WIRE(mode="straight") {%p2576 #"I1370":2};
//   %p2577 = (402, -286);
//   %wire_5651 = &"GND" @WIRE(mode="straight") {%p2577 #"I943":2};
//   %p2578 = (64, -461);
//   %wire_5652 = &"GND" @WIRE(mode="straight") {%p2578 #"I1347":2};
//   %p2579 = (234, -426);
//   %wire_5653 = &"GND" @WIRE(mode="straight") {%p2579 #"I1010":2};
//   %p2580 = (330, -391);
//   %wire_5654 = &"GND" @WIRE(mode="straight") {%p2580 #"I1342":2};
//   %p2581 = (402, -321);
//   %wire_5655 = &"GND" @WIRE(mode="straight") {%p2581 #"I1328":2};
//   %p2582 = (16, -566);
//   %wire_5656 = &"GND" @WIRE(mode="straight") {%p2582 #"I1079":2};
//   %p2583 = (306, -496);
//   %wire_5657 = &"GND" @WIRE(mode="straight") {%p2583 #"I1067":2};
//   %p2584 = (282, -461);
//   %wire_5658 = &"GND" @WIRE(mode="straight") {%p2584 #"I1357":2};
//   %p2585 = (174, -391);
//   %wire_5659 = &"GND" @WIRE(mode="straight") {%p2585 #"I1336":2};
//   %p2586 = (-32, -320);
//   %wire_5660 = &"GND" @WIRE(mode="straight") {%p2586 #"I1487":4};
//   %p2587 = (150, -741);
//   %wire_5661 = &"GND" @WIRE(mode="straight") {%p2587 #"I1420":2};
//   %p2588 = (330, -286);
//   %wire_5662 = &"GND" @WIRE(mode="straight") {%p2588 #"I946":2};
//   %p2589 = (-44, -390);
//   %wire_5663 = &"GND" @WIRE(mode="straight") {%p2589 #"I1498":5};
//   %p2590 = (282, -426);
//   %wire_5664 = &"GND" @WIRE(mode="straight") {%p2590 #"I1028":2};
//   %p2591 = (402, -601);
//   %wire_5665 = &"GND" @WIRE(mode="straight") {%p2591 #"I1396":2};
//   %p2592 = (88, -41);
//   %wire_5666 = &"GND" @WIRE(mode="straight") {%p2592 #"I773":2};
//   %p2593 = (-44, -355);
//   %wire_5667 = &"GND" @WIRE(mode="straight") {%p2593 #"I1500":5};
//   %p2594 = (150, -426);
//   %wire_5668 = &"GND" @WIRE(mode="straight") {%p2594 #"I1013":2};
//   %wire_5669 = &"GND" @WIRE(mode="straight") {#"I799":10 #"I770":10};
//   %p2595 = (414, -363);
//   %wire_5670 = &"GND" @WIRE(mode="straight") {%p2595 #"I982":4};
//   %p2596 = (354, -251);
//   %wire_5671 = &"GND" @WIRE(mode="straight") {%p2596 #"I1309":2};
//   %p2597 = (103, -66);
//   %wire_5672 = &"GND" @WIRE(mode="straight") {%p2597 #"M131":4};
//   %p2598 = (-8, -169);
//   %wire_5673 = &"GND" @WIRE(mode="straight") {%p2598 #"I1470":5};
//   %p2599 = (234, -601);
//   %wire_5674 = &"GND" @WIRE(mode="straight") {%p2599 #"I1389":2};
//   %p2600 = (414, -398);
//   %wire_5675 = &"GND" @WIRE(mode="straight") {%p2600 #"I1339":4};
//   %p2601 = (40, -426);
//   %wire_5676 = &"GND" @WIRE(mode="straight") {%p2601 #"I1000":2};
//   %p2602 = (-32, -180);
//   %wire_5677 = &"GND" @WIRE(mode="straight") {%p2602 #"I1471":4};
//   %p2603 = (378, -321);
//   %wire_5678 = &"GND" @WIRE(mode="straight") {%p2603 #"I1327":2};
//   %p2604 = (-32, -250);
//   %wire_5679 = &"GND" @WIRE(mode="straight") {%p2604 #"I1479":4};
//   %p2605 = (-44, -215);
//   %wire_5680 = &"GND" @WIRE(mode="straight") {%p2605 #"I1484":5};
//   %p2606 = (306, -391);
//   %wire_5681 = &"GND" @WIRE(mode="straight") {%p2606 #"I1341":2};
//   %p2607 = (-8, -379);
//   %wire_5682 = &"GND" @WIRE(mode="straight") {%p2607 #"I1494":5};
//   %p2608 = (-16, -414);
//   %wire_5683 = &"GND" @WIRE(mode="straight") {%p2608 #"I1509":5};
//   %wire_5684 = &"GND" @WIRE(mode="straight") {#"I919":10 #"I1298":10};
//   %wire_5685 = &"GND" @WIRE(mode="straight") {#"I959":10 #"I1315":10};
//   %p2609 = (40, -601);
//   %wire_5686 = &"GND" @WIRE(mode="straight") {%p2609 #"I1382":2};
//   %p2610 = (330, -6);
//   %wire_5687 = &"GND" @WIRE(mode="straight") {%p2610 #"I679":2};
//   %p2611 = (378, -6);
//   %wire_5688 = &"GND" @WIRE(mode="straight") {%p2611 #"I723":2};
//   %p2612 = (354, -356);
//   %wire_5689 = &"GND" @WIRE(mode="straight") {%p2612 #"I985":2};
//   %p2613 = (150, -391);
//   %wire_5690 = &"GND" @WIRE(mode="straight") {%p2613 #"I1335":2};
//   %p2614 = (330, -41);
//   %wire_5691 = &"GND" @WIRE(mode="straight") {%p2614 #"I786":2};
//   %p2615 = (354, -216);
//   %wire_5692 = &"GND" @WIRE(mode="straight") {%p2615 #"I905":2};
//   %p2616 = (378, -531);
//   %wire_5693 = &"GND" @WIRE(mode="straight") {%p2616 #"I1378":2};
//   %p2617 = (402, -251);
//   %wire_5694 = &"GND" @WIRE(mode="straight") {%p2617 #"I1311":2};
//   %p2618 = (40, -566);
//   %wire_5695 = &"GND" @WIRE(mode="straight") {%p2618 #"I1080":2};
//   %p2619 = (-55, -145);
//   %wire_5696 = &"GND" @WIRE(mode="straight") {%p2619 #"I1475":4};
//   %p2620 = (354, -531);
//   %wire_5697 = &"GND" @WIRE(mode="straight") {%p2620 #"I1377":2};
//   %p2621 = (378, -76);
//   %wire_5698 = &"GND" @WIRE(mode="straight") {%p2621 #"I824":2};
//   %p2622 = (-32, -215);
//   %wire_5699 = &"GND" @WIRE(mode="straight") {%p2622 #"I1480":4};
//   %p2623 = (-32, -285);
//   %wire_5700 = &"GND" @WIRE(mode="straight") {%p2623 #"I1488":4};
//   %p2624 = (174, -146);
//   %wire_5701 = &"GND" @WIRE(mode="straight") {%p2624 #"I852":2};
//   %p2625 = (378, -741);
//   %wire_5702 = &"GND" @WIRE(mode="straight") {%p2625 #"I1429":2};
//   %p2626 = (150, -146);
//   %wire_5703 = &"GND" @WIRE(mode="straight") {%p2626 #"I853":2};
//   %p2627 = (103, -241);
//   %wire_5704 = &"GND" @WIRE(mode="straight") {%p2627 #"M136":4};
//   %p2628 = (-32, -390);
//   %wire_5705 = &"GND" @WIRE(mode="straight") {%p2628 #"I1495":4};
//   %p2629 = (174, -426);
//   %wire_5706 = &"GND" @WIRE(mode="straight") {%p2629 #"I1012":2};
//   %p2630 = (-32, -355);
//   %wire_5707 = &"GND" @WIRE(mode="straight") {%p2630 #"I1496":4};
//   %p2631 = (-55, -390);
//   %wire_5708 = &"GND" @WIRE(mode="straight") {%p2631 #"I1497":4};
//   %p2632 = (103, -661);
//   %wire_5709 = &"GND" @WIRE(mode="straight") {%p2632 #"M148":4};
//   %p2633 = (88, -146);
//   %wire_5710 = &"GND" @WIRE(mode="straight") {%p2633 #"I842":2};
//   %p2634 = (-55, -355);
//   %wire_5711 = &"GND" @WIRE(mode="straight") {%p2634 #"I1499":4};
//   %p2635 = (234, -6);
//   %wire_5712 = &"GND" @WIRE(mode="straight") {%p2635 #"I591":2};
//   %p2636 = (88, -671);
//   %wire_5713 = &"GND" @WIRE(mode="straight") {%p2636 #"I1397":2};
//   %p2637 = (378, -286);
//   %wire_5714 = &"GND" @WIRE(mode="straight") {%p2637 #"I944":2};
//   %p2638 = (40, -6);
//   %wire_5715 = &"GND" @WIRE(mode="straight") {%p2638 #"I437":2};
//   %p2639 = (282, -41);
//   %wire_5716 = &"GND" @WIRE(mode="straight") {%p2639 #"I788":2};
//   %p2640 = (-44, -460);
//   %wire_5717 = &"GND" @WIRE(mode="straight") {%p2640 #"I1506":5};
//   %p2641 = (-44, -495);
//   %wire_5718 = &"GND" @WIRE(mode="straight") {%p2641 #"I1516":5};
//   %p2642 = (16, -41);
//   %wire_5719 = &"GND" @WIRE(mode="straight") {%p2642 #"I770":2};
//   %p2643 = (-55, -40);
//   %wire_5720 = &"GND" @WIRE(mode="straight") {%p2643 #"I774":4};
//   %p2644 = (330, -426);
//   %wire_5721 = &"GND" @WIRE(mode="straight") {%p2644 #"I1026":2};
//   %p2645 = (-55, -495);
//   %wire_5722 = &"GND" @WIRE(mode="straight") {%p2645 #"I1515":4};
//   %p2646 = (174, -76);
//   %wire_5723 = &"GND" @WIRE(mode="straight") {%p2646 #"I812":2};
//   %p2647 = (-55, -530);
//   %wire_5724 = &"GND" @WIRE(mode="straight") {%p2647 #"I1513":4};
//   %p2648 = (-8, -519);
//   %wire_5725 = &"GND" @WIRE(mode="straight") {%p2648 #"I1510":5};
//   %p2649 = (103, -276);
//   %wire_5726 = &"GND" @WIRE(mode="straight") {%p2649 #"M137":4};
//   %p2650 = (354, -76);
//   %wire_5727 = &"GND" @WIRE(mode="straight") {%p2650 #"I825":2};
//   %p2651 = (103, -381);
//   %wire_5728 = &"GND" @WIRE(mode="straight") {%p2651 #"M140":4};
//   %p2652 = (-55, -425);
//   %wire_5729 = &"GND" @WIRE(mode="straight") {%p2652 #"I1507":4};
//   %p2653 = (103, -206);
//   %wire_5730 = &"GND" @WIRE(mode="straight") {%p2653 #"M135":4};
//   %p2654 = (-55, -460);
//   %wire_5731 = &"GND" @WIRE(mode="straight") {%p2654 #"I1505":4};
//   %p2655 = (414, -48);
//   %wire_5732 = &"GND" @WIRE(mode="straight") {%p2655 #"I782":4};
//   %p2656 = (103, -486);
//   %wire_5733 = &"GND" @WIRE(mode="straight") {%p2656 #"M143":4};
//   %p2657 = (-44, -600);
//   %wire_5734 = &"GND" @WIRE(mode="straight") {%p2657 #"I1522":5};
//   %p2658 = (282, -146);
//   %wire_5735 = &"GND" @WIRE(mode="straight") {%p2658 #"I868":2};
//   %p2659 = (198, -216);
//   %wire_5736 = &"GND" @WIRE(mode="straight") {%p2659 #"I891":2};
//   %p2660 = (258, -671);
//   %wire_5737 = &"GND" @WIRE(mode="straight") {%p2660 #"I1401":2};
//   %p2661 = (378, -671);
//   %wire_5738 = &"GND" @WIRE(mode="straight") {%p2661 #"I1412":2};
//   %p2662 = (234, -216);
//   %wire_5739 = &"GND" @WIRE(mode="straight") {%p2662 #"I890":2};
//   %p2663 = (198, -146);
//   %wire_5740 = &"GND" @WIRE(mode="straight") {%p2663 #"I851":2};
//   %p2664 = (64, -41);
//   %wire_5741 = &"GND" @WIRE(mode="straight") {%p2664 #"I772":2};
//   %p2665 = (-32, -495);
//   %wire_5742 = &"GND" @WIRE(mode="straight") {%p2665 #"I1512":4};
//   %wire_5743 = &"GND" @WIRE(mode="straight") {#"I1264":10 #"I799":10};
//   %p2666 = (234, -146);
//   %wire_5744 = &"GND" @WIRE(mode="straight") {%p2666 #"I850":2};
//   %p2667 = (234, -391);
//   %wire_5745 = &"GND" @WIRE(mode="straight") {%p2667 #"I1338":2};
//   %p2668 = (150, -496);
//   %wire_5746 = &"GND" @WIRE(mode="straight") {%p2668 #"I1053":2};
//   %p2669 = (40, -391);
//   %wire_5747 = &"GND" @WIRE(mode="straight") {%p2669 #"I1331":2};
//   %p2670 = (88, -496);
//   %wire_5748 = &"GND" @WIRE(mode="straight") {%p2670 #"I1042":2};
//   %wire_5749 = &"GND" @WIRE(mode="straight") {#"I1400":10 #"I1119":10};
//   %p2671 = (64, -531);
//   %wire_5750 = &"GND" @WIRE(mode="straight") {%p2671 #"I1364":2};
//   %p2672 = (64, -741);
//   %wire_5751 = &"GND" @WIRE(mode="straight") {%p2672 #"I1415":2};
//   %p2673 = (150, -216);
//   %wire_5752 = &"GND" @WIRE(mode="straight") {%p2673 #"I893":2};
//   %p2674 = (40, -461);
//   %wire_5753 = &"GND" @WIRE(mode="straight") {%p2674 #"I1348":2};
//   %p2675 = (234, -531);
//   %wire_5754 = &"GND" @WIRE(mode="straight") {%p2675 #"I1372":2};
//   %p2676 = (282, -531);
//   %wire_5755 = &"GND" @WIRE(mode="straight") {%p2676 #"I1374":2};
//   %p2677 = (402, -671);
//   %wire_5756 = &"GND" @WIRE(mode="straight") {%p2677 #"I1413":2};
//   %p2678 = (174, -216);
//   %wire_5757 = &"GND" @WIRE(mode="straight") {%p2678 #"I892":2};
//   %p2679 = (150, -601);
//   %wire_5758 = &"GND" @WIRE(mode="straight") {%p2679 #"I1386":2};
//   %p2680 = (16, -286);
//   %wire_5759 = &"GND" @WIRE(mode="straight") {%p2680 #"I919":2};
//   %p2681 = (330, -216);
//   %wire_5760 = &"GND" @WIRE(mode="straight") {%p2681 #"I906":2};
//   %p2682 = (258, -146);
//   %wire_5761 = &"GND" @WIRE(mode="straight") {%p2682 #"I849":2};
//   %p2683 = (354, -601);
//   %wire_5762 = &"GND" @WIRE(mode="straight") {%p2683 #"I1394":2};
//   %p2684 = (258, -41);
//   %wire_5763 = &"GND" @WIRE(mode="straight") {%p2684 #"I776":2};
//   %p2685 = (88, -286);
//   %wire_5764 = &"GND" @WIRE(mode="straight") {%p2685 #"I922":2};
//   %p2686 = (258, -286);
//   %wire_5765 = &"GND" @WIRE(mode="straight") {%p2686 #"I929":2};
//   %p2687 = (234, -286);
//   %wire_5766 = &"GND" @WIRE(mode="straight") {%p2687 #"I930":2};
//   %p2688 = (198, -286);
//   %wire_5767 = &"GND" @WIRE(mode="straight") {%p2688 #"I931":2};
//   %p2689 = (40, -286);
//   %wire_5768 = &"GND" @WIRE(mode="straight") {%p2689 #"I920":2};
//   %p2690 = (-44, 30);
//   %wire_5769 = &"GND" @WIRE(mode="straight") {%p2690 #"I1543":5};
//   %p2691 = (64, -6);
//   %wire_5770 = &"GND" @WIRE(mode="straight") {%p2691 #"I459":2};
//   %p2692 = (150, -41);
//   %wire_5771 = &"GND" @WIRE(mode="straight") {%p2692 #"I780":2};
//   %p2693 = (198, -356);
//   %wire_5772 = &"GND" @WIRE(mode="straight") {%p2693 #"I971":2};
//   %p2694 = (330, -76);
//   %wire_5773 = &"GND" @WIRE(mode="straight") {%p2694 #"I826":2};
//   %p2695 = (126, -671);
//   %wire_5774 = &"GND" @WIRE(mode="straight") {%p2695 #"I1402":2};
//   %p2696 = (354, -671);
//   %wire_5775 = &"GND" @WIRE(mode="straight") {%p2696 #"I1411":2};
//   %p2697 = (234, -461);
//   %wire_5776 = &"GND" @WIRE(mode="straight") {%p2697 #"I1355":2};
//   %p2698 = (174, -461);
//   %wire_5777 = &"GND" @WIRE(mode="straight") {%p2698 #"I1353":2};
//   %p2699 = (282, -216);
//   %wire_5778 = &"GND" @WIRE(mode="straight") {%p2699 #"I908":2};
//   %p2700 = (-55, 30);
//   %wire_5779 = &"GND" @WIRE(mode="straight") {%p2700 #"I1542":4};
//   %p2701 = (258, -426);
//   %wire_5780 = &"GND" @WIRE(mode="straight") {%p2701 #"I1009":2};
//   %p2702 = (414, -608);
//   %wire_5781 = &"GND" @WIRE(mode="straight") {%p2702 #"I1390":4};
//   %p2703 = (306, -601);
//   %wire_5782 = &"GND" @WIRE(mode="straight") {%p2703 #"I1392":2};
//   %p2704 = (198, -741);
//   %wire_5783 = &"GND" @WIRE(mode="straight") {%p2704 #"I1422":2};
//   %p2705 = (-55, 65);
//   %wire_5784 = &"GND" @WIRE(mode="straight") {%p2705 #"I1550":4};
//   %p2706 = (414, -748);
//   %wire_5785 = &"GND" @WIRE(mode="straight") {%p2706 #"I1424":4};
//   %p2707 = (354, -461);
//   %wire_5786 = &"GND" @WIRE(mode="straight") {%p2707 #"I1360":2};
//   %p2708 = (-55, -215);
//   %wire_5787 = &"GND" @WIRE(mode="straight") {%p2708 #"I1483":4};
//   %p2709 = (234, -356);
//   %wire_5788 = &"GND" @WIRE(mode="straight") {%p2709 #"I970":2};
//   %p2710 = (378, -426);
//   %wire_5789 = &"GND" @WIRE(mode="straight") {%p2710 #"I1024":2};
//   %p2711 = (330, -461);
//   %wire_5790 = &"GND" @WIRE(mode="straight") {%p2711 #"I1359":2};
//   %p2712 = (282, -601);
//   %wire_5791 = &"GND" @WIRE(mode="straight") {%p2712 #"I1391":2};
//   %p2713 = (16, -356);
//   %wire_5792 = &"GND" @WIRE(mode="straight") {%p2713 #"I959":2};
//   %p2714 = (40, -531);
//   %wire_5793 = &"GND" @WIRE(mode="straight") {%p2714 #"I1365":2};
//   %p2715 = (-55, -285);
//   %wire_5794 = &"GND" @WIRE(mode="straight") {%p2715 #"I1491":4};
//   %p2716 = (402, -426);
//   %wire_5795 = &"GND" @WIRE(mode="straight") {%p2716 #"I1023":2};
//   %p2717 = (126, -531);
//   %wire_5796 = &"GND" @WIRE(mode="straight") {%p2717 #"I1368":2};
//   %p2718 = (126, -496);
//   %wire_5797 = &"GND" @WIRE(mode="straight") {%p2718 #"I1054":2};
//   %p2719 = (16, -496);
//   %wire_5798 = &"GND" @WIRE(mode="straight") {%p2719 #"I1039":2};
//   %p2720 = (40, -356);
//   %wire_5799 = &"GND" @WIRE(mode="straight") {%p2720 #"I960":2};
//   %p2721 = (88, -566);
//   %wire_5800 = &"GND" @WIRE(mode="straight") {%p2721 #"I1082":2};
//   %p2722 = (64, -496);
//   %wire_5801 = &"GND" @WIRE(mode="straight") {%p2722 #"I1041":2};
//   %wire_5802 = &"GND" @WIRE(mode="straight") {#"I1119":10 #"I1383":10};
//   %p2723 = (88, -391);
//   %wire_5803 = &"GND" @WIRE(mode="straight") {%p2723 #"I1329":2};
//   %p2724 = (174, -496);
//   %wire_5804 = &"GND" @WIRE(mode="straight") {%p2724 #"I1052":2};
//   %p2725 = (378, -461);
//   %wire_5805 = &"GND" @WIRE(mode="straight") {%p2725 #"I1361":2};
//   %p2726 = (437, -726);
//   %wire_5806 = &"GND" @WIRE(mode="straight") {%p2726 #"I1260":5};
//   %p2727 = (282, -391);
//   %wire_5807 = &"GND" @WIRE(mode="straight") {%p2727 #"I1340":2};
//   %p2728 = (402, -531);
//   %wire_5808 = &"GND" @WIRE(mode="straight") {%p2728 #"I1379":2};
//   %p2729 = (16, -601);
//   %wire_5809 = &"GND" @WIRE(mode="straight") {%p2729 #"I1383":2};
//   %wire_5810 = &"GND" @WIRE(mode="straight") {#"I770":10 #"I415":10};
//   %p2730 = (174, -741);
//   %wire_5811 = &"GND" @WIRE(mode="straight") {%p2730 #"I1421":2};
//   %p2731 = (402, -496);
//   %wire_5812 = &"GND" @WIRE(mode="straight") {%p2731 #"I1063":2};
//   %p2732 = (354, -741);
//   %wire_5813 = &"GND" @WIRE(mode="straight") {%p2732 #"I1428":2};
//   %p2733 = (64, -601);
//   %wire_5814 = &"GND" @WIRE(mode="straight") {%p2733 #"I1381":2};
//   %p2734 = (126, -391);
//   %wire_5815 = &"GND" @WIRE(mode="straight") {%p2734 #"I1334":2};
//   %p2735 = (126, -41);
//   %wire_5816 = &"GND" @WIRE(mode="straight") {%p2735 #"I781":2};
//   %p2736 = (330, -356);
//   %wire_5817 = &"GND" @WIRE(mode="straight") {%p2736 #"I986":2};
//   %p2737 = (402, -741);
//   %wire_5818 = &"GND" @WIRE(mode="straight") {%p2737 #"I1430":2};
//   %p2738 = (40, -496);
//   %wire_5819 = &"GND" @WIRE(mode="straight") {%p2738 #"I1040":2};
//   %p2739 = (103, -451);
//   %wire_5820 = &"GND" @WIRE(mode="straight") {%p2739 #"M142":4};
//   %p2740 = (64, -391);
//   %wire_5821 = &"GND" @WIRE(mode="straight") {%p2740 #"I1330":2};
//   %p2741 = (126, -426);
//   %wire_5822 = &"GND" @WIRE(mode="straight") {%p2741 #"I1014":2};
//   %wire_5823 = &"GND" @WIRE(mode="straight") {#"I1417":10 #"I1159":10};
//   %p2742 = (64, -426);
//   %wire_5824 = &"GND" @WIRE(mode="straight") {%p2742 #"I1001":2};
//   %p2743 = (40, -321);
//   %wire_5825 = &"GND" @WIRE(mode="straight") {%p2743 #"I1314":2};
//   %p2744 = (354, -6);
//   %wire_5826 = &"GND" @WIRE(mode="straight") {%p2744 #"I701":2};
//   %p2745 = (198, -251);
//   %wire_5827 = &"GND" @WIRE(mode="straight") {%p2745 #"I1303":2};
//   %wire_5828 = &"GND" @WIRE(mode="straight") {#"I839":10 #"I1264":10};
//   %p2746 = (354, -286);
//   %wire_5829 = &"GND" @WIRE(mode="straight") {%p2746 #"I945":2};
//   %p2747 = (282, -251);
//   %wire_5830 = &"GND" @WIRE(mode="straight") {%p2747 #"I1306":2};
//   %p2748 = (126, -321);
//   %wire_5831 = &"GND" @WIRE(mode="straight") {%p2748 #"I1317":2};
//   %p2749 = (402, -41);
//   %wire_5832 = &"GND" @WIRE(mode="straight") {%p2749 #"I783":2};
//   %p2750 = (306, -251);
//   %wire_5833 = &"GND" @WIRE(mode="straight") {%p2750 #"I1307":2};
//   %p2751 = (103, -521);
//   %wire_5834 = &"GND" @WIRE(mode="straight") {%p2751 #"M144":4};
//   %p2752 = (354, -321);
//   %wire_5835 = &"GND" @WIRE(mode="straight") {%p2752 #"I1326":2};
//   %p2753 = (282, -566);
//   %wire_5836 = &"GND" @WIRE(mode="straight") {%p2753 #"I1108":2};
//   %p2754 = (150, -566);
//   %wire_5837 = &"GND" @WIRE(mode="straight") {%p2754 #"I1093":2};
//   %p2755 = (414, -85);
//   %wire_5838 = &"GND" @WIRE(mode="straight") {%p2755 #"I822":4};
//   %p2756 = (306, -6);
//   %wire_5839 = &"GND" @WIRE(mode="straight") {%p2756 #"I657":2};
//   %p2757 = (16, -76);
//   %wire_5840 = &"GND" @WIRE(mode="straight") {%p2757 #"I799":2};
//   %p2758 = (-8, -449);
//   %wire_5841 = &"GND" @WIRE(mode="straight") {%p2758 #"I1502":5};
//   %p2759 = (-32, -460);
//   %wire_5842 = &"GND" @WIRE(mode="straight") {%p2759 #"I1503":4};
//   %p2760 = (-32, -40);
//   %wire_5843 = &"GND" @WIRE(mode="straight") {%p2760 #"I769":4};
//   %p2761 = (258, -566);
//   %wire_5844 = &"GND" @WIRE(mode="straight") {%p2761 #"I1089":2};
//   %p2762 = (174, -601);
//   %wire_5845 = &"GND" @WIRE(mode="straight") {%p2762 #"I1387":2};
//   %p2763 = (234, -496);
//   %wire_5846 = &"GND" @WIRE(mode="straight") {%p2763 #"I1050":2};
//   %p2764 = (150, -671);
//   %wire_5847 = &"GND" @WIRE(mode="straight") {%p2764 #"I1403":2};
//   %p2765 = (330, -531);
//   %wire_5848 = &"GND" @WIRE(mode="straight") {%p2765 #"I1376":2};
//   %p2766 = (40, -76);
//   %wire_5849 = &"GND" @WIRE(mode="straight") {%p2766 #"I800":2};
//   %p2767 = (126, -566);
//   %wire_5850 = &"GND" @WIRE(mode="straight") {%p2767 #"I1094":2};
//   %p2768 = (306, -566);
//   %wire_5851 = &"GND" @WIRE(mode="straight") {%p2768 #"I1107":2};
//   %p2769 = (150, -321);
//   %wire_5852 = &"GND" @WIRE(mode="straight") {%p2769 #"I1318":2};
//   %p2770 = (306, -286);
//   %wire_5853 = &"GND" @WIRE(mode="straight") {%p2770 #"I947":2};
//   %p2771 = (282, -286);
//   %wire_5854 = &"GND" @WIRE(mode="straight") {%p2771 #"I948":2};
//   %p2772 = (174, -286);
//   %wire_5855 = &"GND" @WIRE(mode="straight") {%p2772 #"I932":2};
//   %p2773 = (198, -566);
//   %wire_5856 = &"GND" @WIRE(mode="straight") {%p2773 #"I1091":2};
//   %p2774 = (414, -468);
//   %wire_5857 = &"GND" @WIRE(mode="straight") {%p2774 #"I1356":4};
//   %p2775 = (64, -321);
//   %wire_5858 = &"GND" @WIRE(mode="straight") {%p2775 #"I1313":2};
//   %p2776 = (174, -566);
//   %wire_5859 = &"GND" @WIRE(mode="straight") {%p2776 #"I1092":2};
//   %p2777 = (306, -426);
//   %wire_5860 = &"GND" @WIRE(mode="straight") {%p2777 #"I1027":2};
//   %p2778 = (354, -391);
//   %wire_5861 = &"GND" @WIRE(mode="straight") {%p2778 #"I1343":2};
//   %p2779 = (234, -76);
//   %wire_5862 = &"GND" @WIRE(mode="straight") {%p2779 #"I810":2};
//   %p2780 = (234, -566);
//   %wire_5863 = &"GND" @WIRE(mode="straight") {%p2780 #"I1090":2};
//   %p2781 = (414, -538);
//   %wire_5864 = &"GND" @WIRE(mode="straight") {%p2781 #"I1373":4};
//   %p2782 = (258, -461);
//   %wire_5865 = &"GND" @WIRE(mode="straight") {%p2782 #"I1350":2};
//   %p2783 = (88, -76);
//   %wire_5866 = &"GND" @WIRE(mode="straight") {%p2783 #"I802":2};
//   %p2784 = (198, -426);
//   %wire_5867 = &"GND" @WIRE(mode="straight") {%p2784 #"I1011":2};
//   %p2785 = (103, -171);
//   %wire_5868 = &"GND" @WIRE(mode="straight") {%p2785 #"M134":4};
//   %p2786 = (88, -426);
//   %wire_5869 = &"GND" @WIRE(mode="straight") {%p2786 #"I1002":2};
//   %p2787 = (103, -416);
//   %wire_5870 = &"GND" @WIRE(mode="straight") {%p2787 #"M141":4};
//   %p2788 = (258, -216);
//   %wire_5871 = &"GND" @WIRE(mode="straight") {%p2788 #"I889":2};
//   %p2789 = (414, -258);
//   %wire_5872 = &"GND" @WIRE(mode="straight") {%p2789 #"I1305":4};
//   %p2790 = (16, -321);
//   %wire_5873 = &"GND" @WIRE(mode="straight") {%p2790 #"I1315":2};
//   %p2791 = (126, -216);
//   %wire_5874 = &"GND" @WIRE(mode="straight") {%p2791 #"I894":2};
//   %p2792 = (330, -146);
//   %wire_5875 = &"GND" @WIRE(mode="straight") {%p2792 #"I866":2};
//   %p2793 = (-44, -250);
//   %wire_5876 = &"GND" @WIRE(mode="straight") {%p2793 #"I1482":5};
//   %p2794 = (198, -391);
//   %wire_5877 = &"GND" @WIRE(mode="straight") {%p2794 #"I1337":2};
//   %p2795 = (126, -76);
//   %wire_5878 = &"GND" @WIRE(mode="straight") {%p2795 #"I814":2};
//   %p2796 = (16, -741);
//   %wire_5879 = &"GND" @WIRE(mode="straight") {%p2796 #"I1417":2};
//   %p2797 = (64, -356);
//   %wire_5880 = &"GND" @WIRE(mode="straight") {%p2797 #"I961":2};
//   %p2798 = (282, -671);
//   %wire_5881 = &"GND" @WIRE(mode="straight") {%p2798 #"I1408":2};
//   %p2799 = (306, -146);
//   %wire_5882 = &"GND" @WIRE(mode="straight") {%p2799 #"I867":2};
//   %p2800 = (-44, -565);
//   %wire_5883 = &"GND" @WIRE(mode="straight") {%p2800 #"I1524":5};
//   %p2801 = (402, -216);
//   %wire_5884 = &"GND" @WIRE(mode="straight") {%p2801 #"I903":2};
//   %p2802 = (126, -741);
//   %wire_5885 = &"GND" @WIRE(mode="straight") {%p2802 #"I1419":2};
//   %p2803 = (103, -101);
//   %wire_5886 = &"GND" @WIRE(mode="straight") {%p2803 #"M132":4};
//   %p2804 = (103, -31);
//   %wire_5887 = &"GND" @WIRE(mode="straight") {%p2804 #"M130":4};
//   %wire_5888 = &"GND" @WIRE(mode="straight") {#"I1039":10 #"I1349":10};
//   %p2805 = (198, -461);
//   %wire_5889 = &"GND" @WIRE(mode="straight") {%p2805 #"I1354":2};
//   %p2806 = (258, -356);
//   %wire_5890 = &"GND" @WIRE(mode="straight") {%p2806 #"I969":2};
//   %p2807 = (-44, -530);
//   %wire_5891 = &"GND" @WIRE(mode="straight") {%p2807 #"I1514":5};
//   %p2808 = (88, -741);
//   %wire_5892 = &"GND" @WIRE(mode="straight") {%p2808 #"I1414":2};
//   %p2809 = (378, -496);
//   %wire_5893 = &"GND" @WIRE(mode="straight") {%p2809 #"I1064":2};
//   %p2810 = (330, -671);
//   %wire_5894 = &"GND" @WIRE(mode="straight") {%p2810 #"I1410":2};
//   %p2811 = (198, -496);
//   %wire_5895 = &"GND" @WIRE(mode="straight") {%p2811 #"I1051":2};
//   %p2812 = (-55, -565);
//   %wire_5896 = &"GND" @WIRE(mode="straight") {%p2812 #"I1523":4};
//   %p2813 = (258, -531);
//   %wire_5897 = &"GND" @WIRE(mode="straight") {%p2813 #"I1367":2};
//   %p2814 = (258, -741);
//   %wire_5898 = &"GND" @WIRE(mode="straight") {%p2814 #"I1418":2};
//   %wire_5899 = &"GND" @WIRE(mode="straight") {#"I879":10 #"I1281":10};
//   %p2815 = (64, -566);
//   %wire_5900 = &"GND" @WIRE(mode="straight") {%p2815 #"I1081":2};
//   %p2816 = (103, -591);
//   %wire_5901 = &"GND" @WIRE(mode="straight") {%p2816 #"M146":4};
//   %wire_5902 = &"GND" @WIRE(mode="straight") {#"I1332":10 #"I959":10};
//   %p2817 = (378, -251);
//   %wire_5903 = &"GND" @WIRE(mode="straight") {%p2817 #"I1310":2};
//   %p2818 = (258, -76);
//   %wire_5904 = &"GND" @WIRE(mode="straight") {%p2818 #"I809":2};
//   %p2819 = (211, -661);
//   %wire_5905 = &"GND" @WIRE(mode="straight") {%p2819 #"M153":4};
//   %p2820 = (234, -251);
//   %wire_5906 = &"GND" @WIRE(mode="straight") {%p2820 #"I1304":2};
//   %p2821 = (103, -346);
//   %wire_5907 = &"GND" @WIRE(mode="straight") {%p2821 #"M139":4};
//   %p2822 = (414, -15);
//   %wire_5908 = &"GND" @WIRE(mode="straight") {%p2822 #"I768":4};
//   %p2823 = (40, -741);
//   %wire_5909 = &"GND" @WIRE(mode="straight") {%p2823 #"I1416":2};
//   %p2824 = (126, -461);
//   %wire_5910 = &"GND" @WIRE(mode="straight") {%p2824 #"I1351":2};
//   %p2825 = (282, -6);
//   %wire_5911 = &"GND" @WIRE(mode="straight") {%p2825 #"I635":2};
//   %p2826 = (43, -757);
//   %wire_5912 = &"GND" @WIRE(mode="straight") {%p2826 #"I1621":5};
//   %p2827 = (198, -671);
//   %wire_5913 = &"GND" @WIRE(mode="straight") {%p2827 #"I1405":2};
//   %p2828 = (198, -531);
//   %wire_5914 = &"GND" @WIRE(mode="straight") {%p2828 #"I1371":2};
//   %p2829 = (198, -76);
//   %wire_5915 = &"GND" @WIRE(mode="straight") {%p2829 #"I811":2};
//   %p2830 = (-44, -75);
//   %wire_5916 = &"GND" @WIRE(mode="straight") {%p2830 #"I1468":5};
//   %p2831 = (414, -328);
//   %wire_5917 = &"GND" @WIRE(mode="straight") {%p2831 #"I1322":4};
//   %p2832 = (-44, -110);
//   %wire_5918 = &"GND" @WIRE(mode="straight") {%p2832 #"I1466":5};
//   %p2833 = (174, -671);
//   %wire_5919 = &"GND" @WIRE(mode="straight") {%p2833 #"I1404":2};
//   %p2834 = (330, -321);
//   %wire_5920 = &"GND" @WIRE(mode="straight") {%p2834 #"I1325":2};
//   %p2835 = (103, -696);
//   %wire_5921 = &"GND" @WIRE(mode="straight") {%p2835 #"M149":4};
//   %p2836 = (306, -741);
//   %wire_5922 = &"GND" @WIRE(mode="straight") {%p2836 #"I1426":2};
//   %p2837 = (378, -356);
//   %wire_5923 = &"GND" @WIRE(mode="straight") {%p2837 #"I984":2};
//   %p2838 = (150, -76);
//   %wire_5924 = &"GND" @WIRE(mode="straight") {%p2838 #"I813":2};
//   %p2839 = (16, -461);
//   %wire_5925 = &"GND" @WIRE(mode="straight") {%p2839 #"I1349":2};
//   %p2840 = (-44, -145);
//   %wire_5926 = &"GND" @WIRE(mode="straight") {%p2840 #"I1476":5};
//   %p2841 = (306, -356);
//   %wire_5927 = &"GND" @WIRE(mode="straight") {%p2841 #"I987":2};
//   %p2842 = (282, -496);
//   %wire_5928 = &"GND" @WIRE(mode="straight") {%p2842 #"I1068":2};
//   %p2843 = (414, -505);
//   %wire_5929 = &"GND" @WIRE(mode="straight") {%p2843 #"I1062":4};
//   %p2844 = (88, -216);
//   %wire_5930 = &"GND" @WIRE(mode="straight") {%p2844 #"I882":2};
//   %p2845 = (306, -461);
//   %wire_5931 = &"GND" @WIRE(mode="straight") {%p2845 #"I1358":2};
//   %p2846 = (258, -321);
//   %wire_5932 = &"GND" @WIRE(mode="straight") {%p2846 #"I1316":2};
//   %p2847 = (402, -391);
//   %wire_5933 = &"GND" @WIRE(mode="straight") {%p2847 #"I1345":2};
//   %p2848 = (88, -531);
//   %wire_5934 = &"GND" @WIRE(mode="straight") {%p2848 #"I1363":2};
//   %p2849 = (64, -216);
//   %wire_5935 = &"GND" @WIRE(mode="straight") {%p2849 #"I881":2};
//   %p2850 = (330, -741);
//   %wire_5936 = &"GND" @WIRE(mode="straight") {%p2850 #"I1427":2};
//   %p2851 = (282, -321);
//   %wire_5937 = &"GND" @WIRE(mode="straight") {%p2851 #"I1323":2};
//   %wire_5938 = &"GND" @WIRE(mode="straight") {#"I1079":10 #"I1366":10};
//   %p2852 = (378, -391);
//   %wire_5939 = &"GND" @WIRE(mode="straight") {%p2852 #"I1344":2};
//   %p2853 = (40, -216);
//   %wire_5940 = &"GND" @WIRE(mode="straight") {%p2853 #"I880":2};
//   %p2854 = (64, -76);
//   %wire_5941 = &"GND" @WIRE(mode="straight") {%p2854 #"I801":2};
//   %wire_5942 = &"GND" @WIRE(mode="straight") {#"I1315":10 #"I919":10};
//   %p2855 = (88, -601);
//   %wire_5943 = &"GND" @WIRE(mode="straight") {%p2855 #"I1380":2};
//   %p2856 = (378, -41);
//   %wire_5944 = &"GND" @WIRE(mode="straight") {%p2856 #"I784":2};
//   %p2857 = (354, -496);
//   %wire_5945 = &"GND" @WIRE(mode="straight") {%p2857 #"I1065":2};
//   %p2858 = (-8, -239);
//   %wire_5946 = &"GND" @WIRE(mode="straight") {%p2858 #"I1478":5};
//   %p2859 = (16, -216);
//   %wire_5947 = &"GND" @WIRE(mode="straight") {%p2859 #"I879":2};
//   %p2860 = (-16, -204);
//   %wire_5948 = &"GND" @WIRE(mode="straight") {%p2860 #"I1485":5};
//   %p2861 = (16, -146);
//   %wire_5949 = &"GND" @WIRE(mode="straight") {%p2861 #"I839":2};
//   %p2862 = (330, -496);
//   %wire_5950 = &"GND" @WIRE(mode="straight") {%p2862 #"I1066":2};
//   %p2863 = (211, -696);
//   %wire_5951 = &"GND" @WIRE(mode="straight") {%p2863 #"M152":4};
//   %p2864 = (-16, -274);
//   %wire_5952 = &"GND" @WIRE(mode="straight") {%p2864 #"I1493":5};
//   %p2865 = (282, -741);
//   %wire_5953 = &"GND" @WIRE(mode="straight") {%p2865 #"I1425":2};
//   %p2866 = (402, -146);
//   %wire_5954 = &"GND" @WIRE(mode="straight") {%p2866 #"I863":2};
//   %p2867 = (103, -626);
//   %wire_5955 = &"GND" @WIRE(mode="straight") {%p2867 #"M147":4};
//   %p2868 = (16, -531);
//   %wire_5956 = &"GND" @WIRE(mode="straight") {%p2868 #"I1366":2};
//   %p2869 = (414, -295);
//   %wire_5957 = &"GND" @WIRE(mode="straight") {%p2869 #"I942":4};
//   %p2870 = (306, -671);
//   %wire_5958 = &"GND" @WIRE(mode="straight") {%p2870 #"I1409":2};
//   %p2871 = (-16, -134);
//   %wire_5959 = &"GND" @WIRE(mode="straight") {%p2871 #"I1477":5};
//   %p2872 = (40, -41);
//   %wire_5960 = &"GND" @WIRE(mode="straight") {%p2872 #"I771":2};
//   %p2873 = (174, -41);
//   %wire_5961 = &"GND" @WIRE(mode="straight") {%p2873 #"I779":2};
//   %wire_5962 = &"GND" @WIRE(mode="straight") {#"I1298":10 #"I879":10};
//   %wire_5564 @TEXT("GND", size=1, halign="middle", valign="baseline", rotate=90) => @PLACE(257.3, -4);
//   %wire_5955 @TEXT("GND", size=1, halign="middle", valign="baseline", rotate=90) => @PLACE(102.3, -625);
//   %wire_5959 @TEXT("GND", size=1, halign="middle", valign="baseline") => @PLACE(-14, -134.3);
//   %wire_5957 @TEXT("GND", size=1, halign="middle", valign="baseline", rotate=90) => @PLACE(413.3, -293);
//   %wire_5943 @TEXT("GND", size=1, halign="middle", valign="baseline", rotate=90) => @PLACE(87.3, -599);
//   %wire_5954 @TEXT("GND", size=1, halign="middle", valign="baseline", rotate=90) => @PLACE(401.3, -144);
//   %wire_5884 @TEXT("GND", size=1, halign="middle", valign="baseline", rotate=90) => @PLACE(401.3, -214);
//   %wire_5953 @TEXT("GND", size=1, halign="middle", valign="baseline", rotate=90) => @PLACE(281.3, -739);
//   %wire_5726 @TEXT("GND", size=1, halign="middle", valign="baseline", rotate=90) => @PLACE(102.3, -275);
//   %wire_5949 @TEXT("GND", size=1, halign="middle", valign="baseline", rotate=90) => @PLACE(15.3, -144);
//   %wire_5948 @TEXT("GND", size=1, halign="middle", valign="baseline") => @PLACE(-14, -204.3);
//   %wire_5950 @TEXT("GND", size=1, halign="middle", valign="baseline", rotate=90) => @PLACE(329.3, -494);
//   %wire_5952 @TEXT("GND", size=1, halign="middle", valign="baseline") => @PLACE(-14, -274.3);
//   %wire_5947 @TEXT("GND", size=1, halign="middle", valign="baseline", rotate=90) => @PLACE(15.3, -214);
//   %wire_5599 @TEXT("GND", size=1, halign="middle", valign="baseline", rotate=90) => @PLACE(413.3, -433);
//   %wire_5945 @TEXT("GND", size=1, halign="middle", valign="baseline", rotate=90) => @PLACE(353.3, -494);
//   %wire_5946 @TEXT("GND", size=1, halign="middle", valign="baseline") => @PLACE(-10, -239.3);
//   %wire_5940 @TEXT("GND", size=1, halign="middle", valign="baseline", rotate=90) => @PLACE(39.3, -214);
//   %wire_5799 @TEXT("GND", size=1, halign="middle", valign="baseline", rotate=90) => @PLACE(39.3, -354);
//   %wire_5939 @TEXT("GND", size=1, halign="middle", valign="baseline", rotate=90) => @PLACE(377.3, -389);
//   %wire_5725 @TEXT("GND", size=1, halign="middle", valign="baseline") => @PLACE(-10, -519.3);
//   %wire_5658 @TEXT("GND", size=1, halign="middle", valign="baseline", rotate=90) => @PLACE(281.3, -459);
//   %wire_5941 @TEXT("GND", size=1, halign="middle", valign="baseline", rotate=90) => @PLACE(63.3, -74);
//   %wire_5936 @TEXT("GND", size=1, halign="middle", valign="baseline", rotate=90) => @PLACE(329.3, -739);
//   %wire_5875 @TEXT("GND", size=1, halign="middle", valign="baseline", rotate=90) => @PLACE(329.3, -144);
//   %wire_5935 @TEXT("GND", size=1, halign="middle", valign="baseline", rotate=90) => @PLACE(63.3, -214);
//   %wire_5934 @TEXT("GND", size=1, halign="middle", valign="baseline", rotate=90) => @PLACE(87.3, -529);
//   %wire_5933 @TEXT("GND", size=1, halign="middle", valign="baseline", rotate=90) => @PLACE(401.3, -389);
//   %wire_5930 @TEXT("GND", size=1, halign="middle", valign="baseline", rotate=90) => @PLACE(87.3, -214);
//   %wire_5827 @TEXT("GND", size=1, halign="middle", valign="baseline", rotate=90) => @PLACE(197.3, -249);
//   %wire_5929 @TEXT("GND", size=1, halign="middle", valign="baseline", rotate=90) => @PLACE(413.3, -503);
//   %wire_5907 @TEXT("GND", size=1, halign="middle", valign="baseline", rotate=90) => @PLACE(102.3, -345);
//   %wire_5925 @TEXT("GND", size=1, halign="middle", valign="baseline", rotate=90) => @PLACE(15.3, -459);
//   %wire_5924 @TEXT("GND", size=1, halign="middle", valign="baseline", rotate=90) => @PLACE(149.3, -74);
//   %wire_5920 @TEXT("GND", size=1, halign="middle", valign="baseline", rotate=90) => @PLACE(329.3, -319);
//   %wire_5922 @TEXT("GND", size=1, halign="middle", valign="baseline", rotate=90) => @PLACE(305.3, -739);
//   %wire_5894 @TEXT("GND", size=1, halign="middle", valign="baseline", rotate=90) => @PLACE(329.3, -669);
//   %wire_5791 @TEXT("GND", size=1, halign="middle", valign="baseline", rotate=90) => @PLACE(281.3, -599);
//   %wire_5917 @TEXT("GND", size=1, halign="middle", valign="baseline", rotate=90) => @PLACE(413.3, -328);
//   %wire_5898 @TEXT("GND", size=1, halign="middle", valign="baseline", rotate=90) => @PLACE(257.3, -739);
//   %wire_5918 @TEXT("GND", size=1, halign="middle", valign="baseline", rotate=90) => @PLACE(-44.7, -108);
//   %wire_5916 @TEXT("GND", size=1, halign="middle", valign="baseline", rotate=90) => @PLACE(-44.7, -73);
//   %wire_5915 @TEXT("GND", size=1, halign="middle", valign="baseline", rotate=90) => @PLACE(197.3, -74);
//   %wire_5600 @TEXT("GND", size=1, halign="middle", valign="baseline", rotate=90) => @PLACE(87.3, -459);
//   %wire_5914 @TEXT("GND", size=1, halign="middle", valign="baseline", rotate=90) => @PLACE(197.3, -529);
//   %wire_5910 @TEXT("GND", size=1, halign="middle", valign="baseline", rotate=90) => @PLACE(125.3, -459);
//   %wire_5961 @TEXT("GND", size=1, halign="middle", valign="baseline", rotate=90) => @PLACE(173.3, -39);
//   %wire_5960 @TEXT("GND", size=1, halign="middle", valign="baseline", rotate=90) => @PLACE(39.3, -39);
//   %wire_5632 @TEXT("GND", size=1, halign="middle", valign="baseline", rotate=90) => @PLACE(413.3, -153);
//   %wire_5739 @TEXT("GND", size=1, halign="middle", valign="baseline", rotate=90) => @PLACE(233.3, -214);
//   %wire_5601 @TEXT("GND", size=1, halign="middle", valign="baseline", rotate=90) => @PLACE(149.3, -459);
//   %wire_5647 @TEXT("GND", size=1, halign="middle", valign="baseline", rotate=90) => @PLACE(377.3, -599);
//   %wire_5903 @TEXT("GND", size=1, halign="middle", valign="baseline", rotate=90) => @PLACE(377.3, -249);
//   %wire_5904 @TEXT("GND", size=1, halign="middle", valign="baseline", rotate=90) => @PLACE(257.3, -74);
//   %wire_5562 @TEXT("GND", size=1, halign="middle", valign="baseline", rotate=90) => @PLACE(-55.7, -598);
//   %wire_5871 @TEXT("GND", size=1, halign="middle", valign="baseline", rotate=90) => @PLACE(257.3, -214);
//   %wire_5895 @TEXT("GND", size=1, halign="middle", valign="baseline", rotate=90) => @PLACE(197.3, -494);
//   %wire_5900 @TEXT("GND", size=1, halign="middle", valign="baseline", rotate=90) => @PLACE(63.3, -564);
//   %wire_5858 @TEXT("GND", size=1, halign="middle", valign="baseline", rotate=90) => @PLACE(63.3, -319);
//   %wire_5892 @TEXT("GND", size=1, halign="middle", valign="baseline", rotate=90) => @PLACE(87.3, -739);
//   %wire_5613 @TEXT("GND", size=1, halign="middle", valign="baseline", rotate=90) => @PLACE(197.3, -39);
//   %wire_5604 @TEXT("GND", size=1, halign="middle", valign="baseline", rotate=90) => @PLACE(305.3, -529);
//   %wire_5890 @TEXT("GND", size=1, halign="middle", valign="baseline", rotate=90) => @PLACE(257.3, -354);
//   %wire_5889 @TEXT("GND", size=1, halign="middle", valign="baseline", rotate=90) => @PLACE(197.3, -459);
//   %wire_5882 @TEXT("GND", size=1, halign="middle", valign="baseline", rotate=90) => @PLACE(305.3, -144);
//   %wire_5881 @TEXT("GND", size=1, halign="middle", valign="baseline", rotate=90) => @PLACE(281.3, -669);
//   %wire_5603 @TEXT("GND", size=1, halign="middle", valign="baseline", rotate=90) => @PLACE(281.3, -354);
//   %wire_5872 @TEXT("GND", size=1, halign="middle", valign="baseline", rotate=90) => @PLACE(413.3, -258);
//   %wire_5880 @TEXT("GND", size=1, halign="middle", valign="baseline", rotate=90) => @PLACE(63.3, -354);
//   %wire_5820 @TEXT("GND", size=1, halign="middle", valign="baseline", rotate=90) => @PLACE(102.3, -450);
//   %wire_5958 @TEXT("GND", size=1, halign="middle", valign="baseline", rotate=90) => @PLACE(305.3, -669);
//   %wire_5868 @TEXT("GND", size=1, halign="middle", valign="baseline", rotate=90) => @PLACE(102.3, -170);
//   %wire_5876 @TEXT("GND", size=1, halign="middle", valign="baseline", rotate=90) => @PLACE(-44.7, -248);
//   %wire_5433 @TEXT("GND", size=1, halign="middle", valign="baseline", rotate=90) => @PLACE(106.3, -778);
//   %wire_5787 @TEXT("GND", size=1, halign="middle", valign="baseline", rotate=90) => @PLACE(-55.7, -213);
//   %wire_5866 @TEXT("GND", size=1, halign="middle", valign="baseline", rotate=90) => @PLACE(87.3, -74);
//   %wire_5851 @TEXT("GND", size=1, halign="middle", valign="baseline", rotate=90) => @PLACE(305.3, -564);
//   %wire_5696 @TEXT("GND", size=1, halign="middle", valign="baseline", rotate=90) => @PLACE(-55.7, -143);
//   %wire_5694 @TEXT("GND", size=1, halign="middle", valign="baseline", rotate=90) => @PLACE(401.3, -249);
//   %wire_5830 @TEXT("GND", size=1, halign="middle", valign="baseline", rotate=90) => @PLACE(281.3, -249);
//   %wire_5673 @TEXT("GND", size=1, halign="middle", valign="baseline") => @PLACE(-10, -169.3);
//   %wire_5661 @TEXT("GND", size=1, halign="middle", valign="baseline", rotate=90) => @PLACE(149.3, -739);
//   %wire_5837 @TEXT("GND", size=1, halign="middle", valign="baseline", rotate=90) => @PLACE(149.3, -564);
//   %wire_5614 @TEXT("GND", size=1, halign="middle", valign="baseline", rotate=90) => @PLACE(257.3, -249);
//   %wire_5906 @TEXT("GND", size=1, halign="middle", valign="baseline", rotate=90) => @PLACE(233.3, -249);
//   %wire_5850 @TEXT("GND", size=1, halign="middle", valign="baseline", rotate=90) => @PLACE(125.3, -564);
//   %wire_5864 @TEXT("GND", size=1, halign="middle", valign="baseline", rotate=90) => @PLACE(413.3, -538);
//   %wire_5956 @TEXT("GND", size=1, halign="middle", valign="baseline", rotate=90) => @PLACE(15.3, -529);
//   %wire_5686 @TEXT("GND", size=1, halign="middle", valign="baseline", rotate=90) => @PLACE(39.3, -599);
//   %wire_5861 @TEXT("GND", size=1, halign="middle", valign="baseline", rotate=90) => @PLACE(353.3, -389);
//   %wire_5543 @TEXT("GND", size=1, halign="middle", valign="baseline", rotate=90) => @PLACE(87.3, -319);
//   %wire_5862 @TEXT("GND", size=1, halign="middle", valign="baseline", rotate=90) => @PLACE(233.3, -74);
//   %wire_5825 @TEXT("GND", size=1, halign="middle", valign="baseline", rotate=90) => @PLACE(39.3, -319);
//   %wire_5652 @TEXT("GND", size=1, halign="middle", valign="baseline", rotate=90) => @PLACE(63.3, -459);
//   %wire_5595 @TEXT("GND", size=1, halign="middle", valign="baseline", rotate=90) => @PLACE(-55.7, -248);
//   %wire_5845 @TEXT("GND", size=1, halign="middle", valign="baseline", rotate=90) => @PLACE(173.3, -599);
//   %wire_5674 @TEXT("GND", size=1, halign="middle", valign="baseline", rotate=90) => @PLACE(233.3, -599);
//   %wire_5873 @TEXT("GND", size=1, halign="middle", valign="baseline", rotate=90) => @PLACE(15.3, -319);
//   %wire_5852 @TEXT("GND", size=1, halign="middle", valign="baseline", rotate=90) => @PLACE(149.3, -319);
//   %wire_5841 @TEXT("GND", size=1, halign="middle", valign="baseline") => @PLACE(-10, -449.3);
//   %wire_5833 @TEXT("GND", size=1, halign="middle", valign="baseline", rotate=90) => @PLACE(305.3, -249);
//   %wire_5843 @TEXT("GND", size=1, halign="middle", valign="baseline", rotate=90) => @PLACE(-32.7, -38);
//   %wire_5809 @TEXT("GND", size=1, halign="middle", valign="baseline", rotate=90) => @PLACE(15.3, -599);
//   %wire_5856 @TEXT("GND", size=1, halign="middle", valign="baseline", rotate=90) => @PLACE(197.3, -564);
//   %wire_5863 @TEXT("GND", size=1, halign="middle", valign="baseline", rotate=90) => @PLACE(233.3, -564);
//   %wire_5838 @TEXT("GND", size=1, halign="middle", valign="baseline", rotate=90) => @PLACE(413.3, -83);
//   %wire_5840 @TEXT("GND", size=1, halign="middle", valign="baseline", rotate=90) => @PLACE(15.3, -74);
//   %wire_5831 @TEXT("GND", size=1, halign="middle", valign="baseline", rotate=90) => @PLACE(125.3, -319);
//   %wire_5847 @TEXT("GND", size=1, halign="middle", valign="baseline", rotate=90) => @PLACE(149.3, -669);
//   %wire_5678 @TEXT("GND", size=1, halign="middle", valign="baseline", rotate=90) => @PLACE(377.3, -319);
//   %wire_5832 @TEXT("GND", size=1, halign="middle", valign="baseline", rotate=90) => @PLACE(401.3, -39);
//   %wire_5844 @TEXT("GND", size=1, halign="middle", valign="baseline", rotate=90) => @PLACE(257.3, -564);
//   %wire_5819 @TEXT("GND", size=1, halign="middle", valign="baseline", rotate=90) => @PLACE(39.3, -494);
//   %wire_5870 @TEXT("GND", size=1, halign="middle", valign="baseline", rotate=90) => @PLACE(102.3, -415);
//   %wire_5670 @TEXT("GND", size=1, halign="middle", valign="baseline", rotate=90) => @PLACE(413.3, -363);
//   %wire_5919 @TEXT("GND", size=1, halign="middle", valign="baseline", rotate=90) => @PLACE(173.3, -669);
//   %wire_5891 @TEXT("GND", size=1, halign="middle", valign="baseline", rotate=90) => @PLACE(-44.7, -528);
//   %wire_5883 @TEXT("GND", size=1, halign="middle", valign="baseline", rotate=90) => @PLACE(-44.7, -563);
//   %wire_5859 @TEXT("GND", size=1, halign="middle", valign="baseline", rotate=90) => @PLACE(173.3, -564);
//   %wire_5569 @TEXT("GND", size=1, halign="middle", valign="baseline", rotate=90) => @PLACE(39.3, -669);
//   %wire_5790 @TEXT("GND", size=1, halign="middle", valign="baseline", rotate=90) => @PLACE(329.3, -459);
//   %wire_5808 @TEXT("GND", size=1, halign="middle", valign="baseline", rotate=90) => @PLACE(401.3, -529);
//   %wire_5566 @TEXT("GND", size=1, halign="middle", valign="baseline", rotate=90) => @PLACE(377.3, -144);
//   %wire_5901 @TEXT("GND", size=1, halign="middle", valign="baseline", rotate=90) => @PLACE(102.3, -590);
//   %wire_5869 @TEXT("GND", size=1, halign="middle", valign="baseline", rotate=90) => @PLACE(87.3, -424);
//   %wire_5879 @TEXT("GND", size=1, halign="middle", valign="baseline", rotate=90) => @PLACE(15.3, -739);
//   %wire_5944 @TEXT("GND", size=1, halign="middle", valign="baseline", rotate=90) => @PLACE(377.3, -39);
//   %wire_5598 @TEXT("GND", size=1, halign="middle", valign="baseline") => @PLACE(-10, -309.3);
//   %wire_5573 @TEXT("GND", size=1, halign="middle", valign="baseline", rotate=90) => @PLACE(63.3, -669);
//   %wire_5606 @TEXT("GND", size=1, halign="middle", valign="baseline", rotate=90) => @PLACE(149.3, -284);
//   %wire_5754 @TEXT("GND", size=1, halign="middle", valign="baseline", rotate=90) => @PLACE(233.3, -529);
//   %wire_5834 @TEXT("GND", size=1, halign="middle", valign="baseline", rotate=90) => @PLACE(102.3, -520);
//   %wire_5736 @TEXT("GND", size=1, halign="middle", valign="baseline", rotate=90) => @PLACE(197.3, -214);
//   %wire_5817 @TEXT("GND", size=1, halign="middle", valign="baseline", rotate=90) => @PLACE(329.3, -354);
//   %wire_5693 @TEXT("GND", size=1, halign="middle", valign="baseline", rotate=90) => @PLACE(377.3, -529);
//   %wire_5816 @TEXT("GND", size=1, halign="middle", valign="baseline", rotate=90) => @PLACE(125.3, -39);
//   %wire_5813 @TEXT("GND", size=1, halign="middle", valign="baseline", rotate=90) => @PLACE(353.3, -739);
//   %wire_5570 @TEXT("GND", size=1, halign="middle", valign="baseline", rotate=90) => @PLACE(377.3, -214);
//   %wire_5812 @TEXT("GND", size=1, halign="middle", valign="baseline", rotate=90) => @PLACE(401.3, -494);
//   %wire_5846 @TEXT("GND", size=1, halign="middle", valign="baseline", rotate=90) => @PLACE(233.3, -494);
//   %wire_5794 @TEXT("GND", size=1, halign="middle", valign="baseline", rotate=90) => @PLACE(-55.7, -283);
//   %wire_5688 @TEXT("GND", size=1, halign="middle", valign="baseline", rotate=90) => @PLACE(377.3, -4);
//   %wire_5666 @TEXT("GND", size=1, halign="middle", valign="baseline", rotate=90) => @PLACE(87.3, -39);
//   %wire_5836 @TEXT("GND", size=1, halign="middle", valign="baseline", rotate=90) => @PLACE(281.3, -564);
//   %wire_5745 @TEXT("GND", size=1, halign="middle", valign="baseline", rotate=90) => @PLACE(233.3, -389);
//   %wire_5805 @TEXT("GND", size=1, halign="middle", valign="baseline", rotate=90) => @PLACE(377.3, -459);
//   %wire_5597 @TEXT("GND", size=1, halign="middle", valign="baseline", rotate=90) => @PLACE(305.3, -319);
//   %wire_5801 @TEXT("GND", size=1, halign="middle", valign="baseline", rotate=90) => @PLACE(63.3, -494);
//   %wire_5815 @TEXT("GND", size=1, halign="middle", valign="baseline", rotate=90) => @PLACE(125.3, -389);
//   %wire_5800 @TEXT("GND", size=1, halign="middle", valign="baseline", rotate=90) => @PLACE(87.3, -564);
//   %wire_5937 @TEXT("GND", size=1, halign="middle", valign="baseline", rotate=90) => @PLACE(281.3, -319);
//   %wire_5596 @TEXT("GND", size=1, halign="middle", valign="baseline", rotate=90) => @PLACE(15.3, -389);
//   %wire_5807 @TEXT("GND", size=1, halign="middle", valign="baseline", rotate=90) => @PLACE(281.3, -389);
//   %wire_5656 @TEXT("GND", size=1, halign="middle", valign="baseline", rotate=90) => @PLACE(15.3, -564);
//   %wire_5747 @TEXT("GND", size=1, halign="middle", valign="baseline", rotate=90) => @PLACE(39.3, -389);
//   %wire_5779 @TEXT("GND", size=1, halign="middle", valign="baseline", rotate=90) => @PLACE(-55.7, 32);
//   %wire_5795 @TEXT("GND", size=1, halign="middle", valign="baseline", rotate=90) => @PLACE(401.3, -424);
//   %wire_5951 @TEXT("GND", size=1, halign="middle", valign="baseline", rotate=90) => @PLACE(210.3, -695);
//   %wire_5798 @TEXT("GND", size=1, halign="middle", valign="baseline", rotate=90) => @PLACE(15.3, -494);
//   %wire_5797 @TEXT("GND", size=1, halign="middle", valign="baseline", rotate=90) => @PLACE(125.3, -494);
//   %wire_5592 @TEXT("GND", size=1, halign="middle", valign="baseline", rotate=90) => @PLACE(413.3, -678);
//   %wire_5803 @TEXT("GND", size=1, halign="middle", valign="baseline", rotate=90) => @PLACE(87.3, -389);
//   %wire_5796 @TEXT("GND", size=1, halign="middle", valign="baseline", rotate=90) => @PLACE(125.3, -529);
//   %wire_5788 @TEXT("GND", size=1, halign="middle", valign="baseline", rotate=90) => @PLACE(233.3, -354);
//   %wire_5789 @TEXT("GND", size=1, halign="middle", valign="baseline", rotate=90) => @PLACE(377.3, -424);
//   %wire_5602 @TEXT("GND", size=1, halign="middle", valign="baseline", rotate=90) => @PLACE(-55.7, -318);
//   %wire_5768 @TEXT("GND", size=1, halign="middle", valign="baseline", rotate=90) => @PLACE(39.3, -284);
//   %wire_5648 @TEXT("GND", size=1, halign="middle", valign="baseline", rotate=90) => @PLACE(329.3, -599);
//   %wire_5765 @TEXT("GND", size=1, halign="middle", valign="baseline", rotate=90) => @PLACE(257.3, -284);
//   %wire_5579 @TEXT("GND", size=1, halign="middle", valign="baseline", rotate=90) => @PLACE(125.3, -599);
//   %wire_5766 @TEXT("GND", size=1, halign="middle", valign="baseline", rotate=90) => @PLACE(233.3, -284);
//   %wire_5781 @TEXT("GND", size=1, halign="middle", valign="baseline", rotate=90) => @PLACE(413.3, -608);
//   %wire_5780 @TEXT("GND", size=1, halign="middle", valign="baseline", rotate=90) => @PLACE(257.3, -424);
//   %wire_5777 @TEXT("GND", size=1, halign="middle", valign="baseline", rotate=90) => @PLACE(173.3, -459);
//   %wire_5776 @TEXT("GND", size=1, halign="middle", valign="baseline", rotate=90) => @PLACE(233.3, -459);
//   %wire_5750 @TEXT("GND", size=1, halign="middle", valign="baseline", rotate=90) => @PLACE(63.3, -529);
//   %wire_5744 @TEXT("GND", size=1, halign="middle", valign="baseline", rotate=90) => @PLACE(233.3, -144);
//   %wire_5887 @TEXT("GND", size=1, halign="middle", valign="baseline", rotate=90) => @PLACE(102.3, -30);
//   %wire_5774 @TEXT("GND", size=1, halign="middle", valign="baseline", rotate=90) => @PLACE(125.3, -669);
//   %wire_5773 @TEXT("GND", size=1, halign="middle", valign="baseline", rotate=90) => @PLACE(329.3, -74);
//   %wire_5650 @TEXT("GND", size=1, halign="middle", valign="baseline", rotate=90) => @PLACE(173.3, -529);
//   %wire_5772 @TEXT("GND", size=1, halign="middle", valign="baseline", rotate=90) => @PLACE(197.3, -354);
//   %wire_5771 @TEXT("GND", size=1, halign="middle", valign="baseline", rotate=90) => @PLACE(149.3, -39);
//   %wire_5770 @TEXT("GND", size=1, halign="middle", valign="baseline", rotate=90) => @PLACE(63.3, -4);
//   %wire_5719 @TEXT("GND", size=1, halign="middle", valign="baseline", rotate=90) => @PLACE(15.3, -39);
//   %wire_5764 @TEXT("GND", size=1, halign="middle", valign="baseline", rotate=90) => @PLACE(87.3, -284);
//   %wire_5767 @TEXT("GND", size=1, halign="middle", valign="baseline", rotate=90) => @PLACE(197.3, -284);
//   %wire_5762 @TEXT("GND", size=1, halign="middle", valign="baseline", rotate=90) => @PLACE(353.3, -599);
//   %wire_5741 @TEXT("GND", size=1, halign="middle", valign="baseline", rotate=90) => @PLACE(63.3, -39);
//   %wire_5728 @TEXT("GND", size=1, halign="middle", valign="baseline", rotate=90) => @PLACE(102.3, -380);
//   %wire_5760 @TEXT("GND", size=1, halign="middle", valign="baseline", rotate=90) => @PLACE(329.3, -214);
//   %wire_5520 @TEXT("GND", size=1, halign="middle", valign="baseline", rotate=90) => @PLACE(-44.7, 67);
//   %wire_5593 @TEXT("GND", size=1, halign="middle", valign="baseline", rotate=90) => @PLACE(102.3, -730);
//   %wire_5757 @TEXT("GND", size=1, halign="middle", valign="baseline", rotate=90) => @PLACE(173.3, -214);
//   %wire_5738 @TEXT("GND", size=1, halign="middle", valign="baseline", rotate=90) => @PLACE(377.3, -669);
//   %wire_5737 @TEXT("GND", size=1, halign="middle", valign="baseline", rotate=90) => @PLACE(257.3, -669);
//   %wire_5681 @TEXT("GND", size=1, halign="middle", valign="baseline", rotate=90) => @PLACE(305.3, -389);
//   %wire_5752 @TEXT("GND", size=1, halign="middle", valign="baseline", rotate=90) => @PLACE(149.3, -214);
//   %wire_5481 @TEXT("GND", size=1, halign="middle", valign="baseline", rotate=90) => @PLACE(214.3, -778);
//   %wire_5751 @TEXT("GND", size=1, halign="middle", valign="baseline", rotate=90) => @PLACE(63.3, -739);
//   %wire_5607 @TEXT("GND", size=1, halign="middle", valign="baseline", rotate=90) => @PLACE(63.3, -284);
//   %wire_5627 @TEXT("GND", size=1, halign="middle", valign="baseline", rotate=90) => @PLACE(197.3, -599);
//   %wire_5645 @TEXT("GND", size=1, halign="middle", valign="baseline", rotate=90) => @PLACE(-32.7, -423);
//   %wire_5821 @TEXT("GND", size=1, halign="middle", valign="baseline", rotate=90) => @PLACE(63.3, -389);
//   %wire_5655 @TEXT("GND", size=1, halign="middle", valign="baseline", rotate=90) => @PLACE(401.3, -319);
//   %wire_5740 @TEXT("GND", size=1, halign="middle", valign="baseline", rotate=90) => @PLACE(197.3, -144);
//   %wire_5763 @TEXT("GND", size=1, halign="middle", valign="baseline", rotate=90) => @PLACE(257.3, -39);
//   %wire_5732 @TEXT("GND", size=1, halign="middle", valign="baseline", rotate=90) => @PLACE(413.3, -48);
//   %wire_5722 @TEXT("GND", size=1, halign="middle", valign="baseline", rotate=90) => @PLACE(-55.7, -493);
//   %wire_5733 @TEXT("GND", size=1, halign="middle", valign="baseline", rotate=90) => @PLACE(102.3, -485);
//   %wire_5818 @TEXT("GND", size=1, halign="middle", valign="baseline", rotate=90) => @PLACE(401.3, -739);
//   %wire_5761 @TEXT("GND", size=1, halign="middle", valign="baseline", rotate=90) => @PLACE(257.3, -144);
//   %wire_5886 @TEXT("GND", size=1, halign="middle", valign="baseline", rotate=90) => @PLACE(102.3, -100);
//   %wire_5727 @TEXT("GND", size=1, halign="middle", valign="baseline", rotate=90) => @PLACE(353.3, -74);
//   %wire_5608 @TEXT("GND", size=1, halign="middle", valign="baseline", rotate=90) => @PLACE(281.3, -74);
//   %wire_5630 @TEXT("GND", size=1, halign="middle", valign="baseline", rotate=90) => @PLACE(413.3, -223);
//   %wire_5724 @TEXT("GND", size=1, halign="middle", valign="baseline", rotate=90) => @PLACE(-55.7, -528);
//   %wire_5631 @TEXT("GND", size=1, halign="middle", valign="baseline", rotate=90) => @PLACE(305.3, -74);
//   %wire_5723 @TEXT("GND", size=1, halign="middle", valign="baseline", rotate=90) => @PLACE(173.3, -74);
//   %wire_5640 @TEXT("GND", size=1, halign="middle", valign="baseline", rotate=90) => @PLACE(102.3, -310);
//   %wire_5716 @TEXT("GND", size=1, halign="middle", valign="baseline", rotate=90) => @PLACE(281.3, -39);
//   %wire_5721 @TEXT("GND", size=1, halign="middle", valign="baseline", rotate=90) => @PLACE(329.3, -424);
//   %wire_5720 @TEXT("GND", size=1, halign="middle", valign="baseline", rotate=90) => @PLACE(-55.7, -38);
//   %wire_5931 @TEXT("GND", size=1, halign="middle", valign="baseline", rotate=90) => @PLACE(305.3, -459);
//   %wire_5717 @TEXT("GND", size=1, halign="middle", valign="baseline", rotate=90) => @PLACE(-44.7, -458);
//   %wire_5715 @TEXT("GND", size=1, halign="middle", valign="baseline", rotate=90) => @PLACE(39.3, -4);
//   %wire_5638 @TEXT("GND", size=1, halign="middle", valign="baseline", rotate=90) => @PLACE(401.3, -4);
//   %wire_5713 @TEXT("GND", size=1, halign="middle", valign="baseline", rotate=90) => @PLACE(87.3, -669);
//   %wire_5714 @TEXT("GND", size=1, halign="middle", valign="baseline", rotate=90) => @PLACE(377.3, -284);
//   %wire_5718 @TEXT("GND", size=1, halign="middle", valign="baseline", rotate=90) => @PLACE(-44.7, -493);
//   %wire_5704 @TEXT("GND", size=1, halign="middle", valign="baseline", rotate=90) => @PLACE(102.3, -240);
//   %wire_5731 @TEXT("GND", size=1, halign="middle", valign="baseline", rotate=90) => @PLACE(-55.7, -458);
//   %wire_5703 @TEXT("GND", size=1, halign="middle", valign="baseline", rotate=90) => @PLACE(149.3, -144);
//   %wire_5683 @TEXT("GND", size=1, halign="middle", valign="baseline") => @PLACE(-14, -414.3);
//   %wire_5814 @TEXT("GND", size=1, halign="middle", valign="baseline", rotate=90) => @PLACE(63.3, -599);
//   %wire_5589 @TEXT("GND", size=1, halign="middle", valign="baseline", rotate=90) => @PLACE(401.3, -459);
//   %wire_5835 @TEXT("GND", size=1, halign="middle", valign="baseline", rotate=90) => @PLACE(353.3, -319);
//   %wire_5707 @TEXT("GND", size=1, halign="middle", valign="baseline", rotate=90) => @PLACE(-32.7, -353);
//   %wire_5911 @TEXT("GND", size=1, halign="middle", valign="baseline", rotate=90) => @PLACE(281.3, -4);
//   %wire_5908 @TEXT("GND", size=1, halign="middle", valign="baseline", rotate=90) => @PLACE(413.3, -13);
//   %wire_5667 @TEXT("GND", size=1, halign="middle", valign="baseline", rotate=90) => @PLACE(-44.7, -353);
//   %wire_5705 @TEXT("GND", size=1, halign="middle", valign="baseline", rotate=90) => @PLACE(-32.7, -388);
//   %wire_5538 @TEXT("GND", size=1, halign="middle", valign="baseline", rotate=90) => @PLACE(210.3, -625);
//   %wire_5702 @TEXT("GND", size=1, halign="middle", valign="baseline", rotate=90) => @PLACE(377.3, -739);
//   %wire_5701 @TEXT("GND", size=1, halign="middle", valign="baseline", rotate=90) => @PLACE(173.3, -144);
//   %wire_5700 @TEXT("GND", size=1, halign="middle", valign="baseline", rotate=90) => @PLACE(-32.7, -283);
//   %wire_5410 @TEXT("GND", size=1, halign="middle", valign="baseline", rotate=90) => @PLACE(-44.7, -318);
//   %wire_5578 @TEXT("GND", size=1, halign="middle", valign="baseline", rotate=90) => @PLACE(149.3, -354);
//   %wire_5585 @TEXT("GND", size=1, halign="middle", valign="baseline", rotate=90) => @PLACE(173.3, -354);
//   %wire_5848 @TEXT("GND", size=1, halign="middle", valign="baseline", rotate=90) => @PLACE(329.3, -529);
//   %wire_5582 @TEXT("GND", size=1, halign="middle", valign="baseline", rotate=90) => @PLACE(401.3, -354);
//   %wire_5824 @TEXT("GND", size=1, halign="middle", valign="baseline", rotate=90) => @PLACE(63.3, -424);
//   %wire_5822 @TEXT("GND", size=1, halign="middle", valign="baseline", rotate=90) => @PLACE(125.3, -424);
//   %wire_5698 @TEXT("GND", size=1, halign="middle", valign="baseline", rotate=90) => @PLACE(377.3, -74);
//   %wire_5811 @TEXT("GND", size=1, halign="middle", valign="baseline", rotate=90) => @PLACE(173.3, -739);
//   %wire_5697 @TEXT("GND", size=1, halign="middle", valign="baseline", rotate=90) => @PLACE(353.3, -529);
//   %wire_5927 @TEXT("GND", size=1, halign="middle", valign="baseline", rotate=90) => @PLACE(305.3, -354);
//   %wire_5928 @TEXT("GND", size=1, halign="middle", valign="baseline", rotate=90) => @PLACE(281.3, -494);
//   %wire_5690 @TEXT("GND", size=1, halign="middle", valign="baseline", rotate=90) => @PLACE(149.3, -389);
//   %wire_5695 @TEXT("GND", size=1, halign="middle", valign="baseline", rotate=90) => @PLACE(39.3, -564);
//   %wire_5412 @TEXT("GND", size=1, halign="middle", valign="baseline", rotate=90) => @PLACE(-44.7, -283);
//   %wire_5692 @TEXT("GND", size=1, halign="middle", valign="baseline", rotate=90) => @PLACE(353.3, -214);
//   %wire_5660 @TEXT("GND", size=1, halign="middle", valign="baseline", rotate=90) => @PLACE(-32.7, -318);
//   %wire_5691 @TEXT("GND", size=1, halign="middle", valign="baseline", rotate=90) => @PLACE(329.3, -39);
//   %wire_5689 @TEXT("GND", size=1, halign="middle", valign="baseline", rotate=90) => @PLACE(353.3, -354);
//   %wire_5687 @TEXT("GND", size=1, halign="middle", valign="baseline", rotate=90) => @PLACE(329.3, -4);
//   %wire_5712 @TEXT("GND", size=1, halign="middle", valign="baseline", rotate=90) => @PLACE(233.3, -4);
//   %wire_5679 @TEXT("GND", size=1, halign="middle", valign="baseline", rotate=90) => @PLACE(-32.7, -248);
//   %wire_5575 @TEXT("GND", size=1, halign="middle", valign="baseline", rotate=90) => @PLACE(257.3, -389);
//   %wire_5682 @TEXT("GND", size=1, halign="middle", valign="baseline") => @PLACE(-10, -379.3);
//   %wire_5677 @TEXT("GND", size=1, halign="middle", valign="baseline", rotate=90) => @PLACE(-32.7, -178);
//   %wire_5699 @TEXT("GND", size=1, halign="middle", valign="baseline", rotate=90) => @PLACE(-32.7, -213);
//   %wire_5784 @TEXT("GND", size=1, halign="middle", valign="baseline", rotate=90) => @PLACE(-55.7, 67);
//   %wire_5775 @TEXT("GND", size=1, halign="middle", valign="baseline", rotate=90) => @PLACE(353.3, -669);
//   %wire_5676 @TEXT("GND", size=1, halign="middle", valign="baseline", rotate=90) => @PLACE(39.3, -424);
//   %wire_5675 @TEXT("GND", size=1, halign="middle", valign="baseline", rotate=90) => @PLACE(413.3, -398);
//   %wire_5857 @TEXT("GND", size=1, halign="middle", valign="baseline", rotate=90) => @PLACE(413.3, -468);
//   %wire_5710 @TEXT("GND", size=1, halign="middle", valign="baseline", rotate=90) => @PLACE(87.3, -144);
//   %wire_5672 @TEXT("GND", size=1, halign="middle", valign="baseline", rotate=90) => @PLACE(102.3, -65);
//   %wire_5671 @TEXT("GND", size=1, halign="middle", valign="baseline", rotate=90) => @PLACE(353.3, -249);
//   %wire_5668 @TEXT("GND", size=1, halign="middle", valign="baseline", rotate=90) => @PLACE(149.3, -424);
//   %wire_5909 @TEXT("GND", size=1, halign="middle", valign="baseline", rotate=90) => @PLACE(39.3, -739);
//   %wire_5734 @TEXT("GND", size=1, halign="middle", valign="baseline", rotate=90) => @PLACE(-44.7, -598);
//   %wire_5706 @TEXT("GND", size=1, halign="middle", valign="baseline", rotate=90) => @PLACE(173.3, -424);
//   %wire_5729 @TEXT("GND", size=1, halign="middle", valign="baseline", rotate=90) => @PLACE(-55.7, -423);
//   %wire_5409 @TEXT("GND", size=1, halign="middle", valign="baseline") => @PLACE(-10, -99.3);
//   %wire_5665 @TEXT("GND", size=1, halign="middle", valign="baseline", rotate=90) => @PLACE(401.3, -599);
//   %wire_5885 @TEXT("GND", size=1, halign="middle", valign="baseline", rotate=90) => @PLACE(125.3, -739);
//   %wire_5664 @TEXT("GND", size=1, halign="middle", valign="baseline", rotate=90) => @PLACE(281.3, -424);
//   %wire_5662 @TEXT("GND", size=1, halign="middle", valign="baseline", rotate=90) => @PLACE(329.3, -284);
//   %wire_5663 @TEXT("GND", size=1, halign="middle", valign="baseline", rotate=90) => @PLACE(-44.7, -388);
//   %wire_5709 @TEXT("GND", size=1, halign="middle", valign="baseline", rotate=90) => @PLACE(102.3, -660);
//   %wire_5829 @TEXT("GND", size=1, halign="middle", valign="baseline", rotate=90) => @PLACE(353.3, -284);
//   %wire_5659 @TEXT("GND", size=1, halign="middle", valign="baseline", rotate=90) => @PLACE(173.3, -389);
//   %wire_5860 @TEXT("GND", size=1, halign="middle", valign="baseline", rotate=90) => @PLACE(305.3, -424);
//   %wire_5657 @TEXT("GND", size=1, halign="middle", valign="baseline", rotate=90) => @PLACE(305.3, -494);
//   %wire_5893 @TEXT("GND", size=1, halign="middle", valign="baseline", rotate=90) => @PLACE(377.3, -494);
//   %wire_5932 @TEXT("GND", size=1, halign="middle", valign="baseline", rotate=90) => @PLACE(257.3, -319);
//   %wire_5653 @TEXT("GND", size=1, halign="middle", valign="baseline", rotate=90) => @PLACE(233.3, -424);
//   %wire_5865 @TEXT("GND", size=1, halign="middle", valign="baseline", rotate=90) => @PLACE(257.3, -459);
//   %wire_5654 @TEXT("GND", size=1, halign="middle", valign="baseline", rotate=90) => @PLACE(329.3, -389);
//   %wire_5867 @TEXT("GND", size=1, halign="middle", valign="baseline", rotate=90) => @PLACE(197.3, -424);
//   %wire_5651 @TEXT("GND", size=1, halign="middle", valign="baseline", rotate=90) => @PLACE(401.3, -284);
//   %wire_5646 @TEXT("GND", size=1, halign="middle", valign="baseline", rotate=90) => @PLACE(15.3, -669);
//   %wire_5855 @TEXT("GND", size=1, halign="middle", valign="baseline", rotate=90) => @PLACE(173.3, -284);
//   %wire_5854 @TEXT("GND", size=1, halign="middle", valign="baseline", rotate=90) => @PLACE(281.3, -284);
//   %wire_5853 @TEXT("GND", size=1, halign="middle", valign="baseline", rotate=90) => @PLACE(305.3, -284);
//   %wire_5842 @TEXT("GND", size=1, halign="middle", valign="baseline", rotate=90) => @PLACE(-32.7, -458);
//   %wire_5642 @TEXT("GND", size=1, halign="middle", valign="baseline", rotate=90) => @PLACE(-44.7, -423);
//   %wire_5644 @TEXT("GND", size=1, halign="middle", valign="baseline", rotate=90) => @PLACE(125.3, -144);
//   %wire_5643 @TEXT("GND", size=1, halign="middle", valign="baseline", rotate=90) => @PLACE(233.3, -739);
//   %wire_5637 @TEXT("GND", size=1, halign="middle", valign="baseline", rotate=90) => @PLACE(176.3, -756);
//   %wire_5635 @TEXT("GND", size=1, halign="middle", valign="baseline", rotate=90) => @PLACE(233.3, -39);
//   %wire_5826 @TEXT("GND", size=1, halign="middle", valign="baseline", rotate=90) => @PLACE(353.3, -4);
//   %wire_5634 @TEXT("GND", size=1, halign="middle", valign="baseline", rotate=90) => @PLACE(353.3, -144);
//   %wire_5633 @TEXT("GND", size=1, halign="middle", valign="baseline", rotate=90) => @PLACE(15.3, -4);
//   %wire_5636 @TEXT("GND", size=1, halign="middle", valign="baseline", rotate=90) => @PLACE(-32.7, -528);
//   %wire_5735 @TEXT("GND", size=1, halign="middle", valign="baseline", rotate=90) => @PLACE(281.3, -144);
//   %wire_5501 @TEXT("GND", size=1, halign="middle", valign="baseline", rotate=90) => @PLACE(5.3, -739);
//   %wire_5497 @TEXT("GND", size=1, halign="middle", valign="baseline", rotate=90) => @PLACE(102.3, -135);
//   %wire_5628 @TEXT("GND", size=1, halign="middle", valign="baseline", rotate=90) => @PLACE(7.3, -756);
//   %wire_5874 @TEXT("GND", size=1, halign="middle", valign="baseline", rotate=90) => @PLACE(125.3, -214);
//   %wire_5568 @TEXT("GND", size=1, halign="middle", valign="baseline", rotate=90) => @PLACE(233.3, -669);
//   %wire_5778 @TEXT("GND", size=1, halign="middle", valign="baseline", rotate=90) => @PLACE(281.3, -214);
//   %wire_5792 @TEXT("GND", size=1, halign="middle", valign="baseline", rotate=90) => @PLACE(15.3, -354);
//   %wire_5804 @TEXT("GND", size=1, halign="middle", valign="baseline", rotate=90) => @PLACE(173.3, -494);
//   %wire_5877 @TEXT("GND", size=1, halign="middle", valign="baseline", rotate=90) => @PLACE(197.3, -389);
//   %wire_5783 @TEXT("GND", size=1, halign="middle", valign="baseline", rotate=90) => @PLACE(197.3, -739);
//   %wire_5625 @TEXT("GND", size=1, halign="middle", valign="baseline", rotate=90) => @PLACE(353.3, -424);
//   %wire_5621 @TEXT("GND", size=1, halign="middle", valign="baseline", rotate=90) => @PLACE(401.3, -74);
//   %wire_5620 @TEXT("GND", size=1, halign="middle", valign="baseline", rotate=90) => @PLACE(353.3, -39);
//   %wire_5615 @TEXT("GND", size=1, halign="middle", valign="baseline", rotate=90) => @PLACE(197.3, -4);
//   %wire_5617 @TEXT("GND", size=1, halign="middle", valign="baseline", rotate=90) => @PLACE(87.3, -4);
//   %wire_5612 @TEXT("GND", size=1, halign="middle", valign="baseline", rotate=90) => @PLACE(-55.7, -3);
//   %wire_5611 @TEXT("GND", size=1, halign="middle", valign="baseline", rotate=90) => @PLACE(-32.7, -3);
//   %wire_5610 @TEXT("GND", size=1, halign="middle", valign="baseline", rotate=90) => @PLACE(-44.7, -3);
//   %wire_5609 @TEXT("GND", size=1, halign="middle", valign="baseline", rotate=90) => @PLACE(-44.7, -38);
//   %wire_5913 @TEXT("GND", size=1, halign="middle", valign="baseline", rotate=90) => @PLACE(197.3, -669);
//   %wire_5574 @TEXT("GND", size=1, halign="middle", valign="baseline", rotate=90) => @PLACE(79.3, -756);
//   %wire_5629 @TEXT("GND", size=1, halign="middle", valign="baseline", rotate=90) => @PLACE(305.3, -214);
//   %wire_5782 @TEXT("GND", size=1, halign="middle", valign="baseline", rotate=90) => @PLACE(305.3, -599);
//   %wire_5759 @TEXT("GND", size=1, halign="middle", valign="baseline", rotate=90) => @PLACE(15.3, -284);
//   %wire_5758 @TEXT("GND", size=1, halign="middle", valign="baseline", rotate=90) => @PLACE(149.3, -599);
//   %wire_5793 @TEXT("GND", size=1, halign="middle", valign="baseline", rotate=90) => @PLACE(39.3, -529);
//   %wire_5605 @TEXT("GND", size=1, halign="middle", valign="baseline", rotate=90) => @PLACE(415.3, -781);
//   %wire_5755 @TEXT("GND", size=1, halign="middle", valign="baseline", rotate=90) => @PLACE(281.3, -529);
//   %wire_5753 @TEXT("GND", size=1, halign="middle", valign="baseline", rotate=90) => @PLACE(39.3, -459);
//   %wire_5626 @TEXT("GND", size=1, halign="middle", valign="baseline", rotate=90) => @PLACE(257.3, -494);
//   %wire_5748 @TEXT("GND", size=1, halign="middle", valign="baseline", rotate=90) => @PLACE(87.3, -494);
//   %wire_5746 @TEXT("GND", size=1, halign="middle", valign="baseline", rotate=90) => @PLACE(149.3, -494);
//   %wire_5616 @TEXT("GND", size=1, halign="middle", valign="baseline", rotate=90) => @PLACE(125.3, -4);
//   %wire_5618 @TEXT("GND", size=1, halign="middle", valign="baseline", rotate=90) => @PLACE(173.3, -4);
//   %wire_5619 @TEXT("GND", size=1, halign="middle", valign="baseline", rotate=90) => @PLACE(149.3, -4);
//   %wire_5622 @TEXT("GND", size=1, halign="middle", valign="baseline", rotate=90) => @PLACE(102.3, -555);
//   %wire_5591 @TEXT("GND", size=1, halign="middle", valign="baseline", rotate=90) => @PLACE(125.3, -284);
//   %wire_5756 @TEXT("GND", size=1, halign="middle", valign="baseline", rotate=90) => @PLACE(401.3, -669);
//   %wire_5590 @TEXT("GND", size=1, halign="middle", valign="baseline", rotate=90) => @PLACE(149.3, -529);
//   %wire_5588 @TEXT("GND", size=1, halign="middle", valign="baseline", rotate=90) => @PLACE(125.3, -354);
//   %wire_5586 @TEXT("GND", size=1, halign="middle", valign="baseline", rotate=90) => @PLACE(31.3, -756);
//   %wire_5584 @TEXT("GND", size=1, halign="middle", valign="baseline", rotate=90) => @PLACE(102.3, 5);
//   %wire_5583 @TEXT("GND", size=1, halign="middle", valign="baseline", rotate=90) => @PLACE(15.3, -424);
//   %wire_5587 @TEXT("GND", size=1, halign="middle", valign="baseline", rotate=90) => @PLACE(87.3, -354);
//   %wire_5594 @TEXT("GND", size=1, halign="middle", valign="baseline", rotate=90) => @PLACE(55.3, -756);
//   %wire_5923 @TEXT("GND", size=1, halign="middle", valign="baseline", rotate=90) => @PLACE(377.3, -354);
//   %wire_5786 @TEXT("GND", size=1, halign="middle", valign="baseline", rotate=90) => @PLACE(353.3, -459);
//   %wire_5849 @TEXT("GND", size=1, halign="middle", valign="baseline", rotate=90) => @PLACE(39.3, -74);
//   %wire_5581 @TEXT("GND", size=1, halign="middle", valign="baseline", rotate=90) => @PLACE(305.3, -39);
//   %wire_5897 @TEXT("GND", size=1, halign="middle", valign="baseline", rotate=90) => @PLACE(257.3, -529);
//   %wire_5572 @TEXT("GND", size=1, halign="middle", valign="baseline") => @PLACE(-14, -344.3);
//   %wire_5571 @TEXT("GND", size=1, halign="middle", valign="baseline", rotate=90) => @PLACE(257.3, -599);
//   %wire_5577 @TEXT("GND", size=1, halign="middle", valign="baseline", rotate=90) => @PLACE(39.3, -144);
//   %wire_5565 @TEXT("GND", size=1, halign="middle", valign="baseline", rotate=90) => @PLACE(63.3, -144);
//   %wire_5785 @TEXT("GND", size=1, halign="middle", valign="baseline", rotate=90) => @PLACE(413.3, -748);
//   %wire_5878 @TEXT("GND", size=1, halign="middle", valign="baseline", rotate=90) => @PLACE(125.3, -74);
//   %wire_5839 @TEXT("GND", size=1, halign="middle", valign="baseline", rotate=90) => @PLACE(305.3, -4);
//   %wire_5560 @TEXT("GND", size=1, halign="middle", valign="baseline", rotate=90) => @PLACE(173.3, -249);
//   %wire_5561 @TEXT("GND", size=1, halign="middle", valign="baseline", rotate=90) => @PLACE(173.3, -319);
//   %wire_5559 @TEXT("GND", size=1, halign="middle", valign="baseline", rotate=90) => @PLACE(329.3, -564);
//   %wire_5557 @TEXT("GND", size=1, halign="middle", valign="baseline", rotate=90) => @PLACE(353.3, -564);
//   %wire_5558 @TEXT("GND", size=1, halign="middle", valign="baseline", rotate=90) => @PLACE(197.3, -319);
//   %wire_5555 @TEXT("GND", size=1, halign="middle", valign="baseline", rotate=90) => @PLACE(329.3, -249);
//   %wire_5554 @TEXT("GND", size=1, halign="middle", valign="baseline", rotate=90) => @PLACE(377.3, -564);
//   %wire_5556 @TEXT("GND", size=1, halign="middle", valign="baseline", rotate=90) => @PLACE(233.3, -319);
//   %wire_5806 @TEXT("GND", size=1, halign="middle", valign="baseline", rotate=90) => @PLACE(436.3, -726);
//   %wire_5553 @TEXT("GND", size=1, halign="middle", valign="baseline", rotate=90) => @PLACE(401.3, -564);
//   %wire_5552 @TEXT("GND", size=1, halign="middle", valign="baseline", rotate=90) => @PLACE(413.3, -573);
//   %wire_5551 @TEXT("GND", size=1, halign="middle", valign="baseline") => @PLACE(-14, -64.3);
//   %wire_5550 @TEXT("GND", size=1, halign="middle", valign="baseline", rotate=90) => @PLACE(-55.7, -178);
//   %wire_5549 @TEXT("GND", size=1, halign="middle", valign="baseline", rotate=90) => @PLACE(-44.7, -178);
//   %wire_5926 @TEXT("GND", size=1, halign="middle", valign="baseline", rotate=90) => @PLACE(-44.7, -143);
//   %wire_5545 @TEXT("GND", size=1, halign="middle", valign="baseline", rotate=90) => @PLACE(149.3, -179);
//   %wire_5544 @TEXT("GND", size=1, halign="middle", valign="baseline", rotate=90) => @PLACE(15.3, -634);
//   %wire_5542 @TEXT("GND", size=1, halign="middle", valign="baseline", rotate=90) => @PLACE(173.3, -179);
//   %wire_5541 @TEXT("GND", size=1, halign="middle", valign="baseline", rotate=90) => @PLACE(39.3, -634);
//   %wire_5540 @TEXT("GND", size=1, halign="middle", valign="baseline", rotate=90) => @PLACE(197.3, -179);
//   %wire_5905 @TEXT("GND", size=1, halign="middle", valign="baseline", rotate=90) => @PLACE(210.3, -660);
//   %wire_5539 @TEXT("GND", size=1, halign="middle", valign="baseline", rotate=90) => @PLACE(63.3, -634);
//   %wire_5546 @TEXT("GND", size=1, halign="middle", valign="baseline", rotate=90) => @PLACE(233.3, -179);
//   %wire_5537 @TEXT("GND", size=1, halign="middle", valign="baseline", rotate=90) => @PLACE(87.3, -634);
//   %wire_5535 @TEXT("GND", size=1, halign="middle", valign="baseline", rotate=90) => @PLACE(257.3, -179);
//   %wire_5534 @TEXT("GND", size=1, halign="middle", valign="baseline", rotate=90) => @PLACE(125.3, -634);
//   %wire_5536 @TEXT("GND", size=1, halign="middle", valign="baseline", rotate=90) => @PLACE(125.3, -179);
//   %wire_5532 @TEXT("GND", size=1, halign="middle", valign="baseline", rotate=90) => @PLACE(149.3, -634);
//   %wire_5531 @TEXT("GND", size=1, halign="middle", valign="baseline", rotate=90) => @PLACE(305.3, -179);
//   %wire_5530 @TEXT("GND", size=1, halign="middle", valign="baseline", rotate=90) => @PLACE(173.3, -634);
//   %wire_5529 @TEXT("GND", size=1, halign="middle", valign="baseline", rotate=90) => @PLACE(329.3, -179);
//   %wire_5533 @TEXT("GND", size=1, halign="middle", valign="baseline", rotate=90) => @PLACE(281.3, -179);
//   %wire_5528 @TEXT("GND", size=1, halign="middle", valign="baseline", rotate=90) => @PLACE(353.3, -179);
//   %wire_5527 @TEXT("GND", size=1, halign="middle", valign="baseline", rotate=90) => @PLACE(197.3, -634);
//   %wire_5526 @TEXT("GND", size=1, halign="middle", valign="baseline", rotate=90) => @PLACE(210.3, -730);
//   %wire_5563 @TEXT("GND", size=1, halign="middle", valign="baseline", rotate=90) => @PLACE(214.3, -789);
//   %wire_5525 @TEXT("GND", size=1, halign="middle", valign="baseline", rotate=90) => @PLACE(377.3, -179);
//   %wire_5524 @TEXT("GND", size=1, halign="middle", valign="baseline", rotate=90) => @PLACE(233.3, -634);
//   %wire_5523 @TEXT("GND", size=1, halign="middle", valign="baseline", rotate=90) => @PLACE(401.3, -179);
//   %wire_5521 @TEXT("GND", size=1, halign="middle", valign="baseline", rotate=90) => @PLACE(257.3, -634);
//   %wire_5522 @TEXT("GND", size=1, halign="middle", valign="baseline", rotate=90) => @PLACE(413.3, -188);
//   %wire_5519 @TEXT("GND", size=1, halign="middle", valign="baseline", rotate=90) => @PLACE(281.3, -634);
//   %wire_5518 @TEXT("GND", size=1, halign="middle", valign="baseline", rotate=90) => @PLACE(15.3, -249);
//   %wire_5517 @TEXT("GND", size=1, halign="middle", valign="baseline", rotate=90) => @PLACE(87.3, -179);
//   %wire_5511 @TEXT("GND", size=1, halign="middle", valign="baseline", rotate=90) => @PLACE(87.3, -249);
//   %wire_5769 @TEXT("GND", size=1, halign="middle", valign="baseline", rotate=90) => @PLACE(-44.7, 32);
//   %wire_5515 @TEXT("GND", size=1, halign="middle", valign="baseline", rotate=90) => @PLACE(305.3, -634);
//   %wire_5516 @TEXT("GND", size=1, halign="middle", valign="baseline", rotate=90) => @PLACE(39.3, -249);
//   %wire_5514 @TEXT("GND", size=1, halign="middle", valign="baseline", rotate=90) => @PLACE(63.3, -249);
//   %wire_5513 @TEXT("GND", size=1, halign="middle", valign="baseline", rotate=90) => @PLACE(329.3, -634);
//   %wire_5510 @TEXT("GND", size=1, halign="middle", valign="baseline", rotate=90) => @PLACE(353.3, -634);
//   %wire_5509 @TEXT("GND", size=1, halign="middle", valign="baseline", rotate=90) => @PLACE(125.3, -249);
//   %wire_5508 @TEXT("GND", size=1, halign="middle", valign="baseline", rotate=90) => @PLACE(377.3, -634);
//   %wire_5507 @TEXT("GND", size=1, halign="middle", valign="baseline", rotate=90) => @PLACE(401.3, -634);
//   %wire_5500 @TEXT("GND", size=1, halign="middle", valign="baseline", rotate=90) => @PLACE(149.3, -249);
//   %wire_5506 @TEXT("GND", size=1, halign="middle", valign="baseline", rotate=90) => @PLACE(413.3, -643);
//   %wire_5505 @TEXT("GND", size=1, halign="middle", valign="baseline", rotate=90) => @PLACE(-55.7, -108);
//   %wire_5504 @TEXT("GND", size=1, halign="middle", valign="baseline", rotate=90) => @PLACE(-55.7, -73);
//   %wire_5742 @TEXT("GND", size=1, halign="middle", valign="baseline", rotate=90) => @PLACE(-32.7, -493);
//   %wire_5896 @TEXT("GND", size=1, halign="middle", valign="baseline", rotate=90) => @PLACE(-55.7, -563);
//   %wire_5503 @TEXT("GND", size=1, halign="middle", valign="baseline", rotate=90) => @PLACE(-32.7, -108);
//   %wire_5502 @TEXT("GND", size=1, halign="middle", valign="baseline", rotate=90) => @PLACE(-32.7, -73);
//   %wire_5548 @TEXT("GND", size=1, halign="middle", valign="baseline", rotate=90) => @PLACE(-32.7, -143);
//   %wire_5512 @TEXT("GND", size=1, halign="middle", valign="baseline", rotate=90) => @PLACE(63.3, -109);
//   %wire_5499 @TEXT("GND", size=1, halign="middle", valign="baseline", rotate=90) => @PLACE(15.3, -704);
//   %wire_5498 @TEXT("GND", size=1, halign="middle", valign="baseline", rotate=90) => @PLACE(87.3, -109);
//   %wire_5496 @TEXT("GND", size=1, halign="middle", valign="baseline", rotate=90) => @PLACE(39.3, -704);
//   %wire_5495 @TEXT("GND", size=1, halign="middle", valign="baseline", rotate=90) => @PLACE(125.3, -109);
//   %wire_5494 @TEXT("GND", size=1, halign="middle", valign="baseline", rotate=90) => @PLACE(63.3, -704);
//   %wire_5490 @TEXT("GND", size=1, halign="middle", valign="baseline", rotate=90) => @PLACE(173.3, -109);
//   %wire_5493 @TEXT("GND", size=1, halign="middle", valign="baseline", rotate=90) => @PLACE(149.3, -109);
//   %wire_5474 @TEXT("GND", size=1, halign="middle", valign="baseline", rotate=90) => @PLACE(377.3, -109);
//   %wire_5492 @TEXT("GND", size=1, halign="middle", valign="baseline", rotate=90) => @PLACE(87.3, -704);
//   %wire_5489 @TEXT("GND", size=1, halign="middle", valign="baseline", rotate=90) => @PLACE(125.3, -704);
//   %wire_5491 @TEXT("GND", size=1, halign="middle", valign="baseline", rotate=90) => @PLACE(39.3, -109);
//   %wire_5488 @TEXT("GND", size=1, halign="middle", valign="baseline", rotate=90) => @PLACE(197.3, -109);
//   %wire_5487 @TEXT("GND", size=1, halign="middle", valign="baseline", rotate=90) => @PLACE(149.3, -704);
//   %wire_5486 @TEXT("GND", size=1, halign="middle", valign="baseline", rotate=90) => @PLACE(233.3, -109);
//   %wire_5469 @TEXT("GND", size=1, halign="middle", valign="baseline", rotate=90) => @PLACE(15.3, -179);
//   %wire_5485 @TEXT("GND", size=1, halign="middle", valign="baseline", rotate=90) => @PLACE(173.3, -704);
//   %wire_5484 @TEXT("GND", size=1, halign="middle", valign="baseline", rotate=90) => @PLACE(257.3, -109);
//   %wire_5476 @TEXT("GND", size=1, halign="middle", valign="baseline", rotate=90) => @PLACE(353.3, -109);
//   %wire_5483 @TEXT("GND", size=1, halign="middle", valign="baseline", rotate=90) => @PLACE(281.3, -109);
//   %wire_5482 @TEXT("GND", size=1, halign="middle", valign="baseline", rotate=90) => @PLACE(197.3, -704);
//   %wire_5480 @TEXT("GND", size=1, halign="middle", valign="baseline", rotate=90) => @PLACE(305.3, -109);
//   %wire_5479 @TEXT("GND", size=1, halign="middle", valign="baseline", rotate=90) => @PLACE(233.3, -704);
//   %wire_5478 @TEXT("GND", size=1, halign="middle", valign="baseline", rotate=90) => @PLACE(329.3, -109);
//   %wire_5477 @TEXT("GND", size=1, halign="middle", valign="baseline", rotate=90) => @PLACE(257.3, -704);
//   %wire_5475 @TEXT("GND", size=1, halign="middle", valign="baseline", rotate=90) => @PLACE(281.3, -704);
//   %wire_5464 @TEXT("GND", size=1, halign="middle", valign="baseline", rotate=90) => @PLACE(15.3, -109);
//   %wire_5473 @TEXT("GND", size=1, halign="middle", valign="baseline", rotate=90) => @PLACE(305.3, -704);
//   %wire_5472 @TEXT("GND", size=1, halign="middle", valign="baseline", rotate=90) => @PLACE(401.3, -109);
//   %wire_5471 @TEXT("GND", size=1, halign="middle", valign="baseline", rotate=90) => @PLACE(413.3, -118);
//   %wire_5470 @TEXT("GND", size=1, halign="middle", valign="baseline", rotate=90) => @PLACE(329.3, -704);
//   %wire_5730 @TEXT("GND", size=1, halign="middle", valign="baseline", rotate=90) => @PLACE(102.3, -205);
//   %wire_5468 @TEXT("GND", size=1, halign="middle", valign="baseline", rotate=90) => @PLACE(353.3, -704);
//   %wire_5465 @TEXT("GND", size=1, halign="middle", valign="baseline", rotate=90) => @PLACE(39.3, -179);
//   %wire_5466 @TEXT("GND", size=1, halign="middle", valign="baseline", rotate=90) => @PLACE(377.3, -704);
//   %wire_5467 @TEXT("GND", size=1, halign="middle", valign="baseline", rotate=90) => @PLACE(-32.7, 67);
//   %wire_5463 @TEXT("GND", size=1, halign="middle", valign="baseline", rotate=90) => @PLACE(63.3, -179);
//   %wire_5462 @TEXT("GND", size=1, halign="middle", valign="baseline", rotate=90) => @PLACE(401.3, -704);
//   %wire_5461 @TEXT("GND", size=1, halign="middle", valign="baseline", rotate=90) => @PLACE(413.3, -713);
//   %wire_5460 @TEXT("GND", size=1, halign="middle", valign="baseline", rotate=90) => @PLACE(117.3, -756);
//   %wire_5459 @TEXT("GND", size=1, halign="middle", valign="baseline", rotate=90) => @PLACE(189.3, -756);
//   %wire_5458 @TEXT("GND", size=1, halign="middle", valign="baseline", rotate=90) => @PLACE(165.3, -756);
//   %wire_5454 @TEXT("GND", size=1, halign="middle", valign="baseline", rotate=90) => @PLACE(356.3, -756);
//   %wire_5457 @TEXT("GND", size=1, halign="middle", valign="baseline", rotate=90) => @PLACE(380.3, -756);
//   %wire_5456 @TEXT("GND", size=1, halign="middle", valign="baseline", rotate=90) => @PLACE(404.3, -756);
//   %wire_5455 @TEXT("GND", size=1, halign="middle", valign="baseline", rotate=90) => @PLACE(332.3, -756);
//   %wire_5452 @TEXT("GND", size=1, halign="middle", valign="baseline", rotate=90) => @PLACE(249.3, -756);
//   %wire_5451 @TEXT("GND", size=1, halign="middle", valign="baseline", rotate=90) => @PLACE(236.3, -756);
//   %wire_5450 @TEXT("GND", size=1, halign="middle", valign="baseline", rotate=90) => @PLACE(260.3, -756);
//   %wire_5449 @TEXT("GND", size=1, halign="middle", valign="baseline", rotate=90) => @PLACE(273.3, -756);
//   %wire_5448 @TEXT("GND", size=1, halign="middle", valign="baseline", rotate=90) => @PLACE(200.3, -756);
//   %wire_5447 @TEXT("GND", size=1, halign="middle", valign="baseline", rotate=90) => @PLACE(297.3, -756);
//   %wire_5446 @TEXT("GND", size=1, halign="middle", valign="baseline", rotate=90) => @PLACE(225.3, -756);
//   %wire_5453 @TEXT("GND", size=1, halign="middle", valign="baseline", rotate=90) => @PLACE(284.3, -756);
//   %wire_5445 @TEXT("GND", size=1, halign="middle", valign="baseline", rotate=90) => @PLACE(308.3, -756);
//   %wire_5444 @TEXT("GND", size=1, halign="middle", valign="baseline", rotate=90) => @PLACE(152.3, -756);
//   %wire_5443 @TEXT("GND", size=1, halign="middle", valign="baseline", rotate=90) => @PLACE(321.3, -756);
//   %wire_5442 @TEXT("GND", size=1, halign="middle", valign="baseline", rotate=90) => @PLACE(393.3, -756);
//   %wire_5437 @TEXT("GND", size=1, halign="middle", valign="baseline", rotate=90) => @PLACE(428.3, -737);
//   %wire_5441 @TEXT("GND", size=1, halign="middle", valign="baseline", rotate=90) => @PLACE(369.3, -756);
//   %wire_5436 @TEXT("GND", size=1, halign="middle", valign="baseline", rotate=90) => @PLACE(66.3, -756);
//   %wire_5440 @TEXT("GND", size=1, halign="middle", valign="baseline", rotate=90) => @PLACE(345.3, -756);
//   %wire_5438 @TEXT("GND", size=1, halign="middle", valign="baseline", rotate=90) => @PLACE(128.3, -756);
//   %wire_5439 @TEXT("GND", size=1, halign="middle", valign="baseline", rotate=90) => @PLACE(90.3, -756);
//   %wire_5912 @TEXT("GND", size=1, halign="middle", valign="baseline", rotate=90) => @PLACE(42.3, -756);
//   %wire_5580 @TEXT("GND", size=1, halign="middle", valign="baseline", rotate=90) => @PLACE(106.3, -789);
//   %wire_5649 @TEXT("GND", size=1, halign="middle", valign="baseline") => @PLACE(-14, 5.7);
//   %wire_5435 @TEXT("GND", size=1, halign="middle", valign="baseline", rotate=90) => @PLACE(415.3, -765);
//   %wire_5434 @TEXT("GND", size=1, halign="middle", valign="baseline", rotate=90) => @PLACE(436.3, -748);
//   %wire_5921 @TEXT("GND", size=1, halign="middle", valign="baseline", rotate=90) => @PLACE(102.3, -695);
//   %wire_5432 @TEXT("GND", size=1, halign="middle", valign="baseline", rotate=90) => @PLACE(210.3, -590);
//   %wire_5431 @TEXT("GND", size=1, halign="middle", valign="baseline", rotate=90) => @PLACE(210.3, -555);
//   %wire_5430 @TEXT("GND", size=1, halign="middle", valign="baseline", rotate=90) => @PLACE(210.3, -520);
//   %wire_5429 @TEXT("GND", size=1, halign="middle", valign="baseline", rotate=90) => @PLACE(210.3, -485);
//   %wire_5428 @TEXT("GND", size=1, halign="middle", valign="baseline", rotate=90) => @PLACE(210.3, -450);
//   %wire_5427 @TEXT("GND", size=1, halign="middle", valign="baseline", rotate=90) => @PLACE(210.3, -415);
//   %wire_5426 @TEXT("GND", size=1, halign="middle", valign="baseline", rotate=90) => @PLACE(210.3, -380);
//   %wire_5425 @TEXT("GND", size=1, halign="middle", valign="baseline", rotate=90) => @PLACE(210.3, -345);
//   %wire_5424 @TEXT("GND", size=1, halign="middle", valign="baseline", rotate=90) => @PLACE(210.3, -310);
//   %wire_5423 @TEXT("GND", size=1, halign="middle", valign="baseline", rotate=90) => @PLACE(210.3, -275);
//   %wire_5422 @TEXT("GND", size=1, halign="middle", valign="baseline", rotate=90) => @PLACE(210.3, -240);
//   %wire_5421 @TEXT("GND", size=1, halign="middle", valign="baseline", rotate=90) => @PLACE(210.3, -205);
//   %wire_5420 @TEXT("GND", size=1, halign="middle", valign="baseline", rotate=90) => @PLACE(210.3, -170);
//   %wire_5419 @TEXT("GND", size=1, halign="middle", valign="baseline", rotate=90) => @PLACE(-32.7, -563);
//   %wire_5418 @TEXT("GND", size=1, halign="middle", valign="baseline", rotate=90) => @PLACE(-32.7, -598);
//   %wire_5567 @TEXT("GND", size=1, halign="middle", valign="baseline") => @PLACE(-14, -484.3);
//   %wire_5417 @TEXT("GND", size=1, halign="middle", valign="baseline", rotate=90) => @PLACE(210.3, -135);
//   %wire_5416 @TEXT("GND", size=1, halign="middle", valign="baseline", rotate=90) => @PLACE(210.3, -100);
//   %wire_5415 @TEXT("GND", size=1, halign="middle", valign="baseline", rotate=90) => @PLACE(210.3, -65);
//   %wire_5708 @TEXT("GND", size=1, halign="middle", valign="baseline", rotate=90) => @PLACE(-55.7, -388);
//   %wire_5711 @TEXT("GND", size=1, halign="middle", valign="baseline", rotate=90) => @PLACE(-55.7, -353);
//   %wire_5414 @TEXT("GND", size=1, halign="middle", valign="baseline", rotate=90) => @PLACE(210.3, -30);
//   %wire_5413 @TEXT("GND", size=1, halign="middle", valign="baseline", rotate=90) => @PLACE(210.3, 5);
//   %wire_5411 @TEXT("GND", size=1, halign="middle", valign="baseline") => @PLACE(-10, -29.3);
//   %wire_5680 @TEXT("GND", size=1, halign="middle", valign="baseline", rotate=90) => @PLACE(-44.7, -213);
//   %wire_5408 @TEXT("GND", size=1, halign="middle", valign="baseline") => @PLACE(-10, -589.3);
//   %wire_5407 @TEXT("GND", size=1, halign="middle", valign="baseline") => @PLACE(-14, -554.3);
//   %wire_5406 @TEXT("GND", size=1, halign="middle", valign="baseline", rotate=90) => @PLACE(-55.7, -668);
//   %wire_5405 @TEXT("GND", size=1, halign="middle", valign="baseline", rotate=90) => @PLACE(-55.7, -633);
//   %wire_5404 @TEXT("GND", size=1, halign="middle", valign="baseline", rotate=90) => @PLACE(-44.7, -668);
//   %wire_5403 @TEXT("GND", size=1, halign="middle", valign="baseline", rotate=90) => @PLACE(-44.7, -633);
//   %wire_5402 @TEXT("GND", size=1, halign="middle", valign="baseline", rotate=90) => @PLACE(-32.7, -668);
//   %wire_5401 @TEXT("GND", size=1, halign="middle", valign="baseline", rotate=90) => @PLACE(-32.7, -633);
//   %wire_5400 @TEXT("GND", size=1, halign="middle", valign="baseline") => @PLACE(-10, -659.3);
//   %wire_5399 @TEXT("GND", size=1, halign="middle", valign="baseline") => @PLACE(-14, -624.3);
//   %wire_5398 @TEXT("GND", size=1, halign="middle", valign="baseline", rotate=90) => @PLACE(-55.7, -738);
//   %wire_5397 @TEXT("GND", size=1, halign="middle", valign="baseline", rotate=90) => @PLACE(-55.7, -703);
//   %wire_5396 @TEXT("GND", size=1, halign="middle", valign="baseline", rotate=90) => @PLACE(-44.7, -738);
//   %wire_5395 @TEXT("GND", size=1, halign="middle", valign="baseline", rotate=90) => @PLACE(-44.7, -703);
//   %wire_5394 @TEXT("GND", size=1, halign="middle", valign="baseline", rotate=90) => @PLACE(-32.7, -738);
//   %wire_5393 @TEXT("GND", size=1, halign="middle", valign="baseline", rotate=90) => @PLACE(-32.7, -703);
//   %wire_5392 @TEXT("GND", size=1, halign="middle", valign="baseline") => @PLACE(-10, -729.3);
//   %wire_5391 @TEXT("GND", size=1, halign="middle", valign="baseline") => @PLACE(-14, -694.3);
//   %wire_5390 @TEXT("GND", size=1, halign="middle", valign="baseline", rotate=90) => @PLACE(-32.7, 32);
//   %wire_5389 @TEXT("GND", size=1, halign="middle", valign="baseline") => @PLACE(-14, 75.7);
//   %wire_5388 @TEXT("GND", size=1, halign="middle", valign="baseline") => @PLACE(-10, 40.7);
//   %wire_5385 @TEXT("GND", size=1, halign="middle", valign="baseline", rotate=90) => @PLACE(15.3, 66);
//   %wire_5384 @TEXT("GND", size=1, halign="middle", valign="baseline", rotate=90) => @PLACE(15.3, 31);
//   %wire_5383 @TEXT("GND", size=1, halign="middle", valign="baseline", rotate=90) => @PLACE(39.3, 66);
//   %wire_5382 @TEXT("GND", size=1, halign="middle", valign="baseline", rotate=90) => @PLACE(39.3, 31);
//   %wire_5381 @TEXT("GND", size=1, halign="middle", valign="baseline", rotate=90) => @PLACE(63.3, 31);
//   %wire_5380 @TEXT("GND", size=1, halign="middle", valign="baseline", rotate=90) => @PLACE(63.3, 66);
//   %wire_5379 @TEXT("GND", size=1, halign="middle", valign="baseline", rotate=90) => @PLACE(87.3, 66);
//   %wire_5378 @TEXT("GND", size=1, halign="middle", valign="baseline", rotate=90) => @PLACE(87.3, 31);
//   %wire_5377 @TEXT("GND", size=1, halign="middle", valign="baseline", rotate=90) => @PLACE(102.3, 75);
//   %wire_5376 @TEXT("GND", size=1, halign="middle", valign="baseline", rotate=90) => @PLACE(102.3, 40);
//   %wire_5375 @TEXT("GND", size=1, halign="middle", valign="baseline", rotate=90) => @PLACE(125.3, 66);
//   %wire_5374 @TEXT("GND", size=1, halign="middle", valign="baseline", rotate=90) => @PLACE(125.3, 31);
//   %wire_5373 @TEXT("GND", size=1, halign="middle", valign="baseline", rotate=90) => @PLACE(149.3, 66);
//   %wire_5372 @TEXT("GND", size=1, halign="middle", valign="baseline", rotate=90) => @PLACE(149.3, 31);
//   %wire_5371 @TEXT("GND", size=1, halign="middle", valign="baseline", rotate=90) => @PLACE(173.3, 66);
//   %wire_5370 @TEXT("GND", size=1, halign="middle", valign="baseline", rotate=90) => @PLACE(173.3, 31);
//   %wire_5369 @TEXT("GND", size=1, halign="middle", valign="baseline", rotate=90) => @PLACE(197.3, 31);
//   %wire_5368 @TEXT("GND", size=1, halign="middle", valign="baseline", rotate=90) => @PLACE(197.3, 66);
//   %wire_5367 @TEXT("GND", size=1, halign="middle", valign="baseline", rotate=90) => @PLACE(210.3, 75);
//   %wire_5366 @TEXT("GND", size=1, halign="middle", valign="baseline", rotate=90) => @PLACE(210.3, 40);
//   %wire_5365 @TEXT("GND", size=1, halign="middle", valign="baseline", rotate=90) => @PLACE(233.3, 31);
//   %wire_5364 @TEXT("GND", size=1, halign="middle", valign="baseline", rotate=90) => @PLACE(233.3, 66);
//   %wire_5363 @TEXT("GND", size=1, halign="middle", valign="baseline", rotate=90) => @PLACE(257.3, 66);
//   %wire_5362 @TEXT("GND", size=1, halign="middle", valign="baseline", rotate=90) => @PLACE(257.3, 31);
//   %wire_5361 @TEXT("GND", size=1, halign="middle", valign="baseline", rotate=90) => @PLACE(281.3, 31);
//   %wire_5360 @TEXT("GND", size=1, halign="middle", valign="baseline", rotate=90) => @PLACE(281.3, 66);
//   %wire_5359 @TEXT("GND", size=1, halign="middle", valign="baseline", rotate=90) => @PLACE(305.3, 31);
//   %wire_5358 @TEXT("GND", size=1, halign="middle", valign="baseline", rotate=90) => @PLACE(305.3, 66);
//   %wire_5357 @TEXT("GND", size=1, halign="middle", valign="baseline", rotate=90) => @PLACE(329.3, 66);
//   %wire_5356 @TEXT("GND", size=1, halign="middle", valign="baseline", rotate=90) => @PLACE(329.3, 31);
//   %wire_5355 @TEXT("GND", size=1, halign="middle", valign="baseline", rotate=90) => @PLACE(353.3, 31);
//   %wire_5354 @TEXT("GND", size=1, halign="middle", valign="baseline", rotate=90) => @PLACE(353.3, 66);
//   %wire_5353 @TEXT("GND", size=1, halign="middle", valign="baseline", rotate=90) => @PLACE(377.3, 66);
//   %wire_5352 @TEXT("GND", size=1, halign="middle", valign="baseline", rotate=90) => @PLACE(377.3, 31);
//   %wire_5351 @TEXT("GND", size=1, halign="middle", valign="baseline", rotate=90) => @PLACE(401.3, 66);
//   %wire_5350 @TEXT("GND", size=1, halign="middle", valign="baseline", rotate=90) => @PLACE(401.3, 31);
//   %wire_5349 @TEXT("GND", size=1, halign="middle", valign="baseline", rotate=90) => @PLACE(413.3, 57);
//   %wire_5348 @TEXT("GND", size=1, halign="middle", valign="baseline", rotate=90) => @PLACE(413.3, 22);
//   %wire_5346 @TEXT("GND", size=1, halign="middle", valign="top", rotate=90) => @PLACE(433.7, 81);
//   %wire_5345 @TEXT("GND", size=1, halign="middle", valign="baseline", rotate=90) => @PLACE(141.3, -756);
//   %wire_5343 @TEXT("GND", size=1, halign="middle", valign="top") => @PLACE(-99, 33.3);
//   %wire_5340 @TEXT("GND", size=1, halign="middle", valign="top") => @PLACE(-99, 25.3);
//   %wire_5339 @TEXT("GND", size=1, halign="middle", valign="top") => @PLACE(450, -762.7);
//   %wire_5338 @TEXT("GND", size=1, halign="middle", valign="top") => @PLACE(468, -746.7);
//   %wire_5337 @TEXT("GND", size=1, halign="middle", valign="top") => @PLACE(453, -746.7);
//   %p2874 = (-4, -717);
//   %p2875 = (14, -717);
//   %wire_5963 = &"net86" @WIRE(mode="straight") {%p2874 %p2875};
//   %wire_5964 = &"net86" @WIRE(mode="straight") {#"I1534":1 %p2874};
//   %p2876 = (34, -719);
//   %wire_5965 = &"net86" @WIRE(mode="straight") {%p2876 %p2875};
//   %wire_5966 = &"net86" @WIRE(mode="straight") {#"I1417":7 %p2875};
//   %wire_5967 = &"net86" @WIRE(mode="straight") {#"I1416":3 %p2876};
//   %p2877 = (113, -773);
//   %wire_5968 = &"FRAME_4" @WIRE(mode="straight") {%p2877 #"I1197":1};
//   %wire_5968 @TEXT("FRAME\_4", size=1, halign="middle", valign="baseline", rotate=90) => @PLACE(112.3, -768);
//   %p2878 = (75, -773);
//   %wire_5969 = &"FRAME_3" @WIRE(mode="straight") {%p2878 #"I1195":1};
//   %wire_5969 @TEXT("FRAME\_3", size=1, halign="middle", valign="baseline", rotate=90) => @PLACE(74.3, -768);
//   %p2879 = (137, -773);
//   %wire_5970 = &"FRAME_5" @WIRE(mode="straight") {%p2879 #"I1202":1};
//   %wire_5970 @TEXT("FRAME\_5", size=1, halign="middle", valign="baseline", rotate=90) => @PLACE(136.3, -768);
//   %p2880 = (-23, -512);
//   %wire_5971 = &"net2273" @WIRE(mode="straight") {%p2880 #"M79":2};
//   %p2881 = (-23, -475);
//   %wire_5972 = &"net2273" @WIRE(mode="straight") {%p2880 %p2881};
//   %wire_5973 = &"net2273" @WIRE(mode="straight") {#"I1510":3 #"M79":2};
//   %wire_5974 = &"net2273" @WIRE(mode="straight") {%p2881 #"I1517":1};
//   %wire_5975 = &"net2113" @WIRE(mode="straight") {#"I1470":3 #"M69":2};
//   %p2882 = (-23, -162);
//   %wire_5976 = &"net2113" @WIRE(mode="straight") {%p2882 #"M69":2};
//   %p2883 = (-23, -125);
//   %wire_5977 = &"net2113" @WIRE(mode="straight") {%p2882 %p2883};
//   %wire_5978 = &"net2113" @WIRE(mode="straight") {%p2883 #"I1477":1};
//   %p2884 = (419, -719);
//   %wire_5979 = &"net641" @WIRE(mode="straight") {#"I1223":1 %p2884};
//   %p2885 = (398, -719);
//   %wire_5980 = &"net641" @WIRE(mode="straight") {#"I1430":6 %p2885};
//   %wire_5981 = &"net641" @WIRE(mode="straight") {%p2885 %p2884};
//   %wire_5982 = &"net641" @WIRE(mode="straight") {%p2884 #"I1260":3};
//   %p2886 = (215, -206);
//   %wire_5983 = &"net82" @WIRE(mode="straight") {%p2886 #"I890":4};
//   %p2887 = (215, -209);
//   %wire_5984 = &"net82" @WIRE(mode="straight") {%p2887 %p2886};
//   %wire_5985 = &"net82" @WIRE(mode="straight") {%p2886 #"M167":1};
//   %wire_5986 = &"net82" @WIRE(mode="straight") {#"M60":1 %p2887};
//   %wire_5987 = &"net82" @WIRE(mode="straight") {#"I904":4 #"I903":4};
//   %wire_5988 = &"net82" @WIRE(mode="straight") {#"I889":4 #"I908":4};
//   %wire_5989 = &"net82" @WIRE(mode="straight") {#"I907":4 #"I906":4};
//   %wire_5990 = &"net82" @WIRE(mode="straight") {#"I905":4 #"I904":4};
//   %wire_5991 = &"net82" @WIRE(mode="straight") {#"I906":4 #"I905":4};
//   %wire_5992 = &"net82" @WIRE(mode="straight") {#"I908":4 #"I907":4};
//   %wire_5993 = &"net82" @WIRE(mode="straight") {#"I890":4 #"I889":4};
//   %p2888 = (396, -369);
//   %wire_5994 = &"net470" @WIRE(mode="straight") {#"I1345":3 %p2888};
//   %p2889 = (376, -367);
//   %wire_5995 = &"net470" @WIRE(mode="straight") {#"I1344":7 %p2889};
//   %wire_5996 = &"net470" @WIRE(mode="straight") {%p2888 %p2889};
//   %p2890 = (350, -369);
//   %wire_5997 = &"net470" @WIRE(mode="straight") {%p2890 %p2889};
//   %wire_5998 = &"net470" @WIRE(mode="straight") {#"I1343":6 %p2890};
//   %p2891 = (400, -367);
//   %wire_5999 = &"net471" @WIRE(mode="straight") {#"I1345":7 %p2891};
//   %p2892 = (374, -369);
//   %wire_6000 = &"net471" @WIRE(mode="straight") {%p2892 %p2891};
//   %wire_6001 = &"net471" @WIRE(mode="straight") {#"I1344":6 %p2892};
//   %p2893 = (372, -194);
//   %p2894 = (374, -194);
//   %wire_6002 = &"net81" @WIRE(mode="straight") {%p2893 %p2894};
//   %wire_6003 = &"net81" @WIRE(mode="straight") {#"I904":3 %p2893};
//   %wire_6004 = &"net81" @WIRE(mode="straight") {#"I904":6 %p2894};
//   %p2895 = (352, -194);
//   %wire_6005 = &"net81" @WIRE(mode="straight") {%p2895 %p2893};
//   %wire_6006 = &"net81" @WIRE(mode="straight") {#"I905":7 %p2895};
//   %p2896 = (376, -507);
//   %wire_6007 = &"net473" @WIRE(mode="straight") {#"I1378":7 %p2896};
//   %p2897 = (396, -509);
//   %wire_6008 = &"net473" @WIRE(mode="straight") {#"I1379":3 %p2897};
//   %wire_6009 = &"net473" @WIRE(mode="straight") {%p2897 %p2896};
//   %p2898 = (350, -509);
//   %wire_6010 = &"net473" @WIRE(mode="straight") {%p2898 %p2896};
//   %wire_6011 = &"net473" @WIRE(mode="straight") {#"I1377":6 %p2898};
//   %p2899 = (374, -509);
//   %p2900 = (400, -507);
//   %wire_6012 = &"net474" @WIRE(mode="straight") {%p2899 %p2900};
//   %wire_6013 = &"net474" @WIRE(mode="straight") {#"I1378":6 %p2899};
//   %wire_6014 = &"net474" @WIRE(mode="straight") {#"I1379":7 %p2900};
//   %p2901 = (407, -776);
//   %p2902 = (407, -763);
//   %wire_6015 = &"net2" @WIRE(mode="straight") {%p2901 %p2902};
//   %p2903 = (402, -763);
//   %wire_6016 = &"net2" @WIRE(mode="straight") {%p2903 %p2902};
//   %wire_6017 = &"net2" @WIRE(mode="straight") {%p2901 #"I1637":2};
//   %p2904 = (40, -763);
//   %p2905 = (64, -763);
//   %wire_6018 = &"net2" @WIRE(mode="straight") {%p2904 %p2905};
//   %wire_6019 = &"net2" @WIRE(mode="straight") {%p2905 #"I1622":2};
//   %p2906 = (88, -763);
//   %wire_6020 = &"net2" @WIRE(mode="straight") {%p2905 %p2906};
//   %p2907 = (126, -763);
//   %wire_6021 = &"net2" @WIRE(mode="straight") {%p2907 #"I1624":2};
//   %p2908 = (234, -763);
//   %wire_6022 = &"net2" @WIRE(mode="straight") {%p2908 #"I1627":2};
//   %p2909 = (258, -763);
//   %wire_6023 = &"net2" @WIRE(mode="straight") {%p2909 #"I1628":2};
//   %wire_6024 = &"net2" @WIRE(mode="straight") {%p2903 #"I1634":2};
//   %p2910 = (330, -763);
//   %wire_6025 = &"net2" @WIRE(mode="straight") {%p2910 #"I1631":2};
//   %p2911 = (306, -763);
//   %wire_6026 = &"net2" @WIRE(mode="straight") {%p2911 %p2910};
//   %p2912 = (378, -763);
//   %wire_6027 = &"net2" @WIRE(mode="straight") {%p2912 #"I1633":2};
//   %p2913 = (354, -763);
//   %wire_6028 = &"net2" @WIRE(mode="straight") {%p2913 #"I1632":2};
//   %wire_6029 = &"net2" @WIRE(mode="straight") {%p2908 %p2909};
//   %p2914 = (282, -763);
//   %wire_6030 = &"net2" @WIRE(mode="straight") {%p2909 %p2914};
//   %p2915 = (198, -763);
//   %wire_6031 = &"net2" @WIRE(mode="straight") {%p2915 %p2908};
//   %wire_6032 = &"net2" @WIRE(mode="straight") {%p2911 #"I1630":2};
//   %wire_6033 = &"net2" @WIRE(mode="straight") {%p2915 #"I1626":2};
//   %wire_6034 = &"net2" @WIRE(mode="straight") {%p2913 %p2912};
//   %wire_6035 = &"net2" @WIRE(mode="straight") {%p2906 #"I1623":2};
//   %p2916 = (174, -763);
//   %wire_6036 = &"net2" @WIRE(mode="straight") {%p2916 #"I1635":2};
//   %wire_6037 = &"net2" @WIRE(mode="straight") {%p2904 #"I1621":2};
//   %wire_6038 = &"net2" @WIRE(mode="straight") {%p2910 %p2913};
//   %wire_6039 = &"net2" @WIRE(mode="straight") {%p2914 %p2911};
//   %wire_6040 = &"net2" @WIRE(mode="straight") {%p2914 #"I1629":2};
//   %wire_6041 = &"net2" @WIRE(mode="straight") {%p2906 %p2907};
//   %wire_6042 = &"net2" @WIRE(mode="straight") {%p2912 %p2903};
//   %p2917 = (150, -763);
//   %wire_6043 = &"net2" @WIRE(mode="straight") {%p2907 %p2917};
//   %wire_6044 = &"net2" @WIRE(mode="straight") {%p2916 %p2915};
//   %wire_6045 = &"net2" @WIRE(mode="straight") {%p2917 %p2916};
//   %wire_6046 = &"net2" @WIRE(mode="straight") {%p2917 #"I1625":2};
//   %p2918 = (3, -773);
//   %wire_6047 = &"FRAME_0" @WIRE(mode="straight") {%p2918 #"I1189":1};
//   %wire_6047 @TEXT("FRAME\_0", size=1, halign="middle", valign="baseline", rotate=90) => @PLACE(2.3, -768);
//   %p2919 = (120, -194);
//   %wire_6048 = &"net41" @WIRE(mode="straight") {#"I894":3 %p2919};
//   %p2920 = (122, -194);
//   %wire_6049 = &"net41" @WIRE(mode="straight") {%p2919 %p2920};
//   %p2921 = (86, -194);
//   %wire_6050 = &"net41" @WIRE(mode="straight") {#"I882":7 %p2921};
//   %wire_6051 = &"net41" @WIRE(mode="straight") {#"I894":6 %p2920};
//   %wire_6052 = &"net41" @WIRE(mode="straight") {%p2921 %p2919};
//   %p2922 = (124, -218);
//   %p2923 = (148, -218);
//   %wire_6053 = &"net32" @WIRE(mode="straight") {%p2922 %p2923};
//   %p2924 = (14, -218);
//   %p2925 = (38, -218);
//   %wire_6054 = &"net32" @WIRE(mode="straight") {%p2924 %p2925};
//   %wire_6055 = &"net32" @WIRE(mode="straight") {%p2922 #"I894":5};
//   %p2926 = (62, -218);
//   %p2927 = (86, -218);
//   %wire_6056 = &"net32" @WIRE(mode="straight") {%p2926 %p2927};
//   %p2928 = (256, -218);
//   %p2929 = (280, -218);
//   %wire_6057 = &"net32" @WIRE(mode="straight") {%p2928 %p2929};
//   %p2930 = (304, -218);
//   %p2931 = (328, -218);
//   %wire_6058 = &"net32" @WIRE(mode="straight") {%p2930 %p2931};
//   %p2932 = (232, -218);
//   %wire_6059 = &"net32" @WIRE(mode="straight") {%p2932 %p2928};
//   %wire_6060 = &"net32" @WIRE(mode="straight") {%p2925 %p2926};
//   %p2933 = (172, -218);
//   %p2934 = (196, -218);
//   %wire_6061 = &"net32" @WIRE(mode="straight") {%p2933 %p2934};
//   %wire_6062 = &"net32" @WIRE(mode="straight") {%p2923 %p2933};
//   %p2935 = (352, -218);
//   %wire_6063 = &"net32" @WIRE(mode="straight") {%p2931 %p2935};
//   %p2936 = (400, -218);
//   %wire_6064 = &"net32" @WIRE(mode="straight") {%p2936 #"I902":2};
//   %wire_6065 = &"net32" @WIRE(mode="straight") {%p2928 #"I889":5};
//   %wire_6066 = &"net32" @WIRE(mode="straight") {%p2936 #"I903":5};
//   %wire_6067 = &"net32" @WIRE(mode="straight") {%p2930 #"I907":5};
//   %wire_6068 = &"net32" @WIRE(mode="straight") {%p2927 #"I882":5};
//   %wire_6069 = &"net32" @WIRE(mode="straight") {%p2925 #"I880":5};
//   %wire_6070 = &"net32" @WIRE(mode="straight") {%p2929 #"I908":5};
//   %wire_6071 = &"net32" @WIRE(mode="straight") {%p2923 #"I893":5};
//   %wire_6072 = &"net32" @WIRE(mode="straight") {%p2924 #"I879":5};
//   %wire_6073 = &"net32" @WIRE(mode="straight") {%p2932 #"I890":5};
//   %wire_6074 = &"net32" @WIRE(mode="straight") {%p2926 #"I881":5};
//   %p2937 = (376, -218);
//   %wire_6075 = &"net32" @WIRE(mode="straight") {%p2935 %p2937};
//   %p2938 = (-20, -218);
//   %wire_6076 = &"net32" @WIRE(mode="straight") {%p2938 #"I1485":2};
//   %wire_6077 = &"net32" @WIRE(mode="straight") {%p2927 %p2922};
//   %wire_6078 = &"net32" @WIRE(mode="straight") {%p2934 %p2932};
//   %wire_6079 = &"net32" @WIRE(mode="straight") {%p2937 %p2936};
//   %wire_6080 = &"net32" @WIRE(mode="straight") {%p2929 %p2930};
//   %wire_6081 = &"net32" @WIRE(mode="straight") {%p2934 #"I891":5};
//   %wire_6082 = &"net32" @WIRE(mode="straight") {%p2931 #"I906":5};
//   %wire_6083 = &"net32" @WIRE(mode="straight") {%p2933 #"I892":5};
//   %wire_6084 = &"net32" @WIRE(mode="straight") {%p2938 %p2924};
//   %wire_6085 = &"net32" @WIRE(mode="straight") {%p2935 #"I905":5};
//   %wire_6086 = &"net32" @WIRE(mode="straight") {%p2937 #"I904":5};
//   %p2939 = (226, -190);
//   %p2940 = (250, -190);
//   %wire_6087 = &"net55" @WIRE(mode="straight") {%p2939 %p2940};
//   %p2941 = (298, -190);
//   %wire_6088 = &"net55" @WIRE(mode="straight") {#"I907":9 %p2941};
//   %p2942 = (56, -190);
//   %p2943 = (80, -190);
//   %wire_6089 = &"net55" @WIRE(mode="straight") {%p2942 %p2943};
//   %p2944 = (32, -190);
//   %wire_6090 = &"net55" @WIRE(mode="straight") {%p2944 %p2942};
//   %p2945 = (274, -190);
//   %wire_6091 = &"net55" @WIRE(mode="straight") {%p2945 %p2941};
//   %p2946 = (10, -190);
//   %wire_6092 = &"net55" @WIRE(mode="straight") {%p2946 %p2944};
//   %p2947 = (370, -190);
//   %wire_6093 = &"net55" @WIRE(mode="straight") {#"I904":9 %p2947};
//   %p2948 = (8, -190);
//   %wire_6094 = &"net55" @WIRE(mode="straight") {%p2948 %p2946};
//   %p2949 = (394, -190);
//   %wire_6095 = &"net55" @WIRE(mode="straight") {#"I903":9 %p2949};
//   %wire_6096 = &"net55" @WIRE(mode="straight") {#"I890":9 %p2939};
//   %p2950 = (118, -190);
//   %wire_6097 = &"net55" @WIRE(mode="straight") {#"I894":9 %p2950};
//   %wire_6098 = &"net55" @WIRE(mode="straight") {#"I880":9 %p2944};
//   %p2951 = (322, -190);
//   %p2952 = (346, -190);
//   %wire_6099 = &"net55" @WIRE(mode="straight") {%p2951 %p2952};
//   %p2953 = (142, -190);
//   %wire_6100 = &"net55" @WIRE(mode="straight") {#"I893":9 %p2953};
//   %wire_6101 = &"net55" @WIRE(mode="straight") {#"I879":3 %p2946};
//   %p2954 = (190, -190);
//   %wire_6102 = &"net55" @WIRE(mode="straight") {%p2954 %p2939};
//   %wire_6103 = &"net55" @WIRE(mode="straight") {%p2940 %p2945};
//   %wire_6104 = &"net55" @WIRE(mode="straight") {%p2952 %p2947};
//   %wire_6105 = &"net55" @WIRE(mode="straight") {#"I905":9 %p2952};
//   %wire_6106 = &"net55" @WIRE(mode="straight") {%p2941 %p2951};
//   %wire_6107 = &"net55" @WIRE(mode="straight") {#"I908":9 %p2945};
//   %wire_6108 = &"net55" @WIRE(mode="straight") {#"I882":9 %p2943};
//   %wire_6109 = &"net55" @WIRE(mode="straight") {#"I881":9 %p2942};
//   %wire_6110 = &"net55" @WIRE(mode="straight") {#"I889":9 %p2940};
//   %wire_6111 = &"net55" @WIRE(mode="straight") {%p2943 %p2950};
//   %wire_6112 = &"net55" @WIRE(mode="straight") {%p2950 %p2953};
//   %wire_6113 = &"net55" @WIRE(mode="straight") {#"I879":9 %p2948};
//   %wire_6114 = &"net55" @WIRE(mode="straight") {%p2947 %p2949};
//   %wire_6115 = &"net55" @WIRE(mode="straight") {#"I891":9 %p2954};
//   %p2955 = (166, -190);
//   %wire_6116 = &"net55" @WIRE(mode="straight") {%p2955 %p2954};
//   %wire_6117 = &"net55" @WIRE(mode="straight") {%p2953 %p2955};
//   %wire_6118 = &"net55" @WIRE(mode="straight") {#"I906":9 %p2951};
//   %wire_6119 = &"net55" @WIRE(mode="straight") {#"I892":9 %p2955};
//   %wire_6120 = &"net375" @WIRE(mode="straight") {#"I1473":1 #"I1474":3};
//   %p2956 = (12, -127);
//   %wire_6121 = &"net2125" @WIRE(mode="straight") {#"I839":6 %p2956};
//   %wire_6122 = &"net2125" @WIRE(mode="straight") {#"M70":2 %p2956};
//   %wire_6123 = &"net2125" @WIRE(mode="straight") {#"I1477":3 #"M70":2};
//   %p2957 = (-26, -208);
//   %wire_6124 = &"net22" @WIRE(mode="straight") {#"I1484":2 %p2957};
//   %wire_6125 = &"net22" @WIRE(mode="straight") {%p2957 #"I1480":1};
//   %p2958 = (-6, -206);
//   %wire_6126 = &"net22" @WIRE(mode="straight") {%p2958 #"M72":1};
//   %p2959 = (97, -206);
//   %wire_6127 = &"net22" @WIRE(mode="straight") {#"M28":3 %p2959};
//   %wire_6128 = &"net22" @WIRE(mode="straight") {#"I880":4 #"I881":4};
//   %p2960 = (97, -203);
//   %wire_6129 = &"net22" @WIRE(mode="straight") {%p2960 #"M135":3};
//   %wire_6130 = &"net22" @WIRE(mode="straight") {%p2958 #"I879":4};
//   %wire_6131 = &"net22" @WIRE(mode="straight") {#"I882":4 %p2959};
//   %wire_6132 = &"net22" @WIRE(mode="straight") {%p2959 %p2960};
//   %wire_6133 = &"net22" @WIRE(mode="straight") {#"I879":4 #"I880":4};
//   %wire_6134 = &"net22" @WIRE(mode="straight") {#"I881":4 #"I882":4};
//   %wire_6135 = &"net22" @WIRE(mode="straight") {#"I1480":1 %p2958};
//   %p2961 = (447, -756);
//   %wire_6136 = &"VDD" @WIRE(mode="straight") {#"I109":3 %p2961};
//   %p2962 = (471, -740);
//   %wire_6137 = &"VDD" @WIRE(mode="straight") {#"I130":3 %p2962};
//   %p2963 = (456, -740);
//   %wire_6138 = &"VDD" @WIRE(mode="straight") {#"I108":3 %p2963};
//   %p2964 = (-98, 29);
//   %wire_6139 = &"VDD" @WIRE(mode="straight") {%bundle_0:1 %p2964};
//   %wire_6140 = &"VDD" @WIRE(mode="straight") {%bundle_4:1 #"I1642":1};
//   %wire_6141 = &"VDD" @WIRE(mode="straight") {%bundle_2:1 %bundle_1:1};
//   %wire_6142 = &"VDD" @WIRE(mode="straight") {%bundle_3:1 %bundle_2:1};
//   %wire_6143 = &"VDD" @WIRE(mode="straight") {%bundle_1:1 %bundle_4:1};
//   %p2965 = (433, 92);
//   %wire_6144 = &"VDD" @WIRE(mode="straight") {#"I1608":3 %p2965};
//   %p2966 = (414, 69);
//   %wire_6145 = &"VDD" @WIRE(mode="straight") {#"I1602":3 %p2966};
//   %p2967 = (414, 34);
//   %wire_6146 = &"VDD" @WIRE(mode="straight") {#"I1596":3 %p2967};
//   %p2968 = (402, 84);
//   %wire_6147 = &"VDD" @WIRE(mode="straight") {#"I1607":8 %p2968};
//   %p2969 = (402, 49);
//   %wire_6148 = &"VDD" @WIRE(mode="straight") {#"I1597":8 %p2969};
//   %p2970 = (378, 84);
//   %wire_6149 = &"VDD" @WIRE(mode="straight") {#"I1606":8 %p2970};
//   %p2971 = (378, 49);
//   %wire_6150 = &"VDD" @WIRE(mode="straight") {#"I1598":8 %p2971};
//   %p2972 = (354, 84);
//   %wire_6151 = &"VDD" @WIRE(mode="straight") {#"I1605":8 %p2972};
//   %p2973 = (354, 49);
//   %wire_6152 = &"VDD" @WIRE(mode="straight") {#"I1599":8 %p2973};
//   %p2974 = (330, 84);
//   %wire_6153 = &"VDD" @WIRE(mode="straight") {#"I1604":8 %p2974};
//   %p2975 = (330, 49);
//   %wire_6154 = &"VDD" @WIRE(mode="straight") {#"I1600":8 %p2975};
//   %p2976 = (306, 84);
//   %wire_6155 = &"VDD" @WIRE(mode="straight") {#"I1603":8 %p2976};
//   %p2977 = (306, 49);
//   %wire_6156 = &"VDD" @WIRE(mode="straight") {#"I1601":8 %p2977};
//   %p2978 = (282, 49);
//   %wire_6157 = &"VDD" @WIRE(mode="straight") {#"I1566":8 %p2978};
//   %p2979 = (282, 84);
//   %wire_6158 = &"VDD" @WIRE(mode="straight") {#"I1573":8 %p2979};
//   %p2980 = (258, 49);
//   %wire_6159 = &"VDD" @WIRE(mode="straight") {#"I1567":8 %p2980};
//   %p2981 = (258, 84);
//   %wire_6160 = &"VDD" @WIRE(mode="straight") {#"I1579":8 %p2981};
//   %p2982 = (234, 84);
//   %wire_6161 = &"VDD" @WIRE(mode="straight") {#"I1574":8 %p2982};
//   %p2983 = (234, 49);
//   %wire_6162 = &"VDD" @WIRE(mode="straight") {#"I1568":8 %p2983};
//   %p2984 = (207, 39);
//   %wire_6163 = &"VDD" @WIRE(mode="straight") {#"M89":4 %p2984};
//   %p2985 = (207, 74);
//   %wire_6164 = &"VDD" @WIRE(mode="straight") {#"M92":4 %p2985};
//   %p2986 = (198, 49);
//   %wire_6165 = &"VDD" @WIRE(mode="straight") {#"I1569":8 %p2986};
//   %p2987 = (198, 84);
//   %wire_6166 = &"VDD" @WIRE(mode="straight") {#"I1578":8 %p2987};
//   %p2988 = (174, 49);
//   %wire_6167 = &"VDD" @WIRE(mode="straight") {#"I1570":8 %p2988};
//   %p2989 = (174, 84);
//   %wire_6168 = &"VDD" @WIRE(mode="straight") {#"I1577":8 %p2989};
//   %p2990 = (150, 49);
//   %wire_6169 = &"VDD" @WIRE(mode="straight") {#"I1571":8 %p2990};
//   %p2991 = (150, 84);
//   %wire_6170 = &"VDD" @WIRE(mode="straight") {#"I1576":8 %p2991};
//   %p2992 = (126, 49);
//   %wire_6171 = &"VDD" @WIRE(mode="straight") {#"I1572":8 %p2992};
//   %p2993 = (126, 84);
//   %wire_6172 = &"VDD" @WIRE(mode="straight") {#"I1575":8 %p2993};
//   %p2994 = (99, 39);
//   %wire_6173 = &"VDD" @WIRE(mode="straight") {#"M90":4 %p2994};
//   %p2995 = (99, 74);
//   %wire_6174 = &"VDD" @WIRE(mode="straight") {#"M91":4 %p2995};
//   %p2996 = (88, 49);
//   %wire_6175 = &"VDD" @WIRE(mode="straight") {#"I1548":8 %p2996};
//   %p2997 = (88, 84);
//   %wire_6176 = &"VDD" @WIRE(mode="straight") {#"I1556":8 %p2997};
//   %p2998 = (64, 49);
//   %wire_6177 = &"VDD" @WIRE(mode="straight") {#"I1547":8 %p2998};
//   %p2999 = (64, 84);
//   %wire_6178 = &"VDD" @WIRE(mode="straight") {#"I1555":8 %p2999};
//   %p3000 = (40, 49);
//   %wire_6179 = &"VDD" @WIRE(mode="straight") {#"I1546":8 %p3000};
//   %p3001 = (40, 84);
//   %wire_6180 = &"VDD" @WIRE(mode="straight") {#"I1554":8 %p3001};
//   %p3002 = (16, 49);
//   %wire_6181 = &"VDD" @WIRE(mode="straight") {#"I1545":8 %p3002};
//   %p3003 = (16, 84);
//   %wire_6182 = &"VDD" @WIRE(mode="straight") {#"I1553":8 %p3003};
//   %p3004 = (-4, 84);
//   %p3005 = (-4, 86);
//   %wire_6183 = &"VDD" @WIRE(mode="straight") {%p3004 %p3005};
//   %wire_6184 = &"VDD" @WIRE(mode="straight") {#"M88":4 %p3004};
//   %wire_6185 = &"VDD" @WIRE(mode="straight") {#"M88":3 %p3005};
//   %p3006 = (-6, 88);
//   %wire_6186 = &"VDD" @WIRE(mode="straight") {#"M88":3 %p3006};
//   %p3007 = (-8, 88);
//   %wire_6187 = &"VDD" @WIRE(mode="straight") {%p3007 %p3006};
//   %p3008 = (-8, 55);
//   %wire_6188 = &"VDD" @WIRE(mode="straight") {#"I1549":4 %p3008};
//   %p3009 = (-16, 90);
//   %wire_6189 = &"VDD" @WIRE(mode="straight") {#"I1557":4 %p3009};
//   %p3010 = (-16, 53);
//   %p3011 = (-18, 53);
//   %wire_6190 = &"VDD" @WIRE(mode="straight") {%p3010 %p3011};
//   %wire_6191 = &"VDD" @WIRE(mode="straight") {#"M87":3 %p3011};
//   %p3012 = (-20, 49);
//   %wire_6192 = &"VDD" @WIRE(mode="straight") {#"M87":4 %p3012};
//   %p3013 = (-20, 51);
//   %wire_6193 = &"VDD" @WIRE(mode="straight") {#"M87":3 %p3013};
//   %wire_6194 = &"VDD" @WIRE(mode="straight") {%p3012 %p3013};
//   %p3014 = (-32, 81);
//   %wire_6195 = &"VDD" @WIRE(mode="straight") {#"I1552":3 %p3014};
//   %p3015 = (-32, 46);
//   %wire_6196 = &"VDD" @WIRE(mode="straight") {#"I1544":3 %p3015};
//   %p3016 = (-4, -686);
//   %p3017 = (-4, -684);
//   %wire_6197 = &"VDD" @WIRE(mode="straight") {%p3016 %p3017};
//   %wire_6198 = &"VDD" @WIRE(mode="straight") {#"M86":4 %p3016};
//   %wire_6199 = &"VDD" @WIRE(mode="straight") {#"M86":3 %p3017};
//   %p3018 = (-6, -682);
//   %wire_6200 = &"VDD" @WIRE(mode="straight") {#"M86":3 %p3018};
//   %p3019 = (-16, -680);
//   %wire_6201 = &"VDD" @WIRE(mode="straight") {#"I1541":4 %p3019};
//   %p3020 = (-8, -682);
//   %wire_6202 = &"VDD" @WIRE(mode="straight") {%p3020 %p3018};
//   %p3021 = (-20, -721);
//   %p3022 = (-20, -719);
//   %wire_6203 = &"VDD" @WIRE(mode="straight") {%p3021 %p3022};
//   %wire_6204 = &"VDD" @WIRE(mode="straight") {#"M85":3 %p3022};
//   %wire_6205 = &"VDD" @WIRE(mode="straight") {#"M85":4 %p3021};
//   %p3023 = (-18, -717);
//   %wire_6206 = &"VDD" @WIRE(mode="straight") {#"M85":3 %p3023};
//   %p3024 = (-8, -715);
//   %wire_6207 = &"VDD" @WIRE(mode="straight") {#"I1534":4 %p3024};
//   %p3025 = (-16, -717);
//   %wire_6208 = &"VDD" @WIRE(mode="straight") {%p3025 %p3023};
//   %p3026 = (-32, -689);
//   %wire_6209 = &"VDD" @WIRE(mode="straight") {#"I1536":3 %p3026};
//   %p3027 = (-32, -724);
//   %wire_6210 = &"VDD" @WIRE(mode="straight") {#"I1535":3 %p3027};
//   %p3028 = (-44, -689);
//   %wire_6211 = &"VDD" @WIRE(mode="straight") {#"I1540":4 %p3028};
//   %p3029 = (-44, -724);
//   %wire_6212 = &"VDD" @WIRE(mode="straight") {#"I1538":4 %p3029};
//   %p3030 = (-55, -689);
//   %wire_6213 = &"VDD" @WIRE(mode="straight") {#"I1539":3 %p3030};
//   %p3031 = (-55, -724);
//   %wire_6214 = &"VDD" @WIRE(mode="straight") {#"I1537":3 %p3031};
//   %p3032 = (-4, -616);
//   %p3033 = (-4, -614);
//   %wire_6215 = &"VDD" @WIRE(mode="straight") {%p3032 %p3033};
//   %wire_6216 = &"VDD" @WIRE(mode="straight") {#"M84":4 %p3032};
//   %wire_6217 = &"VDD" @WIRE(mode="straight") {#"M84":3 %p3033};
//   %p3034 = (-6, -612);
//   %wire_6218 = &"VDD" @WIRE(mode="straight") {#"M84":3 %p3034};
//   %p3035 = (-16, -610);
//   %wire_6219 = &"VDD" @WIRE(mode="straight") {#"I1533":4 %p3035};
//   %p3036 = (-8, -612);
//   %wire_6220 = &"VDD" @WIRE(mode="straight") {%p3036 %p3034};
//   %p3037 = (-20, -651);
//   %p3038 = (-20, -649);
//   %wire_6221 = &"VDD" @WIRE(mode="straight") {%p3037 %p3038};
//   %wire_6222 = &"VDD" @WIRE(mode="straight") {#"M83":3 %p3038};
//   %wire_6223 = &"VDD" @WIRE(mode="straight") {#"M83":4 %p3037};
//   %p3039 = (-18, -647);
//   %wire_6224 = &"VDD" @WIRE(mode="straight") {#"M83":3 %p3039};
//   %p3040 = (-8, -645);
//   %wire_6225 = &"VDD" @WIRE(mode="straight") {#"I1526":4 %p3040};
//   %p3041 = (-16, -647);
//   %wire_6226 = &"VDD" @WIRE(mode="straight") {%p3041 %p3039};
//   %p3042 = (-32, -619);
//   %wire_6227 = &"VDD" @WIRE(mode="straight") {#"I1528":3 %p3042};
//   %p3043 = (-32, -654);
//   %wire_6228 = &"VDD" @WIRE(mode="straight") {#"I1527":3 %p3043};
//   %p3044 = (-44, -619);
//   %wire_6229 = &"VDD" @WIRE(mode="straight") {#"I1532":4 %p3044};
//   %p3045 = (-44, -654);
//   %wire_6230 = &"VDD" @WIRE(mode="straight") {#"I1530":4 %p3045};
//   %p3046 = (-55, -619);
//   %wire_6231 = &"VDD" @WIRE(mode="straight") {#"I1531":3 %p3046};
//   %p3047 = (-55, -654);
//   %wire_6232 = &"VDD" @WIRE(mode="straight") {#"I1529":3 %p3047};
//   %p3048 = (-4, -546);
//   %p3049 = (-4, -544);
//   %wire_6233 = &"VDD" @WIRE(mode="straight") {%p3048 %p3049};
//   %wire_6234 = &"VDD" @WIRE(mode="straight") {#"M82":4 %p3048};
//   %wire_6235 = &"VDD" @WIRE(mode="straight") {#"M82":3 %p3049};
//   %p3050 = (-6, -542);
//   %wire_6236 = &"VDD" @WIRE(mode="straight") {#"M82":3 %p3050};
//   %p3051 = (-16, -540);
//   %wire_6237 = &"VDD" @WIRE(mode="straight") {#"I1525":4 %p3051};
//   %p3052 = (-8, -542);
//   %wire_6238 = &"VDD" @WIRE(mode="straight") {%p3052 %p3050};
//   %p3053 = (-20, -581);
//   %p3054 = (-20, -579);
//   %wire_6239 = &"VDD" @WIRE(mode="straight") {%p3053 %p3054};
//   %wire_6240 = &"VDD" @WIRE(mode="straight") {#"M81":3 %p3054};
//   %wire_6241 = &"VDD" @WIRE(mode="straight") {#"M81":4 %p3053};
//   %p3055 = (-18, -577);
//   %wire_6242 = &"VDD" @WIRE(mode="straight") {#"M81":3 %p3055};
//   %p3056 = (-8, -575);
//   %wire_6243 = &"VDD" @WIRE(mode="straight") {#"I1518":4 %p3056};
//   %p3057 = (-16, -577);
//   %wire_6244 = &"VDD" @WIRE(mode="straight") {%p3057 %p3055};
//   %p3058 = (-32, -549);
//   %wire_6245 = &"VDD" @WIRE(mode="straight") {#"I1520":3 %p3058};
//   %p3059 = (-16, -87);
//   %p3060 = (-18, -87);
//   %wire_6246 = &"VDD" @WIRE(mode="straight") {%p3059 %p3060};
//   %p3061 = (-8, -15);
//   %wire_6247 = &"VDD" @WIRE(mode="straight") {#"I1461":4 %p3061};
//   %p3062 = (-44, -549);
//   %wire_6248 = &"VDD" @WIRE(mode="straight") {#"I1524":4 %p3062};
//   %p3063 = (-55, -444);
//   %wire_6249 = &"VDD" @WIRE(mode="straight") {#"I1505":3 %p3063};
//   %p3064 = (207, 4);
//   %wire_6250 = &"VDD" @WIRE(mode="straight") {#"M66":4 %p3064};
//   %p3065 = (207, -31);
//   %wire_6251 = &"VDD" @WIRE(mode="straight") {#"M65":4 %p3065};
//   %p3066 = (207, -66);
//   %wire_6252 = &"VDD" @WIRE(mode="straight") {#"M64":4 %p3066};
//   %p3067 = (207, -101);
//   %wire_6253 = &"VDD" @WIRE(mode="straight") {#"M63":4 %p3067};
//   %p3068 = (207, -136);
//   %wire_6254 = &"VDD" @WIRE(mode="straight") {#"M62":4 %p3068};
//   %p3069 = (-6, -402);
//   %wire_6255 = &"VDD" @WIRE(mode="straight") {#"M78":3 %p3069};
//   %p3070 = (207, -171);
//   %wire_6256 = &"VDD" @WIRE(mode="straight") {#"M61":4 %p3070};
//   %p3071 = (207, -206);
//   %wire_6257 = &"VDD" @WIRE(mode="straight") {#"M60":4 %p3071};
//   %p3072 = (-32, -584);
//   %wire_6258 = &"VDD" @WIRE(mode="straight") {#"I1519":3 %p3072};
//   %p3073 = (-16, 20);
//   %wire_6259 = &"VDD" @WIRE(mode="straight") {#"I1460":4 %p3073};
//   %p3074 = (-4, -406);
//   %wire_6260 = &"VDD" @WIRE(mode="straight") {#"M78":4 %p3074};
//   %p3075 = (207, -241);
//   %wire_6261 = &"VDD" @WIRE(mode="straight") {#"M59":4 %p3075};
//   %p3076 = (207, -276);
//   %wire_6262 = &"VDD" @WIRE(mode="straight") {#"M58":4 %p3076};
//   %p3077 = (207, -311);
//   %wire_6263 = &"VDD" @WIRE(mode="straight") {#"M57":4 %p3077};
//   %p3078 = (207, -346);
//   %wire_6264 = &"VDD" @WIRE(mode="straight") {#"M56":4 %p3078};
//   %p3079 = (207, -381);
//   %wire_6265 = &"VDD" @WIRE(mode="straight") {#"M55":4 %p3079};
//   %p3080 = (207, -416);
//   %wire_6266 = &"VDD" @WIRE(mode="straight") {#"M54":4 %p3080};
//   %p3081 = (207, -451);
//   %wire_6267 = &"VDD" @WIRE(mode="straight") {#"M53":4 %p3081};
//   %p3082 = (207, -486);
//   %wire_6268 = &"VDD" @WIRE(mode="straight") {#"M52":4 %p3082};
//   %p3083 = (207, -521);
//   %wire_6269 = &"VDD" @WIRE(mode="straight") {#"M51":4 %p3083};
//   %p3084 = (207, -556);
//   %wire_6270 = &"VDD" @WIRE(mode="straight") {#"M50":4 %p3084};
//   %p3085 = (437, -736);
//   %wire_6271 = &"VDD" @WIRE(mode="straight") {#"I1224":3 %p3085};
//   %p3086 = (416, -753);
//   %wire_6272 = &"VDD" @WIRE(mode="straight") {#"I1223":3 %p3086};
//   %p3087 = (121, -757);
//   %wire_6273 = &"VDD" @WIRE(mode="straight") {%p3087 #"I1624":4};
//   %p3088 = (59, -757);
//   %wire_6274 = &"VDD" @WIRE(mode="straight") {%p3088 #"I1622":4};
//   %p3089 = (83, -757);
//   %wire_6275 = &"VDD" @WIRE(mode="straight") {%p3089 #"I1623":4};
//   %p3090 = (362, -757);
//   %wire_6276 = &"VDD" @WIRE(mode="straight") {%p3090 #"I1220":4};
//   %p3091 = (35, -757);
//   %wire_6277 = &"VDD" @WIRE(mode="straight") {%p3091 #"I1621":4};
//   %p3092 = (386, -757);
//   %wire_6278 = &"VDD" @WIRE(mode="straight") {%p3092 #"I1215":4};
//   %p3093 = (314, -757);
//   %wire_6279 = &"VDD" @WIRE(mode="straight") {%p3093 #"I1213":4};
//   %p3094 = (145, -757);
//   %wire_6280 = &"VDD" @WIRE(mode="straight") {%p3094 #"I1625":4};
//   %p3095 = (338, -757);
//   %wire_6281 = &"VDD" @WIRE(mode="straight") {%p3095 #"I1218":4};
//   %p3096 = (242, -757);
//   %wire_6282 = &"VDD" @WIRE(mode="straight") {%p3096 #"I1207":4};
//   %p3097 = (301, -757);
//   %wire_6283 = &"VDD" @WIRE(mode="straight") {%p3097 #"I1630":4};
//   %p3098 = (218, -757);
//   %wire_6284 = &"VDD" @WIRE(mode="straight") {%p3098 #"I1212":4};
//   %p3099 = (290, -757);
//   %wire_6285 = &"VDD" @WIRE(mode="straight") {%p3099 #"I1210":4};
//   %p3100 = (266, -757);
//   %wire_6286 = &"VDD" @WIRE(mode="straight") {%p3100 #"I1205":4};
//   %p3101 = (253, -757);
//   %wire_6287 = &"VDD" @WIRE(mode="straight") {%p3101 #"I1628":4};
//   %p3102 = (277, -757);
//   %wire_6288 = &"VDD" @WIRE(mode="straight") {%p3102 #"I1629":4};
//   %p3103 = (193, -757);
//   %wire_6289 = &"VDD" @WIRE(mode="straight") {%p3103 #"I1626":4};
//   %p3104 = (229, -757);
//   %wire_6290 = &"VDD" @WIRE(mode="straight") {%p3104 #"I1627":4};
//   %p3105 = (397, -757);
//   %wire_6291 = &"VDD" @WIRE(mode="straight") {%p3105 #"I1634":4};
//   %p3106 = (416, -769);
//   %wire_6292 = &"VDD" @WIRE(mode="straight") {#"I1637":3 %p3106};
//   %p3107 = (349, -757);
//   %wire_6293 = &"VDD" @WIRE(mode="straight") {%p3107 #"I1632":4};
//   %p3108 = (373, -757);
//   %wire_6294 = &"VDD" @WIRE(mode="straight") {%p3108 #"I1633":4};
//   %p3109 = (158, -757);
//   %wire_6295 = &"VDD" @WIRE(mode="straight") {%p3109 #"I1204":4};
//   %p3110 = (209, -790);
//   %wire_6296 = &"VDD" @WIRE(mode="straight") {%p3110 #"I1456":3};
//   %p3111 = (325, -757);
//   %wire_6297 = &"VDD" @WIRE(mode="straight") {%p3111 #"I1631":4};
//   %p3112 = (182, -757);
//   %wire_6298 = &"VDD" @WIRE(mode="straight") {%p3112 #"I1199":4};
//   %p3113 = (414, -701);
//   %wire_6299 = &"VDD" @WIRE(mode="straight") {#"I1182":3 %p3113};
//   %p3114 = (402, -686);
//   %wire_6300 = &"VDD" @WIRE(mode="straight") {#"I1183":8 %p3114};
//   %p3115 = (378, -686);
//   %wire_6301 = &"VDD" @WIRE(mode="straight") {#"I1184":8 %p3115};
//   %p3116 = (40, -161);
//   %wire_6302 = &"VDD" @WIRE(mode="straight") {#"I1280":8 %p3116};
//   %p3117 = (354, -686);
//   %wire_6303 = &"VDD" @WIRE(mode="straight") {#"I1185":8 %p3117};
//   %p3118 = (16, -161);
//   %wire_6304 = &"VDD" @WIRE(mode="straight") {#"I1281":8 %p3118};
//   %p3119 = (-44, 81);
//   %wire_6305 = &"VDD" @WIRE(mode="straight") {#"I1551":4 %p3119};
//   %p3120 = (330, -686);
//   %wire_6306 = &"VDD" @WIRE(mode="straight") {#"I1186":8 %p3120};
//   %p3121 = (306, -231);
//   %wire_6307 = &"VDD" @WIRE(mode="straight") {#"I1307":8 %p3121};
//   %p3122 = (402, -91);
//   %wire_6308 = &"VDD" @WIRE(mode="straight") {#"I1277":8 %p3122};
//   %p3123 = (306, -686);
//   %wire_6309 = &"VDD" @WIRE(mode="straight") {#"I1187":8 %p3123};
//   %p3124 = (378, -91);
//   %wire_6310 = &"VDD" @WIRE(mode="straight") {#"I1276":8 %p3124};
//   %p3125 = (16, -91);
//   %wire_6311 = &"VDD" @WIRE(mode="straight") {#"I1264":8 %p3125};
//   %p3126 = (282, -686);
//   %wire_6312 = &"VDD" @WIRE(mode="straight") {#"I1188":8 %p3126};
//   %p3127 = (354, -91);
//   %wire_6313 = &"VDD" @WIRE(mode="straight") {#"I1275":8 %p3127};
//   %p3128 = (258, -686);
//   %wire_6314 = &"VDD" @WIRE(mode="straight") {#"I1169":8 %p3128};
//   %p3129 = (330, -91);
//   %wire_6315 = &"VDD" @WIRE(mode="straight") {#"I1274":8 %p3129};
//   %p3130 = (64, -161);
//   %wire_6316 = &"VDD" @WIRE(mode="straight") {#"I1279":8 %p3130};
//   %p3131 = (234, -686);
//   %wire_6317 = &"VDD" @WIRE(mode="straight") {#"I1170":8 %p3131};
//   %p3132 = (306, -91);
//   %wire_6318 = &"VDD" @WIRE(mode="straight") {#"I1273":8 %p3132};
//   %p3133 = (282, -91);
//   %wire_6319 = &"VDD" @WIRE(mode="straight") {#"I1272":8 %p3133};
//   %p3134 = (198, -686);
//   %wire_6320 = &"VDD" @WIRE(mode="straight") {#"I1171":8 %p3134};
//   %p3135 = (258, -91);
//   %wire_6321 = &"VDD" @WIRE(mode="straight") {#"I1265":8 %p3135};
//   %p3136 = (174, -686);
//   %wire_6322 = &"VDD" @WIRE(mode="straight") {#"I1172":8 %p3136};
//   %p3137 = (414, -106);
//   %wire_6323 = &"VDD" @WIRE(mode="straight") {#"I1271":3 %p3137};
//   %p3138 = (150, -686);
//   %wire_6324 = &"VDD" @WIRE(mode="straight") {#"I1173":8 %p3138};
//   %p3139 = (234, -91);
//   %wire_6325 = &"VDD" @WIRE(mode="straight") {#"I1270":8 %p3139};
//   %p3140 = (198, -91);
//   %wire_6326 = &"VDD" @WIRE(mode="straight") {#"I1269":8 %p3140};
//   %p3141 = (40, -91);
//   %wire_6327 = &"VDD" @WIRE(mode="straight") {#"I1263":8 %p3141};
//   %p3142 = (126, -686);
//   %wire_6328 = &"VDD" @WIRE(mode="straight") {#"I1174":8 %p3142};
//   %p3143 = (174, -91);
//   %wire_6329 = &"VDD" @WIRE(mode="straight") {#"I1268":8 %p3143};
//   %p3144 = (88, -686);
//   %wire_6330 = &"VDD" @WIRE(mode="straight") {#"I1162":8 %p3144};
//   %p3145 = (150, -91);
//   %wire_6331 = &"VDD" @WIRE(mode="straight") {#"I1267":8 %p3145};
//   %p3146 = (64, -686);
//   %wire_6332 = &"VDD" @WIRE(mode="straight") {#"I1161":8 %p3146};
//   %p3147 = (126, -91);
//   %wire_6333 = &"VDD" @WIRE(mode="straight") {#"I1266":8 %p3147};
//   %p3148 = (40, -686);
//   %wire_6334 = &"VDD" @WIRE(mode="straight") {#"I1160":8 %p3148};
//   %p3149 = (16, -686);
//   %wire_6335 = &"VDD" @WIRE(mode="straight") {#"I1159":8 %p3149};
//   %p3150 = (64, -91);
//   %wire_6336 = &"VDD" @WIRE(mode="straight") {#"I1262":8 %p3150};
//   %p3151 = (88, -91);
//   %wire_6337 = &"VDD" @WIRE(mode="straight") {#"I1261":8 %p3151};
//   %p3152 = (-32, -59);
//   %wire_6338 = &"VDD" @WIRE(mode="straight") {#"I1464":3 %p3152};
//   %p3153 = (-32, -94);
//   %wire_6339 = &"VDD" @WIRE(mode="straight") {#"I1463":3 %p3153};
//   %p3154 = (-55, -549);
//   %wire_6340 = &"VDD" @WIRE(mode="straight") {#"I1523":3 %p3154};
//   %p3155 = (-32, -514);
//   %wire_6341 = &"VDD" @WIRE(mode="straight") {#"I1511":3 %p3155};
//   %p3156 = (-44, -24);
//   %wire_6342 = &"VDD" @WIRE(mode="straight") {#"I1432":4 %p3156};
//   %p3157 = (-55, -59);
//   %wire_6343 = &"VDD" @WIRE(mode="straight") {#"I1467":3 %p3157};
//   %p3158 = (-55, -94);
//   %wire_6344 = &"VDD" @WIRE(mode="straight") {#"I1465":3 %p3158};
//   %p3159 = (414, -631);
//   %wire_6345 = &"VDD" @WIRE(mode="straight") {#"I1142":3 %p3159};
//   %p3160 = (150, -231);
//   %wire_6346 = &"VDD" @WIRE(mode="straight") {#"I1301":8 %p3160};
//   %p3161 = (402, -616);
//   %wire_6347 = &"VDD" @WIRE(mode="straight") {#"I1143":8 %p3161};
//   %p3162 = (437, -710);
//   %wire_6348 = &"VDD" @WIRE(mode="straight") {#"I1260":4 %p3162};
//   %p3163 = (378, -616);
//   %wire_6349 = &"VDD" @WIRE(mode="straight") {#"I1144":8 %p3163};
//   %p3164 = (126, -231);
//   %wire_6350 = &"VDD" @WIRE(mode="straight") {#"I1300":8 %p3164};
//   %p3165 = (354, -616);
//   %wire_6351 = &"VDD" @WIRE(mode="straight") {#"I1145":8 %p3165};
//   %p3166 = (88, -231);
//   %wire_6352 = &"VDD" @WIRE(mode="straight") {#"I1295":8 %p3166};
//   %p3167 = (330, -616);
//   %wire_6353 = &"VDD" @WIRE(mode="straight") {#"I1146":8 %p3167};
//   %p3168 = (88, -161);
//   %wire_6354 = &"VDD" @WIRE(mode="straight") {#"I1278":8 %p3168};
//   %p3169 = (174, -301);
//   %wire_6355 = &"VDD" @WIRE(mode="straight") {#"I1319":8 %p3169};
//   %p3170 = (40, -231);
//   %wire_6356 = &"VDD" @WIRE(mode="straight") {#"I1297":8 %p3170};
//   %p3171 = (306, -616);
//   %wire_6357 = &"VDD" @WIRE(mode="straight") {#"I1147":8 %p3171};
//   %p3172 = (64, -231);
//   %wire_6358 = &"VDD" @WIRE(mode="straight") {#"I1296":8 %p3172};
//   %p3173 = (16, -231);
//   %wire_6359 = &"VDD" @WIRE(mode="straight") {#"I1298":8 %p3173};
//   %p3174 = (282, -616);
//   %wire_6360 = &"VDD" @WIRE(mode="straight") {#"I1148":8 %p3174};
//   %p3175 = (414, -176);
//   %wire_6361 = &"VDD" @WIRE(mode="straight") {#"I1288":3 %p3175};
//   %p3176 = (258, -616);
//   %wire_6362 = &"VDD" @WIRE(mode="straight") {#"I1129":8 %p3176};
//   %p3177 = (402, -161);
//   %wire_6363 = &"VDD" @WIRE(mode="straight") {#"I1294":8 %p3177};
//   %p3178 = (378, -161);
//   %wire_6364 = &"VDD" @WIRE(mode="straight") {#"I1293":8 %p3178};
//   %p3179 = (234, -616);
//   %wire_6365 = &"VDD" @WIRE(mode="straight") {#"I1130":8 %p3179};
//   %p3180 = (354, -161);
//   %wire_6366 = &"VDD" @WIRE(mode="straight") {#"I1292":8 %p3180};
//   %p3181 = (198, -616);
//   %wire_6367 = &"VDD" @WIRE(mode="straight") {#"I1131":8 %p3181};
//   %p3182 = (330, -161);
//   %wire_6368 = &"VDD" @WIRE(mode="straight") {#"I1291":8 %p3182};
//   %p3183 = (174, -616);
//   %wire_6369 = &"VDD" @WIRE(mode="straight") {#"I1132":8 %p3183};
//   %p3184 = (306, -161);
//   %wire_6370 = &"VDD" @WIRE(mode="straight") {#"I1290":8 %p3184};
//   %p3185 = (150, -616);
//   %wire_6371 = &"VDD" @WIRE(mode="straight") {#"I1133":8 %p3185};
//   %p3186 = (258, -161);
//   %wire_6372 = &"VDD" @WIRE(mode="straight") {#"I1282":8 %p3186};
//   %p3187 = (282, -161);
//   %wire_6373 = &"VDD" @WIRE(mode="straight") {#"I1289":8 %p3187};
//   %p3188 = (126, -161);
//   %wire_6374 = &"VDD" @WIRE(mode="straight") {#"I1283":8 %p3188};
//   %p3189 = (126, -616);
//   %wire_6375 = &"VDD" @WIRE(mode="straight") {#"I1134":8 %p3189};
//   %p3190 = (88, -616);
//   %wire_6376 = &"VDD" @WIRE(mode="straight") {#"I1122":8 %p3190};
//   %p3191 = (234, -161);
//   %wire_6377 = &"VDD" @WIRE(mode="straight") {#"I1287":8 %p3191};
//   %p3192 = (64, -616);
//   %wire_6378 = &"VDD" @WIRE(mode="straight") {#"I1121":8 %p3192};
//   %p3193 = (198, -161);
//   %wire_6379 = &"VDD" @WIRE(mode="straight") {#"I1286":8 %p3193};
//   %p3194 = (40, -616);
//   %wire_6380 = &"VDD" @WIRE(mode="straight") {#"I1120":8 %p3194};
//   %p3195 = (174, -161);
//   %wire_6381 = &"VDD" @WIRE(mode="straight") {#"I1285":8 %p3195};
//   %p3196 = (16, -616);
//   %wire_6382 = &"VDD" @WIRE(mode="straight") {#"I1119":8 %p3196};
//   %p3197 = (150, -161);
//   %wire_6383 = &"VDD" @WIRE(mode="straight") {#"I1284":8 %p3197};
//   %p3198 = (-44, -129);
//   %wire_6384 = &"VDD" @WIRE(mode="straight") {#"I1476":4 %p3198};
//   %p3199 = (-44, -164);
//   %wire_6385 = &"VDD" @WIRE(mode="straight") {#"I1474":4 %p3199};
//   %p3200 = (-55, -129);
//   %wire_6386 = &"VDD" @WIRE(mode="straight") {#"I1475":3 %p3200};
//   %p3201 = (-32, -409);
//   %wire_6387 = &"VDD" @WIRE(mode="straight") {#"I1504":3 %p3201};
//   %p3202 = (-32, -479);
//   %wire_6388 = &"VDD" @WIRE(mode="straight") {#"I1512":3 %p3202};
//   %p3203 = (-4, -54);
//   %wire_6389 = &"VDD" @WIRE(mode="straight") {#"M68":3 %p3203};
//   %p3204 = (-6, -52);
//   %wire_6390 = &"VDD" @WIRE(mode="straight") {#"M68":3 %p3204};
//   %p3205 = (-16, -50);
//   %wire_6391 = &"VDD" @WIRE(mode="straight") {#"I1469":4 %p3205};
//   %p3206 = (414, -561);
//   %wire_6392 = &"VDD" @WIRE(mode="straight") {#"I1102":3 %p3206};
//   %p3207 = (402, -546);
//   %wire_6393 = &"VDD" @WIRE(mode="straight") {#"I1103":8 %p3207};
//   %p3208 = (330, -231);
//   %wire_6394 = &"VDD" @WIRE(mode="straight") {#"I1308":8 %p3208};
//   %p3209 = (234, -301);
//   %wire_6395 = &"VDD" @WIRE(mode="straight") {#"I1321":8 %p3209};
//   %p3210 = (378, -546);
//   %wire_6396 = &"VDD" @WIRE(mode="straight") {#"I1104":8 %p3210};
//   %p3211 = (207, -626);
//   %wire_6397 = &"VDD" @WIRE(mode="straight") {#"M47":4 %p3211};
//   %p3212 = (207, -661);
//   %wire_6398 = &"VDD" @WIRE(mode="straight") {#"M46":4 %p3212};
//   %p3213 = (198, -301);
//   %wire_6399 = &"VDD" @WIRE(mode="straight") {#"I1320":8 %p3213};
//   %p3214 = (354, -546);
//   %wire_6400 = &"VDD" @WIRE(mode="straight") {#"I1105":8 %p3214};
//   %p3215 = (174, -231);
//   %wire_6401 = &"VDD" @WIRE(mode="straight") {#"I1302":8 %p3215};
//   %p3216 = (330, -546);
//   %wire_6402 = &"VDD" @WIRE(mode="straight") {#"I1106":8 %p3216};
//   %p3217 = (-32, -24);
//   %wire_6403 = &"VDD" @WIRE(mode="straight") {#"I769":3 %p3217};
//   %p3218 = (-20, -511);
//   %wire_6404 = &"VDD" @WIRE(mode="straight") {#"M79":4 %p3218};
//   %p3219 = (99, -661);
//   %wire_6405 = &"VDD" @WIRE(mode="straight") {#"M41":4 %p3219};
//   %p3220 = (-6, -472);
//   %wire_6406 = &"VDD" @WIRE(mode="straight") {#"M80":3 %p3220};
//   %p3221 = (-55, -584);
//   %wire_6407 = &"VDD" @WIRE(mode="straight") {#"I1521":3 %p3221};
//   %p3222 = (306, -721);
//   %wire_6408 = &"VDD" @WIRE(mode="straight") {#"I1426":8 %p3222};
//   %p3223 = (-44, -584);
//   %wire_6409 = &"VDD" @WIRE(mode="straight") {#"I1522":4 %p3223};
//   %p3224 = (-55, -479);
//   %wire_6410 = &"VDD" @WIRE(mode="straight") {#"I1515":3 %p3224};
//   %p3225 = (-4, -404);
//   %wire_6411 = &"VDD" @WIRE(mode="straight") {#"M78":3 %p3225};
//   %p3226 = (99, -591);
//   %wire_6412 = &"VDD" @WIRE(mode="straight") {#"M39":4 %p3226};
//   %p3227 = (-20, -441);
//   %wire_6413 = &"VDD" @WIRE(mode="straight") {#"M77":4 %p3227};
//   %p3228 = (378, -126);
//   %wire_6414 = &"VDD" @WIRE(mode="straight") {#"I864":8 %p3228};
//   %p3229 = (330, -651);
//   %wire_6415 = &"VDD" @WIRE(mode="straight") {#"I1410":8 %p3229};
//   %p3230 = (-20, -439);
//   %wire_6416 = &"VDD" @WIRE(mode="straight") {%p3227 %p3230};
//   %p3231 = (-4, -476);
//   %wire_6417 = &"VDD" @WIRE(mode="straight") {#"M80":4 %p3231};
//   %wire_6418 = &"VDD" @WIRE(mode="straight") {#"M77":3 %p3230};
//   %p3232 = (378, -196);
//   %wire_6419 = &"VDD" @WIRE(mode="straight") {#"I904":8 %p3232};
//   %p3233 = (174, -371);
//   %wire_6420 = &"VDD" @WIRE(mode="straight") {#"I1336":8 %p3233};
//   %p3234 = (72, -757);
//   %wire_6421 = &"VDD" @WIRE(mode="straight") {%p3234 #"I1195":4};
//   %p3235 = (40, -126);
//   %wire_6422 = &"VDD" @WIRE(mode="straight") {#"I840":8 %p3235};
//   %p3236 = (402, -441);
//   %wire_6423 = &"VDD" @WIRE(mode="straight") {#"I1362":8 %p3236};
//   %p3237 = (-55, 81);
//   %wire_6424 = &"VDD" @WIRE(mode="straight") {#"I1550":3 %p3237};
//   %p3238 = (126, -406);
//   %wire_6425 = &"VDD" @WIRE(mode="straight") {#"I1014":8 %p3238};
//   %p3239 = (-4, -336);
//   %wire_6426 = &"VDD" @WIRE(mode="straight") {#"M76":4 %p3239};
//   %p3240 = (-20, -161);
//   %wire_6427 = &"VDD" @WIRE(mode="straight") {#"M69":4 %p3240};
//   %p3241 = (-20, -159);
//   %wire_6428 = &"VDD" @WIRE(mode="straight") {#"M69":3 %p3241};
//   %wire_6429 = &"VDD" @WIRE(mode="straight") {%p3240 %p3241};
//   %p3242 = (-8, -52);
//   %wire_6430 = &"VDD" @WIRE(mode="straight") {%p3242 %p3204};
//   %p3243 = (24, -757);
//   %wire_6431 = &"VDD" @WIRE(mode="straight") {%p3243 #"I1191":4};
//   %p3244 = (88, -406);
//   %wire_6432 = &"VDD" @WIRE(mode="straight") {#"I1002":8 %p3244};
//   %p3245 = (126, -266);
//   %wire_6433 = &"VDD" @WIRE(mode="straight") {#"I934":8 %p3245};
//   %p3246 = (330, -406);
//   %wire_6434 = &"VDD" @WIRE(mode="straight") {#"I1026":8 %p3246};
//   %p3247 = (48, -757);
//   %wire_6435 = &"VDD" @WIRE(mode="straight") {%p3247 #"I1193":4};
//   %p3248 = (402, -651);
//   %wire_6436 = &"VDD" @WIRE(mode="straight") {#"I1413":8 %p3248};
//   %p3249 = (258, -581);
//   %wire_6437 = &"VDD" @WIRE(mode="straight") {#"I1384":8 %p3249};
//   %p3250 = (126, -546);
//   %wire_6438 = &"VDD" @WIRE(mode="straight") {#"I1094":8 %p3250};
//   %p3251 = (64, -546);
//   %wire_6439 = &"VDD" @WIRE(mode="straight") {#"I1081":8 %p3251};
//   %p3252 = (-8, -122);
//   %p3253 = (-6, -122);
//   %wire_6440 = &"VDD" @WIRE(mode="straight") {%p3252 %p3253};
//   %p3254 = (354, -476);
//   %wire_6441 = &"VDD" @WIRE(mode="straight") {#"I1065":8 %p3254};
//   %p3255 = (198, -371);
//   %wire_6442 = &"VDD" @WIRE(mode="straight") {#"I1337":8 %p3255};
//   %p3256 = (174, -476);
//   %wire_6443 = &"VDD" @WIRE(mode="straight") {#"I1052":8 %p3256};
//   %p3257 = (330, -301);
//   %wire_6444 = &"VDD" @WIRE(mode="straight") {#"I1325":8 %p3257};
//   %p3258 = (64, -371);
//   %wire_6445 = &"VDD" @WIRE(mode="straight") {#"I1330":8 %p3258};
//   %p3259 = (414, -421);
//   %wire_6446 = &"VDD" @WIRE(mode="straight") {#"I1022":3 %p3259};
//   %p3260 = (101, -779);
//   %wire_6447 = &"VDD" @WIRE(mode="straight") {%p3260 #"I1454":3};
//   %p3261 = (16, -336);
//   %wire_6448 = &"VDD" @WIRE(mode="straight") {#"I959":8 %p3261};
//   %p3262 = (198, -581);
//   %wire_6449 = &"VDD" @WIRE(mode="straight") {#"I1388":8 %p3262};
//   %p3263 = (64, -651);
//   %wire_6450 = &"VDD" @WIRE(mode="straight") {#"I1398":8 %p3263};
//   %p3264 = (150, -266);
//   %wire_6451 = &"VDD" @WIRE(mode="straight") {#"I933":8 %p3264};
//   %p3265 = (110, -757);
//   %wire_6452 = &"VDD" @WIRE(mode="straight") {%p3265 #"I1197":4};
//   %p3266 = (414, -281);
//   %wire_6453 = &"VDD" @WIRE(mode="straight") {#"I942":3 %p3266};
//   %p3267 = (134, -757);
//   %wire_6454 = &"VDD" @WIRE(mode="straight") {%p3267 #"I1202":4};
//   %p3268 = (-20, -19);
//   %wire_6455 = &"VDD" @WIRE(mode="straight") {#"M1":3 %p3268};
//   %p3269 = (-20, -21);
//   %wire_6456 = &"VDD" @WIRE(mode="straight") {%p3269 %p3268};
//   %wire_6457 = &"VDD" @WIRE(mode="straight") {#"M1":4 %p3269};
//   %p3270 = (-16, -17);
//   %p3271 = (-18, -17);
//   %wire_6458 = &"VDD" @WIRE(mode="straight") {%p3270 %p3271};
//   %wire_6459 = &"VDD" @WIRE(mode="straight") {#"M1":3 %p3271};
//   %p3272 = (-44, 11);
//   %wire_6460 = &"VDD" @WIRE(mode="straight") {#"I411":4 %p3272};
//   %p3273 = (-55, 11);
//   %wire_6461 = &"VDD" @WIRE(mode="straight") {#"I767":3 %p3273};
//   %p3274 = (-32, 11);
//   %wire_6462 = &"VDD" @WIRE(mode="straight") {#"I412":3 %p3274};
//   %p3275 = (-44, -514);
//   %wire_6463 = &"VDD" @WIRE(mode="straight") {#"I1514":4 %p3275};
//   %p3276 = (99, -521);
//   %wire_6464 = &"VDD" @WIRE(mode="straight") {#"M37":4 %p3276};
//   %p3277 = (150, 14);
//   %wire_6465 = &"VDD" @WIRE(mode="straight") {#"I525":8 %p3277};
//   %p3278 = (64, 14);
//   %wire_6466 = &"VDD" @WIRE(mode="straight") {#"I459":8 %p3278};
//   %p3279 = (88, 14);
//   %wire_6467 = &"VDD" @WIRE(mode="straight") {#"I481":8 %p3279};
//   %p3280 = (126, 14);
//   %wire_6468 = &"VDD" @WIRE(mode="straight") {#"I503":8 %p3280};
//   %p3281 = (198, 14);
//   %wire_6469 = &"VDD" @WIRE(mode="straight") {#"I569":8 %p3281};
//   %p3282 = (174, 14);
//   %wire_6470 = &"VDD" @WIRE(mode="straight") {#"I547":8 %p3282};
//   %p3283 = (402, -56);
//   %wire_6471 = &"VDD" @WIRE(mode="straight") {#"I823":8 %p3283};
//   %p3284 = (101, -790);
//   %wire_6472 = &"VDD" @WIRE(mode="straight") {%p3284 #"I1221":3};
//   %p3285 = (198, -721);
//   %wire_6473 = &"VDD" @WIRE(mode="straight") {#"I1422":8 %p3285};
//   %p3286 = (-16, -507);
//   %p3287 = (-18, -507);
//   %wire_6474 = &"VDD" @WIRE(mode="straight") {%p3286 %p3287};
//   %p3288 = (88, -476);
//   %wire_6475 = &"VDD" @WIRE(mode="straight") {#"I1042":8 %p3288};
//   %p3289 = (-8, -155);
//   %wire_6476 = &"VDD" @WIRE(mode="straight") {#"I1470":4 %p3289};
//   %p3290 = (378, -441);
//   %wire_6477 = &"VDD" @WIRE(mode="straight") {#"I1361":8 %p3290};
//   %p3291 = (150, -476);
//   %wire_6478 = &"VDD" @WIRE(mode="straight") {#"I1053":8 %p3291};
//   %p3292 = (234, -441);
//   %wire_6479 = &"VDD" @WIRE(mode="straight") {#"I1355":8 %p3292};
//   %p3293 = (150, -511);
//   %wire_6480 = &"VDD" @WIRE(mode="straight") {#"I1369":8 %p3293};
//   %p3294 = (0, -757);
//   %wire_6481 = &"VDD" @WIRE(mode="straight") {%p3294 #"I1189":4};
//   %p3295 = (414, -141);
//   %wire_6482 = &"VDD" @WIRE(mode="straight") {#"I862":3 %p3295};
//   %p3296 = (64, -721);
//   %wire_6483 = &"VDD" @WIRE(mode="straight") {#"I1415":8 %p3296};
//   %p3297 = (-20, -509);
//   %wire_6484 = &"VDD" @WIRE(mode="straight") {%p3218 %p3297};
//   %p3298 = (99, -451);
//   %wire_6485 = &"VDD" @WIRE(mode="straight") {#"M35":4 %p3298};
//   %p3299 = (330, -56);
//   %wire_6486 = &"VDD" @WIRE(mode="straight") {#"I826":8 %p3299};
//   %p3300 = (282, -56);
//   %wire_6487 = &"VDD" @WIRE(mode="straight") {#"I828":8 %p3300};
//   %p3301 = (99, -626);
//   %wire_6488 = &"VDD" @WIRE(mode="straight") {#"M40":4 %p3301};
//   %p3302 = (16, 14);
//   %wire_6489 = &"VDD" @WIRE(mode="straight") {#"I415":8 %p3302};
//   %p3303 = (330, -336);
//   %wire_6490 = &"VDD" @WIRE(mode="straight") {#"I986":8 %p3303};
//   %p3304 = (354, -56);
//   %wire_6491 = &"VDD" @WIRE(mode="straight") {#"I825":8 %p3304};
//   %p3305 = (378, -21);
//   %wire_6492 = &"VDD" @WIRE(mode="straight") {#"I784":8 %p3305};
//   %p3306 = (126, -126);
//   %wire_6493 = &"VDD" @WIRE(mode="straight") {#"I854":8 %p3306};
//   %p3307 = (198, -126);
//   %wire_6494 = &"VDD" @WIRE(mode="straight") {#"I851":8 %p3307};
//   %p3308 = (-44, -409);
//   %wire_6495 = &"VDD" @WIRE(mode="straight") {#"I1508":4 %p3308};
//   %p3309 = (258, -651);
//   %wire_6496 = &"VDD" @WIRE(mode="straight") {#"I1401":8 %p3309};
//   %p3310 = (150, -196);
//   %wire_6497 = &"VDD" @WIRE(mode="straight") {#"I893":8 %p3310};
//   %p3311 = (282, -266);
//   %wire_6498 = &"VDD" @WIRE(mode="straight") {#"I948":8 %p3311};
//   %p3312 = (174, -266);
//   %wire_6499 = &"VDD" @WIRE(mode="straight") {#"I932":8 %p3312};
//   %p3313 = (234, -581);
//   %wire_6500 = &"VDD" @WIRE(mode="straight") {#"I1389":8 %p3313};
//   %p3314 = (174, -581);
//   %wire_6501 = &"VDD" @WIRE(mode="straight") {#"I1387":8 %p3314};
//   %p3315 = (16, -651);
//   %wire_6502 = &"VDD" @WIRE(mode="straight") {#"I1400":8 %p3315};
//   %p3316 = (88, -266);
//   %wire_6503 = &"VDD" @WIRE(mode="straight") {#"I922":8 %p3316};
//   %p3317 = (99, -171);
//   %wire_6504 = &"VDD" @WIRE(mode="straight") {#"M27":4 %p3317};
//   %p3318 = (198, -336);
//   %wire_6505 = &"VDD" @WIRE(mode="straight") {#"I971":8 %p3318};
//   %p3319 = (40, -581);
//   %wire_6506 = &"VDD" @WIRE(mode="straight") {#"I1382":8 %p3319};
//   %p3320 = (-55, -304);
//   %wire_6507 = &"VDD" @WIRE(mode="straight") {#"I1489":3 %p3320};
//   %p3321 = (258, -301);
//   %wire_6508 = &"VDD" @WIRE(mode="straight") {#"I1316":8 %p3321};
//   %p3322 = (378, -406);
//   %wire_6509 = &"VDD" @WIRE(mode="straight") {#"I1024":8 %p3322};
//   %p3323 = (258, 14);
//   %wire_6510 = &"VDD" @WIRE(mode="straight") {#"I613":8 %p3323};
//   %p3324 = (150, -721);
//   %wire_6511 = &"VDD" @WIRE(mode="straight") {#"I1420":8 %p3324};
//   %p3325 = (330, -266);
//   %wire_6512 = &"VDD" @WIRE(mode="straight") {#"I946":8 %p3325};
//   %p3326 = (282, -406);
//   %wire_6513 = &"VDD" @WIRE(mode="straight") {#"I1028":8 %p3326};
//   %p3327 = (-32, -199);
//   %wire_6514 = &"VDD" @WIRE(mode="straight") {#"I1480":3 %p3327};
//   %p3328 = (99, -416);
//   %wire_6515 = &"VDD" @WIRE(mode="straight") {#"M34":4 %p3328};
//   %wire_6516 = &"VDD" @WIRE(mode="straight") {#"M67":3 %p3060};
//   %p3329 = (126, -721);
//   %wire_6517 = &"VDD" @WIRE(mode="straight") {#"I1419":8 %p3329};
//   %p3330 = (402, -581);
//   %wire_6518 = &"VDD" @WIRE(mode="straight") {#"I1396":8 %p3330};
//   %p3331 = (-20, -91);
//   %wire_6519 = &"VDD" @WIRE(mode="straight") {#"M67":4 %p3331};
//   %p3332 = (258, -21);
//   %wire_6520 = &"VDD" @WIRE(mode="straight") {#"I776":8 %p3332};
//   %p3333 = (-55, -409);
//   %wire_6521 = &"VDD" @WIRE(mode="straight") {#"I1507":3 %p3333};
//   %p3334 = (174, -406);
//   %wire_6522 = &"VDD" @WIRE(mode="straight") {#"I1012":8 %p3334};
//   %p3335 = (40, -546);
//   %wire_6523 = &"VDD" @WIRE(mode="straight") {#"I1080":8 %p3335};
//   %p3336 = (40, -721);
//   %wire_6524 = &"VDD" @WIRE(mode="straight") {#"I1416":8 %p3336};
//   %p3337 = (150, -406);
//   %wire_6525 = &"VDD" @WIRE(mode="straight") {#"I1013":8 %p3337};
//   %p3338 = (-8, -85);
//   %wire_6526 = &"VDD" @WIRE(mode="straight") {#"I1462":4 %p3338};
//   %p3339 = (-20, -89);
//   %wire_6527 = &"VDD" @WIRE(mode="straight") {%p3331 %p3339};
//   %p3340 = (330, -371);
//   %wire_6528 = &"VDD" @WIRE(mode="straight") {#"I1342":8 %p3340};
//   %p3341 = (402, -301);
//   %wire_6529 = &"VDD" @WIRE(mode="straight") {#"I1328":8 %p3341};
//   %wire_6530 = &"VDD" @WIRE(mode="straight") {#"M67":3 %p3339};
//   %p3342 = (-16, -157);
//   %p3343 = (-18, -157);
//   %wire_6531 = &"VDD" @WIRE(mode="straight") {%p3342 %p3343};
//   %p3344 = (-4, -126);
//   %p3345 = (-4, -124);
//   %wire_6532 = &"VDD" @WIRE(mode="straight") {%p3344 %p3345};
//   %p3346 = (40, -406);
//   %wire_6533 = &"VDD" @WIRE(mode="straight") {#"I1000":8 %p3346};
//   %p3347 = (-32, -164);
//   %wire_6534 = &"VDD" @WIRE(mode="straight") {#"I1471":3 %p3347};
//   %p3348 = (354, -651);
//   %wire_6535 = &"VDD" @WIRE(mode="straight") {#"I1411":8 %p3348};
//   %p3349 = (-32, -129);
//   %wire_6536 = &"VDD" @WIRE(mode="straight") {#"I1472":3 %p3349};
//   %p3350 = (-4, -194);
//   %wire_6537 = &"VDD" @WIRE(mode="straight") {#"M72":3 %p3350};
//   %p3351 = (-20, -231);
//   %wire_6538 = &"VDD" @WIRE(mode="straight") {#"M71":4 %p3351};
//   %p3352 = (-18, -227);
//   %wire_6539 = &"VDD" @WIRE(mode="straight") {#"M71":3 %p3352};
//   %p3353 = (-32, -339);
//   %wire_6540 = &"VDD" @WIRE(mode="straight") {#"I1496":3 %p3353};
//   %p3354 = (-16, -297);
//   %p3355 = (-18, -297);
//   %wire_6541 = &"VDD" @WIRE(mode="straight") {%p3354 %p3355};
//   %p3356 = (354, -441);
//   %wire_6542 = &"VDD" @WIRE(mode="straight") {#"I1360":8 %p3356};
//   %p3357 = (402, -21);
//   %wire_6543 = &"VDD" @WIRE(mode="straight") {#"I783":8 %p3357};
//   %p3358 = (-44, -479);
//   %wire_6544 = &"VDD" @WIRE(mode="straight") {#"I1516":4 %p3358};
//   %p3359 = (414, -526);
//   %wire_6545 = &"VDD" @WIRE(mode="straight") {#"I1373":3 %p3359};
//   %p3360 = (354, -336);
//   %wire_6546 = &"VDD" @WIRE(mode="straight") {#"I985":8 %p3360};
//   %p3361 = (354, -21);
//   %wire_6547 = &"VDD" @WIRE(mode="straight") {#"I785":8 %p3361};
//   %p3362 = (354, -196);
//   %wire_6548 = &"VDD" @WIRE(mode="straight") {#"I905":8 %p3362};
//   %p3363 = (174, -721);
//   %wire_6549 = &"VDD" @WIRE(mode="straight") {#"I1421":8 %p3363};
//   %p3364 = (378, -231);
//   %wire_6550 = &"VDD" @WIRE(mode="straight") {#"I1310":8 %p3364};
//   %p3365 = (378, -476);
//   %wire_6551 = &"VDD" @WIRE(mode="straight") {#"I1064":8 %p3365};
//   %p3366 = (258, -371);
//   %wire_6552 = &"VDD" @WIRE(mode="straight") {#"I1333":8 %p3366};
//   %p3367 = (150, -371);
//   %wire_6553 = &"VDD" @WIRE(mode="straight") {#"I1335":8 %p3367};
//   %p3368 = (-32, -234);
//   %wire_6554 = &"VDD" @WIRE(mode="straight") {#"I1479":3 %p3368};
//   %p3369 = (282, -476);
//   %wire_6555 = &"VDD" @WIRE(mode="straight") {#"I1068":8 %p3369};
//   %p3370 = (-44, -199);
//   %wire_6556 = &"VDD" @WIRE(mode="straight") {#"I1484":4 %p3370};
//   %p3371 = (150, -651);
//   %wire_6557 = &"VDD" @WIRE(mode="straight") {#"I1403":8 %p3371};
//   %p3372 = (-55, -339);
//   %wire_6558 = &"VDD" @WIRE(mode="straight") {#"I1499":3 %p3372};
//   %p3373 = (-55, -374);
//   %wire_6559 = &"VDD" @WIRE(mode="straight") {#"I1497":3 %p3373};
//   %wire_6560 = &"VDD" @WIRE(mode="straight") {#"M70":4 %p3344};
//   %p3374 = (354, -301);
//   %wire_6561 = &"VDD" @WIRE(mode="straight") {#"I1326":8 %p3374};
//   %p3375 = (-16, -227);
//   %wire_6562 = &"VDD" @WIRE(mode="straight") {%p3375 %p3352};
//   %p3376 = (-20, -299);
//   %wire_6563 = &"VDD" @WIRE(mode="straight") {#"M73":3 %p3376};
//   %p3377 = (16, -406);
//   %wire_6564 = &"VDD" @WIRE(mode="straight") {#"I999":8 %p3377};
//   %p3378 = (-44, -234);
//   %wire_6565 = &"VDD" @WIRE(mode="straight") {#"I1482":4 %p3378};
//   %p3379 = (402, -336);
//   %wire_6566 = &"VDD" @WIRE(mode="straight") {#"I983":8 %p3379};
//   %p3380 = (-20, -301);
//   %wire_6567 = &"VDD" @WIRE(mode="straight") {%p3380 %p3376};
//   %p3381 = (414, -386);
//   %wire_6568 = &"VDD" @WIRE(mode="straight") {#"I1339":3 %p3381};
//   %p3382 = (-6, -332);
//   %wire_6569 = &"VDD" @WIRE(mode="straight") {#"M76":3 %p3382};
//   %p3383 = (-44, -269);
//   %wire_6570 = &"VDD" @WIRE(mode="straight") {#"I1492":4 %p3383};
//   %p3384 = (16, -721);
//   %wire_6571 = &"VDD" @WIRE(mode="straight") {#"I1417":8 %p3384};
//   %p3385 = (-4, -334);
//   %wire_6572 = &"VDD" @WIRE(mode="straight") {#"M76":3 %p3385};
//   %p3386 = (-32, -269);
//   %wire_6573 = &"VDD" @WIRE(mode="straight") {#"I1488":3 %p3386};
//   %wire_6574 = &"VDD" @WIRE(mode="straight") {#"M79":3 %p3287};
//   %p3387 = (88, -126);
//   %wire_6575 = &"VDD" @WIRE(mode="straight") {#"I842":8 %p3387};
//   %p3388 = (-32, -304);
//   %wire_6576 = &"VDD" @WIRE(mode="straight") {#"I1487":3 %p3388};
//   %p3389 = (-44, -339);
//   %wire_6577 = &"VDD" @WIRE(mode="straight") {#"I1500":4 %p3389};
//   %p3390 = (-4, -474);
//   %wire_6578 = &"VDD" @WIRE(mode="straight") {#"M80":3 %p3390};
//   %p3391 = (88, -21);
//   %wire_6579 = &"VDD" @WIRE(mode="straight") {#"I773":8 %p3391};
//   %p3392 = (378, -301);
//   %wire_6580 = &"VDD" @WIRE(mode="straight") {#"I1327":8 %p3392};
//   %p3393 = (-8, -365);
//   %wire_6581 = &"VDD" @WIRE(mode="straight") {#"I1494":4 %p3393};
//   %p3394 = (330, -511);
//   %wire_6582 = &"VDD" @WIRE(mode="straight") {#"I1376":8 %p3394};
//   %p3395 = (174, -336);
//   %wire_6583 = &"VDD" @WIRE(mode="straight") {#"I972":8 %p3395};
//   %p3396 = (414, -211);
//   %wire_6584 = &"VDD" @WIRE(mode="straight") {#"I902":3 %p3396};
//   %p3397 = (-44, -374);
//   %wire_6585 = &"VDD" @WIRE(mode="straight") {#"I1498":4 %p3397};
//   %wire_6586 = &"VDD" @WIRE(mode="straight") {%p3239 %p3385};
//   %p3398 = (174, -126);
//   %wire_6587 = &"VDD" @WIRE(mode="straight") {#"I852":8 %p3398};
//   %p3399 = (-6, 18);
//   %wire_6588 = &"VDD" @WIRE(mode="straight") {#"M0":3 %p3399};
//   %p3400 = (-55, -514);
//   %wire_6589 = &"VDD" @WIRE(mode="straight") {#"I1513":3 %p3400};
//   %p3401 = (-4, 16);
//   %wire_6590 = &"VDD" @WIRE(mode="straight") {#"M0":3 %p3401};
//   %p3402 = (378, -266);
//   %wire_6591 = &"VDD" @WIRE(mode="straight") {#"I944":8 %p3402};
//   %p3403 = (378, 14);
//   %wire_6592 = &"VDD" @WIRE(mode="straight") {#"I723":8 %p3403};
//   %p3404 = (-44, -59);
//   %wire_6593 = &"VDD" @WIRE(mode="straight") {#"I1468":4 %p3404};
//   %p3405 = (198, -21);
//   %wire_6594 = &"VDD" @WIRE(mode="straight") {#"I778":8 %p3405};
//   %p3406 = (-44, -444);
//   %wire_6595 = &"VDD" @WIRE(mode="straight") {#"I1506":4 %p3406};
//   %p3407 = (306, -441);
//   %wire_6596 = &"VDD" @WIRE(mode="straight") {#"I1358":8 %p3407};
//   %p3408 = (354, 14);
//   %wire_6597 = &"VDD" @WIRE(mode="straight") {#"I701":8 %p3408};
//   %p3409 = (40, 14);
//   %wire_6598 = &"VDD" @WIRE(mode="straight") {#"I437":8 %p3409};
//   %wire_6599 = &"VDD" @WIRE(mode="straight") {%p3074 %p3225};
//   %p3410 = (414, -36);
//   %wire_6600 = &"VDD" @WIRE(mode="straight") {#"I782":3 %p3410};
//   %p3411 = (-8, -402);
//   %wire_6601 = &"VDD" @WIRE(mode="straight") {%p3411 %p3069};
//   %p3412 = (174, -56);
//   %wire_6602 = &"VDD" @WIRE(mode="straight") {#"I812":8 %p3412};
//   %p3413 = (282, -126);
//   %wire_6603 = &"VDD" @WIRE(mode="straight") {#"I868":8 %p3413};
//   %p3414 = (99, -731);
//   %wire_6604 = &"VDD" @WIRE(mode="straight") {#"M43":4 %p3414};
//   %p3415 = (150, -581);
//   %wire_6605 = &"VDD" @WIRE(mode="straight") {#"I1386":8 %p3415};
//   %p3416 = (354, -721);
//   %wire_6606 = &"VDD" @WIRE(mode="straight") {#"I1428":8 %p3416};
//   %p3417 = (99, -696);
//   %wire_6607 = &"VDD" @WIRE(mode="straight") {#"M42":4 %p3417};
//   %p3418 = (99, -381);
//   %wire_6608 = &"VDD" @WIRE(mode="straight") {#"M33":4 %p3418};
//   %p3419 = (282, -581);
//   %wire_6609 = &"VDD" @WIRE(mode="straight") {#"I1391":8 %p3419};
//   %p3420 = (402, -721);
//   %wire_6610 = &"VDD" @WIRE(mode="straight") {#"I1430":8 %p3420};
//   %p3421 = (-16, -400);
//   %wire_6611 = &"VDD" @WIRE(mode="straight") {#"I1509":4 %p3421};
//   %p3422 = (330, -21);
//   %wire_6612 = &"VDD" @WIRE(mode="straight") {#"I786":8 %p3422};
//   %p3423 = (282, -651);
//   %wire_6613 = &"VDD" @WIRE(mode="straight") {#"I1408":8 %p3423};
//   %p3424 = (198, -651);
//   %wire_6614 = &"VDD" @WIRE(mode="straight") {#"I1405":8 %p3424};
//   %p3425 = (414, -666);
//   %wire_6615 = &"VDD" @WIRE(mode="straight") {#"I1407":3 %p3425};
//   %p3426 = (-8, -472);
//   %wire_6616 = &"VDD" @WIRE(mode="straight") {%p3426 %p3220};
//   %p3427 = (198, -196);
//   %wire_6617 = &"VDD" @WIRE(mode="straight") {#"I891":8 %p3427};
//   %p3428 = (198, -56);
//   %wire_6618 = &"VDD" @WIRE(mode="straight") {#"I811":8 %p3428};
//   %p3429 = (174, -21);
//   %wire_6619 = &"VDD" @WIRE(mode="straight") {#"I779":8 %p3429};
//   %p3430 = (-4, 14);
//   %wire_6620 = &"VDD" @WIRE(mode="straight") {%p3430 %p3401};
//   %p3431 = (282, -196);
//   %wire_6621 = &"VDD" @WIRE(mode="straight") {#"I908":8 %p3431};
//   %p3432 = (258, -476);
//   %wire_6622 = &"VDD" @WIRE(mode="straight") {#"I1049":8 %p3432};
//   %p3433 = (-44, -94);
//   %wire_6623 = &"VDD" @WIRE(mode="straight") {#"I1466":4 %p3433};
//   %p3434 = (-32, -444);
//   %wire_6624 = &"VDD" @WIRE(mode="straight") {#"I1503":3 %p3434};
//   %p3435 = (-32, -374);
//   %wire_6625 = &"VDD" @WIRE(mode="straight") {#"I1495":3 %p3435};
//   %p3436 = (64, -581);
//   %wire_6626 = &"VDD" @WIRE(mode="straight") {#"I1381":8 %p3436};
//   %p3437 = (64, -196);
//   %wire_6627 = &"VDD" @WIRE(mode="straight") {#"I881":8 %p3437};
//   %p3438 = (174, -196);
//   %wire_6628 = &"VDD" @WIRE(mode="straight") {#"I892":8 %p3438};
//   %p3439 = (306, -126);
//   %wire_6629 = &"VDD" @WIRE(mode="straight") {#"I867":8 %p3439};
//   %p3440 = (-16, -470);
//   %wire_6630 = &"VDD" @WIRE(mode="straight") {#"I1517":4 %p3440};
//   %p3441 = (-4, -56);
//   %wire_6631 = &"VDD" @WIRE(mode="straight") {#"M68":4 %p3441};
//   %p3442 = (330, -196);
//   %wire_6632 = &"VDD" @WIRE(mode="straight") {#"I906":8 %p3442};
//   %p3443 = (378, -581);
//   %wire_6633 = &"VDD" @WIRE(mode="straight") {#"I1395":8 %p3443};
//   %p3444 = (150, -56);
//   %wire_6634 = &"VDD" @WIRE(mode="straight") {#"I813":8 %p3444};
//   %p3445 = (198, -266);
//   %wire_6635 = &"VDD" @WIRE(mode="straight") {#"I931":8 %p3445};
//   %p3446 = (40, -266);
//   %wire_6636 = &"VDD" @WIRE(mode="straight") {#"I920":8 %p3446};
//   %p3447 = (126, -21);
//   %wire_6637 = &"VDD" @WIRE(mode="straight") {#"I781":8 %p3447};
//   %p3448 = (258, -511);
//   %wire_6638 = &"VDD" @WIRE(mode="straight") {#"I1367":8 %p3448};
//   %p3449 = (-16, -190);
//   %wire_6639 = &"VDD" @WIRE(mode="straight") {#"I1485":4 %p3449};
//   %p3450 = (414, -596);
//   %wire_6640 = &"VDD" @WIRE(mode="straight") {#"I1390":3 %p3450};
//   %p3451 = (99, -556);
//   %wire_6641 = &"VDD" @WIRE(mode="straight") {#"M38":4 %p3451};
//   %p3452 = (378, -511);
//   %wire_6642 = &"VDD" @WIRE(mode="straight") {#"I1378":8 %p3452};
//   %p3453 = (306, -21);
//   %wire_6643 = &"VDD" @WIRE(mode="straight") {#"I787":8 %p3453};
//   %p3454 = (16, -21);
//   %wire_6644 = &"VDD" @WIRE(mode="straight") {#"I770":8 %p3454};
//   %p3455 = (330, 14);
//   %wire_6645 = &"VDD" @WIRE(mode="straight") {#"I679":8 %p3455};
//   %p3456 = (-55, -24);
//   %wire_6646 = &"VDD" @WIRE(mode="straight") {#"I774":3 %p3456};
//   %p3457 = (-8, -192);
//   %p3458 = (-6, -192);
//   %wire_6647 = &"VDD" @WIRE(mode="straight") {%p3457 %p3458};
//   %p3459 = (402, -266);
//   %wire_6648 = &"VDD" @WIRE(mode="straight") {#"I943":8 %p3459};
//   %p3460 = (174, -511);
//   %wire_6649 = &"VDD" @WIRE(mode="straight") {#"I1370":8 %p3460};
//   %p3461 = (306, -56);
//   %wire_6650 = &"VDD" @WIRE(mode="straight") {#"I827":8 %p3461};
//   %p3462 = (99, -276);
//   %wire_6651 = &"VDD" @WIRE(mode="straight") {#"M30":4 %p3462};
//   %p3463 = (-8, -295);
//   %wire_6652 = &"VDD" @WIRE(mode="straight") {#"I1486":4 %p3463};
//   %p3464 = (402, 14);
//   %wire_6653 = &"VDD" @WIRE(mode="straight") {#"I745":8 %p3464};
//   %p3465 = (234, -126);
//   %wire_6654 = &"VDD" @WIRE(mode="straight") {#"I850":8 %p3465};
//   %p3466 = (64, -511);
//   %wire_6655 = &"VDD" @WIRE(mode="straight") {#"I1364":8 %p3466};
//   %p3467 = (126, -651);
//   %wire_6656 = &"VDD" @WIRE(mode="straight") {#"I1402":8 %p3467};
//   %p3468 = (-55, -164);
//   %wire_6657 = &"VDD" @WIRE(mode="straight") {#"I1473":3 %p3468};
//   %p3469 = (234, -406);
//   %wire_6658 = &"VDD" @WIRE(mode="straight") {#"I1010":8 %p3469};
//   %p3470 = (64, -441);
//   %wire_6659 = &"VDD" @WIRE(mode="straight") {#"I1347":8 %p3470};
//   %p3471 = (306, -196);
//   %wire_6660 = &"VDD" @WIRE(mode="straight") {#"I907":8 %p3471};
//   %p3472 = (258, -441);
//   %wire_6661 = &"VDD" @WIRE(mode="straight") {#"I1350":8 %p3472};
//   %p3473 = (88, -196);
//   %wire_6662 = &"VDD" @WIRE(mode="straight") {#"I882":8 %p3473};
//   %p3474 = (174, -441);
//   %wire_6663 = &"VDD" @WIRE(mode="straight") {#"I1353":8 %p3474};
//   %p3475 = (40, -196);
//   %wire_6664 = &"VDD" @WIRE(mode="straight") {#"I880":8 %p3475};
//   %p3476 = (-16, -120);
//   %wire_6665 = &"VDD" @WIRE(mode="straight") {#"I1477":4 %p3476};
//   %wire_6666 = &"VDD" @WIRE(mode="straight") {%p3441 %p3203};
//   %p3477 = (234, -266);
//   %wire_6667 = &"VDD" @WIRE(mode="straight") {#"I930":8 %p3477};
//   %p3478 = (402, -231);
//   %wire_6668 = &"VDD" @WIRE(mode="straight") {#"I1311":8 %p3478};
//   %p3479 = (258, -266);
//   %wire_6669 = &"VDD" @WIRE(mode="straight") {#"I929":8 %p3479};
//   %p3480 = (330, -581);
//   %wire_6670 = &"VDD" @WIRE(mode="straight") {#"I1393":8 %p3480};
//   %p3481 = (88, -371);
//   %wire_6671 = &"VDD" @WIRE(mode="straight") {#"I1329":8 %p3481};
//   %p3482 = (354, -581);
//   %wire_6672 = &"VDD" @WIRE(mode="straight") {#"I1394":8 %p3482};
//   %p3483 = (64, -266);
//   %wire_6673 = &"VDD" @WIRE(mode="straight") {#"I921":8 %p3483};
//   %p3484 = (126, -581);
//   %wire_6674 = &"VDD" @WIRE(mode="straight") {#"I1385":8 %p3484};
//   %p3485 = (40, -336);
//   %wire_6675 = &"VDD" @WIRE(mode="straight") {#"I960":8 %p3485};
//   %p3486 = (-8, -262);
//   %p3487 = (-6, -262);
//   %wire_6676 = &"VDD" @WIRE(mode="straight") {%p3486 %p3487};
//   %p3488 = (126, -476);
//   %wire_6677 = &"VDD" @WIRE(mode="straight") {#"I1054":8 %p3488};
//   %p3489 = (234, -336);
//   %wire_6678 = &"VDD" @WIRE(mode="straight") {#"I970":8 %p3489};
//   %p3490 = (-16, -260);
//   %wire_6679 = &"VDD" @WIRE(mode="straight") {#"I1493":4 %p3490};
//   %p3491 = (16, -371);
//   %wire_6680 = &"VDD" @WIRE(mode="straight") {#"I1332":8 %p3491};
//   %p3492 = (88, -651);
//   %wire_6681 = &"VDD" @WIRE(mode="straight") {#"I1397":8 %p3492};
//   %p3493 = (64, -476);
//   %wire_6682 = &"VDD" @WIRE(mode="straight") {#"I1041":8 %p3493};
//   %p3494 = (258, -406);
//   %wire_6683 = &"VDD" @WIRE(mode="straight") {#"I1009":8 %p3494};
//   %p3495 = (-44, -304);
//   %wire_6684 = &"VDD" @WIRE(mode="straight") {#"I1490":4 %p3495};
//   %p3496 = (402, -406);
//   %wire_6685 = &"VDD" @WIRE(mode="straight") {#"I1023":8 %p3496};
//   %p3497 = (330, -441);
//   %wire_6686 = &"VDD" @WIRE(mode="straight") {#"I1359":8 %p3497};
//   %p3498 = (-55, 46);
//   %wire_6687 = &"VDD" @WIRE(mode="straight") {#"I1542":3 %p3498};
//   %p3499 = (126, -371);
//   %wire_6688 = &"VDD" @WIRE(mode="straight") {#"I1334":8 %p3499};
//   %p3500 = (16, -476);
//   %wire_6689 = &"VDD" @WIRE(mode="straight") {#"I1039":8 %p3500};
//   %p3501 = (16, -546);
//   %wire_6690 = &"VDD" @WIRE(mode="straight") {#"I1079":8 %p3501};
//   %wire_6691 = &"VDD" @WIRE(mode="straight") {#"M69":3 %p3343};
//   %p3502 = (306, -476);
//   %wire_6692 = &"VDD" @WIRE(mode="straight") {#"I1067":8 %p3502};
//   %p3503 = (429, -725);
//   %wire_6693 = &"VDD" @WIRE(mode="straight") {#"I1431":3 %p3503};
//   %p3504 = (40, -371);
//   %wire_6694 = &"VDD" @WIRE(mode="straight") {#"I1331":8 %p3504};
//   %p3505 = (306, -301);
//   %wire_6695 = &"VDD" @WIRE(mode="straight") {#"I1324":8 %p3505};
//   %p3506 = (354, -231);
//   %wire_6696 = &"VDD" @WIRE(mode="straight") {#"I1309":8 %p3506};
//   %p3507 = (354, -406);
//   %wire_6697 = &"VDD" @WIRE(mode="straight") {#"I1025":8 %p3507};
//   %p3508 = (282, -371);
//   %wire_6698 = &"VDD" @WIRE(mode="straight") {#"I1340":8 %p3508};
//   %p3509 = (414, -491);
//   %wire_6699 = &"VDD" @WIRE(mode="straight") {#"I1062":3 %p3509};
//   %p3510 = (40, -651);
//   %wire_6700 = &"VDD" @WIRE(mode="straight") {#"I1399":8 %p3510};
//   %p3511 = (150, -21);
//   %wire_6701 = &"VDD" @WIRE(mode="straight") {#"I780":8 %p3511};
//   %p3512 = (-4, -266);
//   %p3513 = (-4, -264);
//   %wire_6702 = &"VDD" @WIRE(mode="straight") {%p3512 %p3513};
//   %p3514 = (306, -651);
//   %wire_6703 = &"VDD" @WIRE(mode="straight") {#"I1409":8 %p3514};
//   %p3515 = (-8, 18);
//   %wire_6704 = &"VDD" @WIRE(mode="straight") {%p3515 %p3399};
//   %p3516 = (414, -1);
//   %wire_6705 = &"VDD" @WIRE(mode="straight") {#"I768":3 %p3516};
//   %p3517 = (354, -126);
//   %wire_6706 = &"VDD" @WIRE(mode="straight") {#"I865":8 %p3517};
//   %p3518 = (414, -246);
//   %wire_6707 = &"VDD" @WIRE(mode="straight") {#"I1305":3 %p3518};
//   %p3519 = (-16, -330);
//   %wire_6708 = &"VDD" @WIRE(mode="straight") {#"I1501":4 %p3519};
//   %p3520 = (99, -66);
//   %wire_6709 = &"VDD" @WIRE(mode="straight") {#"M24":4 %p3520};
//   %p3521 = (88, -511);
//   %wire_6710 = &"VDD" @WIRE(mode="straight") {#"I1363":8 %p3521};
//   %p3522 = (282, -301);
//   %wire_6711 = &"VDD" @WIRE(mode="straight") {#"I1323":8 %p3522};
//   %p3523 = (-55, -199);
//   %wire_6712 = &"VDD" @WIRE(mode="straight") {#"I1483":3 %p3523};
//   %p3524 = (282, -721);
//   %wire_6713 = &"VDD" @WIRE(mode="straight") {#"I1425":8 %p3524};
//   %p3525 = (354, -511);
//   %wire_6714 = &"VDD" @WIRE(mode="straight") {#"I1377":8 %p3525};
//   %p3526 = (258, -126);
//   %wire_6715 = &"VDD" @WIRE(mode="straight") {#"I849":8 %p3526};
//   %p3527 = (282, -511);
//   %wire_6716 = &"VDD" @WIRE(mode="straight") {#"I1374":8 %p3527};
//   %p3528 = (234, -651);
//   %wire_6717 = &"VDD" @WIRE(mode="straight") {#"I1406":8 %p3528};
//   %p3529 = (150, -126);
//   %wire_6718 = &"VDD" @WIRE(mode="straight") {#"I853":8 %p3529};
//   %p3530 = (354, -371);
//   %wire_6719 = &"VDD" @WIRE(mode="straight") {#"I1343":8 %p3530};
//   %wire_6720 = &"VDD" @WIRE(mode="straight") {#"M72":3 %p3458};
//   %p3531 = (234, -476);
//   %wire_6721 = &"VDD" @WIRE(mode="straight") {#"I1050":8 %p3531};
//   %wire_6722 = &"VDD" @WIRE(mode="straight") {#"M70":3 %p3345};
//   %p3532 = (282, -441);
//   %wire_6723 = &"VDD" @WIRE(mode="straight") {#"I1357":8 %p3532};
//   %p3533 = (40, -476);
//   %wire_6724 = &"VDD" @WIRE(mode="straight") {#"I1040":8 %p3533};
//   %p3534 = (-18, -367);
//   %wire_6725 = &"VDD" @WIRE(mode="straight") {#"M75":3 %p3534};
//   %p3535 = (378, -651);
//   %wire_6726 = &"VDD" @WIRE(mode="straight") {#"I1412":8 %p3535};
//   %p3536 = (64, -406);
//   %wire_6727 = &"VDD" @WIRE(mode="straight") {#"I1001":8 %p3536};
//   %p3537 = (-20, -229);
//   %wire_6728 = &"VDD" @WIRE(mode="straight") {%p3351 %p3537};
//   %p3538 = (88, -721);
//   %wire_6729 = &"VDD" @WIRE(mode="straight") {#"I1414":8 %p3538};
//   %p3539 = (198, -231);
//   %wire_6730 = &"VDD" @WIRE(mode="straight") {#"I1303":8 %p3539};
//   %p3540 = (40, -301);
//   %wire_6731 = &"VDD" @WIRE(mode="straight") {#"I1314":8 %p3540};
//   %p3541 = (306, -511);
//   %wire_6732 = &"VDD" @WIRE(mode="straight") {#"I1375":8 %p3541};
//   %p3542 = (354, -266);
//   %wire_6733 = &"VDD" @WIRE(mode="straight") {#"I945":8 %p3542};
//   %wire_6734 = &"VDD" @WIRE(mode="straight") {#"M74":4 %p3512};
//   %p3543 = (198, -546);
//   %wire_6735 = &"VDD" @WIRE(mode="straight") {#"I1091":8 %p3543};
//   %p3544 = (207, -731);
//   %wire_6736 = &"VDD" @WIRE(mode="straight") {#"M49":4 %p3544};
//   %p3545 = (282, -231);
//   %wire_6737 = &"VDD" @WIRE(mode="straight") {#"I1306":8 %p3545};
//   %p3546 = (99, -486);
//   %wire_6738 = &"VDD" @WIRE(mode="straight") {#"M36":4 %p3546};
//   %p3547 = (99, -311);
//   %wire_6739 = &"VDD" @WIRE(mode="straight") {#"M31":4 %p3547};
//   %p3548 = (414, -736);
//   %wire_6740 = &"VDD" @WIRE(mode="straight") {#"I1424":3 %p3548};
//   %p3549 = (126, -336);
//   %wire_6741 = &"VDD" @WIRE(mode="straight") {#"I974":8 %p3549};
//   %p3550 = (126, -301);
//   %wire_6742 = &"VDD" @WIRE(mode="straight") {#"I1317":8 %p3550};
//   %p3551 = (99, -206);
//   %wire_6743 = &"VDD" @WIRE(mode="straight") {#"M28":4 %p3551};
//   %p3552 = (402, -476);
//   %wire_6744 = &"VDD" @WIRE(mode="straight") {#"I1063":8 %p3552};
//   %wire_6745 = &"VDD" @WIRE(mode="straight") {%p3231 %p3390};
//   %p3553 = (150, -301);
//   %wire_6746 = &"VDD" @WIRE(mode="straight") {#"I1318":8 %p3553};
//   %p3554 = (258, -231);
//   %wire_6747 = &"VDD" @WIRE(mode="straight") {#"I1299":8 %p3554};
//   %p3555 = (207, -696);
//   %wire_6748 = &"VDD" @WIRE(mode="straight") {#"M45":4 %p3555};
//   %p3556 = (-8, -435);
//   %wire_6749 = &"VDD" @WIRE(mode="straight") {#"I1502":4 %p3556};
//   %p3557 = (99, -136);
//   %wire_6750 = &"VDD" @WIRE(mode="straight") {#"M26":4 %p3557};
//   %p3558 = (16, -126);
//   %wire_6751 = &"VDD" @WIRE(mode="straight") {#"I839":8 %p3558};
//   %p3559 = (234, -721);
//   %wire_6752 = &"VDD" @WIRE(mode="straight") {#"I1423":8 %p3559};
//   %p3560 = (88, -336);
//   %wire_6753 = &"VDD" @WIRE(mode="straight") {#"I962":8 %p3560};
//   %p3561 = (-8, -332);
//   %wire_6754 = &"VDD" @WIRE(mode="straight") {%p3561 %p3382};
//   %p3562 = (174, -546);
//   %wire_6755 = &"VDD" @WIRE(mode="straight") {#"I1092":8 %p3562};
//   %wire_6756 = &"VDD" @WIRE(mode="straight") {#"M74":3 %p3487};
//   %p3563 = (234, -546);
//   %wire_6757 = &"VDD" @WIRE(mode="straight") {#"I1090":8 %p3563};
//   %p3564 = (99, 4);
//   %wire_6758 = &"VDD" @WIRE(mode="straight") {#"M22":4 %p3564};
//   %p3565 = (-20, -371);
//   %wire_6759 = &"VDD" @WIRE(mode="straight") {#"M75":4 %p3565};
//   %p3566 = (126, -196);
//   %wire_6760 = &"VDD" @WIRE(mode="straight") {#"I894":8 %p3566};
//   %p3567 = (88, -301);
//   %wire_6761 = &"VDD" @WIRE(mode="straight") {#"I1312":8 %p3567};
//   %p3568 = (306, -266);
//   %wire_6762 = &"VDD" @WIRE(mode="straight") {#"I947":8 %p3568};
//   %p3569 = (198, -441);
//   %wire_6763 = &"VDD" @WIRE(mode="straight") {#"I1354":8 %p3569};
//   %p3570 = (282, -546);
//   %wire_6764 = &"VDD" @WIRE(mode="straight") {#"I1108":8 %p3570};
//   %p3571 = (306, -546);
//   %wire_6765 = &"VDD" @WIRE(mode="straight") {#"I1107":8 %p3571};
//   %p3572 = (414, -316);
//   %wire_6766 = &"VDD" @WIRE(mode="straight") {#"I1322":3 %p3572};
//   %p3573 = (88, -581);
//   %wire_6767 = &"VDD" @WIRE(mode="straight") {#"I1380":8 %p3573};
//   %p3574 = (150, -546);
//   %wire_6768 = &"VDD" @WIRE(mode="straight") {#"I1093":8 %p3574};
//   %p3575 = (198, -476);
//   %wire_6769 = &"VDD" @WIRE(mode="straight") {#"I1051":8 %p3575};
//   %wire_6770 = &"VDD" @WIRE(mode="straight") {#"M73":3 %p3355};
//   %p3576 = (-55, -269);
//   %wire_6771 = &"VDD" @WIRE(mode="straight") {#"I1491":3 %p3576};
//   %wire_6772 = &"VDD" @WIRE(mode="straight") {#"M0":4 %p3430};
//   %p3577 = (414, -456);
//   %wire_6773 = &"VDD" @WIRE(mode="straight") {#"I1356":3 %p3577};
//   %wire_6774 = &"VDD" @WIRE(mode="straight") {#"M73":4 %p3380};
//   %p3578 = (64, -301);
//   %wire_6775 = &"VDD" @WIRE(mode="straight") {#"I1313":8 %p3578};
//   %p3579 = (198, -406);
//   %wire_6776 = &"VDD" @WIRE(mode="straight") {#"I1011":8 %p3579};
//   %p3580 = (16, -56);
//   %wire_6777 = &"VDD" @WIRE(mode="straight") {#"I799":8 %p3580};
//   %p3581 = (-4, -196);
//   %wire_6778 = &"VDD" @WIRE(mode="straight") {#"M72":4 %p3581};
//   %p3582 = (414, -351);
//   %wire_6779 = &"VDD" @WIRE(mode="straight") {#"I982":3 %p3582};
//   %p3583 = (378, -721);
//   %wire_6780 = &"VDD" @WIRE(mode="straight") {#"I1429":8 %p3583};
//   %p3584 = (282, 14);
//   %wire_6781 = &"VDD" @WIRE(mode="straight") {#"I635":8 %p3584};
//   %p3585 = (99, -101);
//   %wire_6782 = &"VDD" @WIRE(mode="straight") {#"M25":4 %p3585};
//   %wire_6783 = &"VDD" @WIRE(mode="straight") {%p3581 %p3350};
//   %p3586 = (258, -546);
//   %wire_6784 = &"VDD" @WIRE(mode="straight") {#"I1089":8 %p3586};
//   %p3587 = (330, -126);
//   %wire_6785 = &"VDD" @WIRE(mode="straight") {#"I866":8 %p3587};
//   %p3588 = (306, -406);
//   %wire_6786 = &"VDD" @WIRE(mode="straight") {#"I1027":8 %p3588};
//   %wire_6787 = &"VDD" @WIRE(mode="straight") {#"M74":3 %p3513};
//   %p3589 = (-18, -437);
//   %wire_6788 = &"VDD" @WIRE(mode="straight") {#"M77":3 %p3589};
//   %p3590 = (402, -511);
//   %wire_6789 = &"VDD" @WIRE(mode="straight") {#"I1379":8 %p3590};
//   %p3591 = (16, -301);
//   %wire_6790 = &"VDD" @WIRE(mode="straight") {#"I1315":8 %p3591};
//   %wire_6791 = &"VDD" @WIRE(mode="straight") {#"M71":3 %p3537};
//   %p3592 = (402, -371);
//   %wire_6792 = &"VDD" @WIRE(mode="straight") {#"I1345":8 %p3592};
//   %p3593 = (-20, -369);
//   %wire_6793 = &"VDD" @WIRE(mode="straight") {#"M75":3 %p3593};
//   %p3594 = (-55, -234);
//   %wire_6794 = &"VDD" @WIRE(mode="straight") {#"I1481":3 %p3594};
//   %p3595 = (209, -779);
//   %wire_6795 = &"VDD" @WIRE(mode="straight") {%p3595 #"I1455":3};
//   %p3596 = (306, -336);
//   %wire_6796 = &"VDD" @WIRE(mode="straight") {#"I987":8 %p3596};
//   %p3597 = (-44, 46);
//   %wire_6797 = &"VDD" @WIRE(mode="straight") {#"I1543":4 %p3597};
//   %p3598 = (330, -476);
//   %wire_6798 = &"VDD" @WIRE(mode="straight") {#"I1066":8 %p3598};
//   %p3599 = (378, -336);
//   %wire_6799 = &"VDD" @WIRE(mode="straight") {#"I984":8 %p3599};
//   %p3600 = (198, -511);
//   %wire_6800 = &"VDD" @WIRE(mode="straight") {#"I1371":8 %p3600};
//   %p3601 = (16, -581);
//   %wire_6801 = &"VDD" @WIRE(mode="straight") {#"I1383":8 %p3601};
//   %p3602 = (126, -56);
//   %wire_6802 = &"VDD" @WIRE(mode="straight") {#"I814":8 %p3602};
//   %p3603 = (282, -336);
//   %wire_6803 = &"VDD" @WIRE(mode="straight") {#"I988":8 %p3603};
//   %p3604 = (234, -21);
//   %wire_6804 = &"VDD" @WIRE(mode="straight") {#"I777":8 %p3604};
//   %p3605 = (258, -336);
//   %wire_6805 = &"VDD" @WIRE(mode="straight") {#"I969":8 %p3605};
//   %p3606 = (64, -126);
//   %wire_6806 = &"VDD" @WIRE(mode="straight") {#"I841":8 %p3606};
//   %p3607 = (88, -546);
//   %wire_6807 = &"VDD" @WIRE(mode="straight") {#"I1082":8 %p3607};
//   %p3608 = (16, -511);
//   %wire_6808 = &"VDD" @WIRE(mode="straight") {#"I1366":8 %p3608};
//   %p3609 = (258, -196);
//   %wire_6809 = &"VDD" @WIRE(mode="straight") {#"I889":8 %p3609};
//   %p3610 = (99, -346);
//   %wire_6810 = &"VDD" @WIRE(mode="straight") {#"M32":4 %p3610};
//   %p3611 = (150, -441);
//   %wire_6811 = &"VDD" @WIRE(mode="straight") {#"I1352":8 %p3611};
//   %p3612 = (258, -56);
//   %wire_6812 = &"VDD" @WIRE(mode="straight") {#"I809":8 %p3612};
//   %p3613 = (330, -721);
//   %wire_6813 = &"VDD" @WIRE(mode="straight") {#"I1427":8 %p3613};
//   %p3614 = (234, -196);
//   %wire_6814 = &"VDD" @WIRE(mode="straight") {#"I890":8 %p3614};
//   %p3615 = (40, -21);
//   %wire_6815 = &"VDD" @WIRE(mode="straight") {#"I771":8 %p3615};
//   %p3616 = (282, -21);
//   %wire_6816 = &"VDD" @WIRE(mode="straight") {#"I788":8 %p3616};
//   %p3617 = (99, -241);
//   %wire_6817 = &"VDD" @WIRE(mode="straight") {#"M29":4 %p3617};
//   %wire_6818 = &"VDD" @WIRE(mode="straight") {#"M79":3 %p3297};
//   %p3618 = (234, -511);
//   %wire_6819 = &"VDD" @WIRE(mode="straight") {#"I1372":8 %p3618};
//   %p3619 = (258, -721);
//   %wire_6820 = &"VDD" @WIRE(mode="straight") {#"I1418":8 %p3619};
//   %p3620 = (234, -56);
//   %wire_6821 = &"VDD" @WIRE(mode="straight") {#"I810":8 %p3620};
//   %p3621 = (88, -441);
//   %wire_6822 = &"VDD" @WIRE(mode="straight") {#"I1346":8 %p3621};
//   %p3622 = (306, -581);
//   %wire_6823 = &"VDD" @WIRE(mode="straight") {#"I1392":8 %p3622};
//   %p3623 = (64, -21);
//   %wire_6824 = &"VDD" @WIRE(mode="straight") {#"I772":8 %p3623};
//   %p3624 = (174, -651);
//   %wire_6825 = &"VDD" @WIRE(mode="straight") {#"I1404":8 %p3624};
//   %p3625 = (126, -441);
//   %wire_6826 = &"VDD" @WIRE(mode="straight") {#"I1351":8 %p3625};
//   %p3626 = (207, -591);
//   %wire_6827 = &"VDD" @WIRE(mode="straight") {#"M48":4 %p3626};
//   %p3627 = (40, -56);
//   %wire_6828 = &"VDD" @WIRE(mode="straight") {#"I800":8 %p3627};
//   %p3628 = (-16, -367);
//   %wire_6829 = &"VDD" @WIRE(mode="straight") {%p3628 %p3534};
//   %p3629 = (40, -441);
//   %wire_6830 = &"VDD" @WIRE(mode="straight") {#"I1348":8 %p3629};
//   %p3630 = (169, -757);
//   %wire_6831 = &"VDD" @WIRE(mode="straight") {%p3630 #"I1635":4};
//   %p3631 = (16, -441);
//   %wire_6832 = &"VDD" @WIRE(mode="straight") {#"I1349":8 %p3631};
//   %p3632 = (126, -511);
//   %wire_6833 = &"VDD" @WIRE(mode="straight") {#"I1368":8 %p3632};
//   %p3633 = (64, -336);
//   %wire_6834 = &"VDD" @WIRE(mode="straight") {#"I961":8 %p3633};
//   %p3634 = (88, -56);
//   %wire_6835 = &"VDD" @WIRE(mode="straight") {#"I802":8 %p3634};
//   %p3635 = (378, -371);
//   %wire_6836 = &"VDD" @WIRE(mode="straight") {#"I1344":8 %p3635};
//   %p3636 = (306, -371);
//   %wire_6837 = &"VDD" @WIRE(mode="straight") {#"I1341":8 %p3636};
//   %p3637 = (402, -126);
//   %wire_6838 = &"VDD" @WIRE(mode="straight") {#"I863":8 %p3637};
//   %p3638 = (-8, -505);
//   %wire_6839 = &"VDD" @WIRE(mode="straight") {#"I1510":4 %p3638};
//   %p3639 = (64, -56);
//   %wire_6840 = &"VDD" @WIRE(mode="straight") {#"I801":8 %p3639};
//   %p3640 = (99, -31);
//   %wire_6841 = &"VDD" @WIRE(mode="straight") {#"M23":4 %p3640};
//   %p3641 = (-8, -225);
//   %wire_6842 = &"VDD" @WIRE(mode="straight") {#"I1478":4 %p3641};
//   %p3642 = (16, -196);
//   %wire_6843 = &"VDD" @WIRE(mode="straight") {#"I879":8 %p3642};
//   %p3643 = (414, -71);
//   %wire_6844 = &"VDD" @WIRE(mode="straight") {#"I822":3 %p3643};
//   %p3644 = (40, -511);
//   %wire_6845 = &"VDD" @WIRE(mode="straight") {#"I1365":8 %p3644};
//   %p3645 = (16, -266);
//   %wire_6846 = &"VDD" @WIRE(mode="straight") {#"I919":8 %p3645};
//   %p3646 = (234, -231);
//   %wire_6847 = &"VDD" @WIRE(mode="straight") {#"I1304":8 %p3646};
//   %wire_6848 = &"VDD" @WIRE(mode="straight") {%p3565 %p3593};
//   %p3647 = (-16, -437);
//   %wire_6849 = &"VDD" @WIRE(mode="straight") {%p3647 %p3589};
//   %wire_6850 = &"VDD" @WIRE(mode="straight") {#"M70":3 %p3253};
//   %p3648 = (402, -196);
//   %wire_6851 = &"VDD" @WIRE(mode="straight") {#"I903":8 %p3648};
//   %p3649 = (378, -56);
//   %wire_6852 = &"VDD" @WIRE(mode="straight") {#"I824":8 %p3649};
//   %p3650 = (150, -336);
//   %wire_6853 = &"VDD" @WIRE(mode="straight") {#"I973":8 %p3650};
//   %p3651 = (234, -371);
//   %wire_6854 = &"VDD" @WIRE(mode="straight") {#"I1338":8 %p3651};
//   %p3652 = (306, 14);
//   %wire_6855 = &"VDD" @WIRE(mode="straight") {#"I657":8 %p3652};
//   %p3653 = (234, 14);
//   %wire_6856 = &"VDD" @WIRE(mode="straight") {#"I591":8 %p3653};
//   %wire_6856 @TEXT("VDD", size=1, halign="middle", valign="baseline", rotate=90) => @PLACE(233.3, 12);
//   %wire_6469 @TEXT("VDD", size=1, halign="middle", valign="baseline", rotate=90) => @PLACE(197.3, 12);
//   %wire_6855 @TEXT("VDD", size=1, halign="middle", valign="baseline", rotate=90) => @PLACE(305.3, 12);
//   %wire_6705 @TEXT("VDD", size=1, halign="middle", valign="baseline", rotate=90) => @PLACE(413.3, -3);
//   %wire_6492 @TEXT("VDD", size=1, halign="middle", valign="baseline", rotate=90) => @PLACE(377.3, -23);
//   %wire_6461 @TEXT("VDD", size=1, halign="middle", valign="baseline", rotate=90) => @PLACE(-55.7, 9);
//   %wire_6723 @TEXT("VDD", size=1, halign="middle", valign="baseline", rotate=90) => @PLACE(281.3, -443);
//   %wire_6612 @TEXT("VDD", size=1, halign="middle", valign="baseline", rotate=90) => @PLACE(329.3, -23);
//   %wire_6665 @TEXT("VDD", size=1, halign="middle", valign="baseline") => @PLACE(-14, -121.3);
//   %wire_6679 @TEXT("VDD", size=1, halign="middle", valign="baseline") => @PLACE(-14, -261.3);
//   %wire_6846 @TEXT("VDD", size=1, halign="middle", valign="baseline", rotate=90) => @PLACE(15.3, -268);
//   %wire_6477 @TEXT("VDD", size=1, halign="middle", valign="baseline", rotate=90) => @PLACE(377.3, -443);
//   %wire_6441 @TEXT("VDD", size=1, halign="middle", valign="baseline", rotate=90) => @PLACE(353.3, -478);
//   %wire_6510 @TEXT("VDD", size=1, halign="middle", valign="baseline", rotate=90) => @PLACE(257.3, 12);
//   %wire_6844 @TEXT("VDD", size=1, halign="middle", valign="baseline", rotate=90) => @PLACE(413.3, -73);
//   %wire_6843 @TEXT("VDD", size=1, halign="middle", valign="baseline", rotate=90) => @PLACE(15.3, -198);
//   %wire_6845 @TEXT("VDD", size=1, halign="middle", valign="baseline", rotate=90) => @PLACE(39.3, -513);
//   %wire_6842 @TEXT("VDD", size=1, halign="middle", valign="baseline") => @PLACE(-10, -226.3);
//   %wire_6840 @TEXT("VDD", size=1, halign="middle", valign="baseline", rotate=90) => @PLACE(63.3, -58);
//   %wire_6837 @TEXT("VDD", size=1, halign="middle", valign="baseline", rotate=90) => @PLACE(305.3, -373);
//   %wire_6851 @TEXT("VDD", size=1, halign="middle", valign="baseline", rotate=90) => @PLACE(401.3, -198);
//   %wire_6838 @TEXT("VDD", size=1, halign="middle", valign="baseline", rotate=90) => @PLACE(401.3, -128);
//   %wire_6473 @TEXT("VDD", size=1, halign="middle", valign="baseline", rotate=90) => @PLACE(197.3, -723);
//   %wire_6492 @TEXT("VDD", size=1, halign="middle", valign="baseline", rotate=90) => @PLACE(377.3, -23);
//   %wire_6841 @TEXT("VDD", size=1, halign="middle", valign="top", rotate=90) => @PLACE(99.7, -32);
//   %wire_6819 @TEXT("VDD", size=1, halign="middle", valign="baseline", rotate=90) => @PLACE(233.3, -513);
//   %wire_6822 @TEXT("VDD", size=1, halign="middle", valign="baseline", rotate=90) => @PLACE(87.3, -443);
//   %wire_6609 @TEXT("VDD", size=1, halign="middle", valign="baseline", rotate=90) => @PLACE(281.3, -583);
//   %wire_6799 @TEXT("VDD", size=1, halign="middle", valign="baseline", rotate=90) => @PLACE(377.3, -338);
//   %wire_6835 @TEXT("VDD", size=1, halign="middle", valign="baseline", rotate=90) => @PLACE(87.3, -58);
//   %wire_6834 @TEXT("VDD", size=1, halign="middle", valign="baseline", rotate=90) => @PLACE(63.3, -338);
//   %wire_6782 @TEXT("VDD", size=1, halign="middle", valign="top", rotate=90) => @PLACE(99.7, -102);
//   %wire_6699 @TEXT("VDD", size=1, halign="middle", valign="baseline", rotate=90) => @PLACE(413.3, -493);
//   %wire_6796 @TEXT("VDD", size=1, halign="middle", valign="baseline", rotate=90) => @PLACE(305.3, -338);
//   %wire_6561 @TEXT("VDD", size=1, halign="middle", valign="baseline", rotate=90) => @PLACE(353.3, -303);
//   %wire_6610 @TEXT("VDD", size=1, halign="middle", valign="baseline", rotate=90) => @PLACE(401.3, -723);
//   %wire_6615 @TEXT("VDD", size=1, halign="middle", valign="baseline", rotate=90) => @PLACE(413.3, -668);
//   %wire_6829 @TEXT("VDD", size=1, halign="middle", valign="baseline") => @PLACE(-17, -366.3);
//   %wire_6610 @TEXT("VDD", size=1, halign="middle", valign="baseline", rotate=90) => @PLACE(401.3, -723);
//   %wire_6424 @TEXT("VDD", size=1, halign="middle", valign="baseline", rotate=90) => @PLACE(-55.7, 79);
//   %wire_6618 @TEXT("VDD", size=1, halign="middle", valign="baseline", rotate=90) => @PLACE(197.3, -58);
//   %wire_6613 @TEXT("VDD", size=1, halign="middle", valign="baseline", rotate=90) => @PLACE(281.3, -653);
//   %wire_6696 @TEXT("VDD", size=1, halign="middle", valign="baseline", rotate=90) => @PLACE(353.3, -233);
//   %wire_6292 @TEXT("VDD", size=1, halign="middle", valign="baseline", rotate=90) => @PLACE(415.3, -771);
//   %wire_6496 @TEXT("VDD", size=1, halign="middle", valign="baseline", rotate=90) => @PLACE(257.3, -653);
//   %wire_6821 @TEXT("VDD", size=1, halign="middle", valign="baseline", rotate=90) => @PLACE(233.3, -58);
//   %wire_6827 @TEXT("VDD", size=1, halign="middle", valign="top", rotate=90) => @PLACE(207.7, -592);
//   %wire_6711 @TEXT("VDD", size=1, halign="middle", valign="baseline", rotate=90) => @PLACE(281.3, -303);
//   %wire_6826 @TEXT("VDD", size=1, halign="middle", valign="baseline", rotate=90) => @PLACE(125.3, -443);
//   %wire_6814 @TEXT("VDD", size=1, halign="middle", valign="baseline", rotate=90) => @PLACE(233.3, -198);
//   %wire_6813 @TEXT("VDD", size=1, halign="middle", valign="baseline", rotate=90) => @PLACE(329.3, -723);
//   %wire_6606 @TEXT("VDD", size=1, halign="middle", valign="baseline", rotate=90) => @PLACE(353.3, -723);
//   %wire_6812 @TEXT("VDD", size=1, halign="middle", valign="baseline", rotate=90) => @PLACE(257.3, -58);
//   %wire_6483 @TEXT("VDD", size=1, halign="middle", valign="baseline", rotate=90) => @PLACE(63.3, -723);
//   %wire_6809 @TEXT("VDD", size=1, halign="middle", valign="baseline", rotate=90) => @PLACE(257.3, -198);
//   %wire_6767 @TEXT("VDD", size=1, halign="middle", valign="baseline", rotate=90) => @PLACE(87.3, -583);
//   %wire_6719 @TEXT("VDD", size=1, halign="middle", valign="baseline", rotate=90) => @PLACE(353.3, -373);
//   %wire_6808 @TEXT("VDD", size=1, halign="middle", valign="baseline", rotate=90) => @PLACE(15.3, -513);
//   %wire_6551 @TEXT("VDD", size=1, halign="middle", valign="baseline", rotate=90) => @PLACE(377.3, -478);
//   %wire_6806 @TEXT("VDD", size=1, halign="middle", valign="baseline", rotate=90) => @PLACE(63.3, -128);
//   %wire_6698 @TEXT("VDD", size=1, halign="middle", valign="baseline", rotate=90) => @PLACE(281.3, -373);
//   %wire_6729 @TEXT("VDD", size=1, halign="middle", valign="baseline", rotate=90) => @PLACE(87.3, -723);
//   %wire_6764 @TEXT("VDD", size=1, halign="middle", valign="baseline", rotate=90) => @PLACE(281.3, -548);
//   %wire_6802 @TEXT("VDD", size=1, halign="middle", valign="baseline", rotate=90) => @PLACE(125.3, -58);
//   %wire_6547 @TEXT("VDD", size=1, halign="middle", valign="baseline", rotate=90) => @PLACE(353.3, -23);
//   %wire_6661 @TEXT("VDD", size=1, halign="middle", valign="baseline", rotate=90) => @PLACE(257.3, -443);
//   %wire_6661 @TEXT("VDD", size=1, halign="middle", valign="baseline", rotate=90) => @PLACE(257.3, -443);
//   %wire_6553 @TEXT("VDD", size=1, halign="middle", valign="baseline", rotate=90) => @PLACE(149.3, -373);
//   %wire_6707 @TEXT("VDD", size=1, halign="middle", valign="baseline", rotate=90) => @PLACE(413.3, -248);
//   %wire_6760 @TEXT("VDD", size=1, halign="middle", valign="baseline", rotate=90) => @PLACE(125.3, -198);
//   %wire_6854 @TEXT("VDD", size=1, halign="middle", valign="baseline", rotate=90) => @PLACE(233.3, -373);
//   %wire_6550 @TEXT("VDD", size=1, halign="middle", valign="baseline", rotate=90) => @PLACE(377.3, -233);
//   %wire_6769 @TEXT("VDD", size=1, halign="middle", valign="baseline", rotate=90) => @PLACE(197.3, -478);
//   %wire_6816 @TEXT("VDD", size=1, halign="middle", valign="baseline", rotate=90) => @PLACE(281.3, -23);
//   %wire_6542 @TEXT("VDD", size=1, halign="middle", valign="baseline", rotate=90) => @PLACE(353.3, -443);
//   %wire_6789 @TEXT("VDD", size=1, halign="middle", valign="baseline", rotate=90) => @PLACE(401.3, -513);
//   %wire_6820 @TEXT("VDD", size=1, halign="middle", valign="baseline", rotate=90) => @PLACE(257.3, -723);
//   %wire_6825 @TEXT("VDD", size=1, halign="middle", valign="baseline", rotate=90) => @PLACE(173.3, -653);
//   %wire_6800 @TEXT("VDD", size=1, halign="middle", valign="baseline", rotate=90) => @PLACE(197.3, -513);
//   %wire_6823 @TEXT("VDD", size=1, halign="middle", valign="baseline", rotate=90) => @PLACE(305.3, -583);
//   %wire_6798 @TEXT("VDD", size=1, halign="middle", valign="baseline", rotate=90) => @PLACE(329.3, -478);
//   %wire_6717 @TEXT("VDD", size=1, halign="middle", valign="baseline", rotate=90) => @PLACE(233.3, -653);
//   %wire_6438 @TEXT("VDD", size=1, halign="middle", valign="baseline", rotate=90) => @PLACE(125.3, -548);
//   %wire_6747 @TEXT("VDD", size=1, halign="middle", valign="baseline", rotate=90) => @PLACE(257.3, -233);
//   %wire_6719 @TEXT("VDD", size=1, halign="middle", valign="baseline", rotate=90) => @PLACE(353.3, -373);
//   %wire_6765 @TEXT("VDD", size=1, halign="middle", valign="baseline", rotate=90) => @PLACE(305.3, -548);
//   %wire_6820 @TEXT("VDD", size=1, halign="middle", valign="baseline", rotate=90) => @PLACE(257.3, -723);
//   %wire_6307 @TEXT("VDD", size=1, halign="middle", valign="baseline", rotate=90) => @PLACE(305.3, -233);
//   %wire_6779 @TEXT("VDD", size=1, halign="middle", valign="baseline", rotate=90) => @PLACE(413.3, -353);
//   %wire_6721 @TEXT("VDD", size=1, halign="middle", valign="baseline", rotate=90) => @PLACE(233.3, -478);
//   %wire_6776 @TEXT("VDD", size=1, halign="middle", valign="baseline", rotate=90) => @PLACE(197.3, -408);
//   %wire_6737 @TEXT("VDD", size=1, halign="middle", valign="baseline", rotate=90) => @PLACE(281.3, -233);
//   %wire_6777 @TEXT("VDD", size=1, halign="middle", valign="baseline", rotate=90) => @PLACE(15.3, -58);
//   %wire_6735 @TEXT("VDD", size=1, halign="middle", valign="baseline", rotate=90) => @PLACE(197.3, -548);
//   %wire_6545 @TEXT("VDD", size=1, halign="middle", valign="baseline", rotate=90) => @PLACE(413.3, -528);
//   %wire_6671 @TEXT("VDD", size=1, halign="middle", valign="baseline", rotate=90) => @PLACE(87.3, -373);
//   %wire_6817 @TEXT("VDD", size=1, halign="middle", valign="top", rotate=90) => @PLACE(99.7, -242);
//   %wire_6439 @TEXT("VDD", size=1, halign="middle", valign="baseline", rotate=90) => @PLACE(63.3, -548);
//   %wire_6713 @TEXT("VDD", size=1, halign="middle", valign="baseline", rotate=90) => @PLACE(281.3, -723);
//   %wire_6518 @TEXT("VDD", size=1, halign="middle", valign="baseline", rotate=90) => @PLACE(401.3, -583);
//   %wire_6307 @TEXT("VDD", size=1, halign="middle", valign="baseline", rotate=90) => @PLACE(305.3, -233);
//   %wire_6518 @TEXT("VDD", size=1, halign="middle", valign="baseline", rotate=90) => @PLACE(401.3, -583);
//   %wire_6550 @TEXT("VDD", size=1, halign="middle", valign="baseline", rotate=90) => @PLACE(377.3, -233);
//   %wire_6762 @TEXT("VDD", size=1, halign="middle", valign="baseline", rotate=90) => @PLACE(305.3, -268);
//   %wire_6552 @TEXT("VDD", size=1, halign="middle", valign="baseline", rotate=90) => @PLACE(257.3, -373);
//   %wire_6742 @TEXT("VDD", size=1, halign="middle", valign="baseline", rotate=90) => @PLACE(125.3, -303);
//   %wire_6828 @TEXT("VDD", size=1, halign="middle", valign="baseline", rotate=90) => @PLACE(39.3, -58);
//   %wire_6726 @TEXT("VDD", size=1, halign="middle", valign="baseline", rotate=90) => @PLACE(377.3, -653);
//   %wire_6614 @TEXT("VDD", size=1, halign="middle", valign="baseline", rotate=90) => @PLACE(197.3, -653);
//   %wire_6811 @TEXT("VDD", size=1, halign="middle", valign="baseline", rotate=90) => @PLACE(149.3, -443);
//   %wire_6775 @TEXT("VDD", size=1, halign="middle", valign="baseline", rotate=90) => @PLACE(63.3, -303);
//   %wire_6755 @TEXT("VDD", size=1, halign="middle", valign="baseline", rotate=90) => @PLACE(173.3, -548);
//   %wire_6535 @TEXT("VDD", size=1, halign="middle", valign="baseline", rotate=90) => @PLACE(353.3, -653);
//   %wire_6436 @TEXT("VDD", size=1, halign="middle", valign="baseline", rotate=90) => @PLACE(401.3, -653);
//   %wire_6784 @TEXT("VDD", size=1, halign="middle", valign="baseline", rotate=90) => @PLACE(257.3, -548);
//   %wire_6737 @TEXT("VDD", size=1, halign="middle", valign="baseline", rotate=90) => @PLACE(281.3, -233);
//   %wire_6761 @TEXT("VDD", size=1, halign="middle", valign="baseline", rotate=90) => @PLACE(87.3, -303);
//   %wire_6613 @TEXT("VDD", size=1, halign="middle", valign="baseline", rotate=90) => @PLACE(281.3, -653);
//   %wire_6754 @TEXT("VDD", size=1, halign="middle", valign="baseline") => @PLACE(-7, -331.3);
//   %wire_6748 @TEXT("VDD", size=1, halign="middle", valign="top", rotate=90) => @PLACE(207.7, -697);
//   %wire_6749 @TEXT("VDD", size=1, halign="middle", valign="baseline") => @PLACE(-10, -436.3);
//   %wire_6751 @TEXT("VDD", size=1, halign="middle", valign="baseline", rotate=90) => @PLACE(15.3, -128);
//   %wire_6544 @TEXT("VDD", size=1, halign="middle", valign="baseline", rotate=90) => @PLACE(-44.7, -481);
//   %wire_6849 @TEXT("VDD", size=1, halign="middle", valign="baseline") => @PLACE(-17, -436.3);
//   %wire_6780 @TEXT("VDD", size=1, halign="middle", valign="baseline", rotate=90) => @PLACE(377.3, -723);
//   %wire_6792 @TEXT("VDD", size=1, halign="middle", valign="baseline", rotate=90) => @PLACE(401.3, -373);
//   %wire_6738 @TEXT("VDD", size=1, halign="middle", valign="top", rotate=90) => @PLACE(99.7, -487);
//   %wire_6744 @TEXT("VDD", size=1, halign="middle", valign="baseline", rotate=90) => @PLACE(401.3, -478);
//   %wire_6607 @TEXT("VDD", size=1, halign="middle", valign="top", rotate=90) => @PLACE(99.7, -697);
//   %wire_6740 @TEXT("VDD", size=1, halign="middle", valign="baseline", rotate=90) => @PLACE(413.3, -738);
//   %wire_6757 @TEXT("VDD", size=1, halign="middle", valign="baseline", rotate=90) => @PLACE(233.3, -548);
//   %wire_6781 @TEXT("VDD", size=1, halign="middle", valign="baseline", rotate=90) => @PLACE(281.3, 12);
//   %wire_6616 @TEXT("VDD", size=1, halign="middle", valign="baseline") => @PLACE(-7, -471.3);
//   %wire_6515 @TEXT("VDD", size=1, halign="middle", valign="top", rotate=90) => @PLACE(99.7, -417);
//   %wire_6831 @TEXT("VDD", size=1, halign="middle", valign="baseline", rotate=90) => @PLACE(168.3, -756);
//   %wire_6768 @TEXT("VDD", size=1, halign="middle", valign="baseline", rotate=90) => @PLACE(149.3, -548);
//   %wire_6805 @TEXT("VDD", size=1, halign="middle", valign="baseline", rotate=90) => @PLACE(257.3, -338);
//   %wire_6792 @TEXT("VDD", size=1, halign="middle", valign="baseline", rotate=90) => @PLACE(401.3, -373);
//   %wire_6425 @TEXT("VDD", size=1, halign="middle", valign="baseline", rotate=90) => @PLACE(125.3, -408);
//   %wire_6708 @TEXT("VDD", size=1, halign="middle", valign="baseline") => @PLACE(-14, -331.3);
//   %wire_6813 @TEXT("VDD", size=1, halign="middle", valign="baseline", rotate=90) => @PLACE(329.3, -723);
//   %wire_6732 @TEXT("VDD", size=1, halign="middle", valign="baseline", rotate=90) => @PLACE(305.3, -513);
//   %wire_6606 @TEXT("VDD", size=1, halign="middle", valign="baseline", rotate=90) => @PLACE(353.3, -723);
//   %wire_6714 @TEXT("VDD", size=1, halign="middle", valign="baseline", rotate=90) => @PLACE(353.3, -513);
//   %wire_6415 @TEXT("VDD", size=1, halign="middle", valign="baseline", rotate=90) => @PLACE(329.3, -653);
//   %wire_6711 @TEXT("VDD", size=1, halign="middle", valign="baseline", rotate=90) => @PLACE(281.3, -303);
//   %wire_6723 @TEXT("VDD", size=1, halign="middle", valign="baseline", rotate=90) => @PLACE(281.3, -443);
//   %wire_6408 @TEXT("VDD", size=1, halign="middle", valign="baseline", rotate=90) => @PLACE(305.3, -723);
//   %wire_6408 @TEXT("VDD", size=1, halign="middle", valign="baseline", rotate=90) => @PLACE(305.3, -723);
//   %wire_6724 @TEXT("VDD", size=1, halign="middle", valign="baseline", rotate=90) => @PLACE(39.3, -478);
//   %wire_6703 @TEXT("VDD", size=1, halign="middle", valign="baseline", rotate=90) => @PLACE(305.3, -653);
//   %wire_6753 @TEXT("VDD", size=1, halign="middle", valign="baseline", rotate=90) => @PLACE(87.3, -338);
//   %wire_6710 @TEXT("VDD", size=1, halign="middle", valign="baseline", rotate=90) => @PLACE(87.3, -513);
//   %wire_6715 @TEXT("VDD", size=1, halign="middle", valign="baseline", rotate=90) => @PLACE(257.3, -128);
//   %wire_6549 @TEXT("VDD", size=1, halign="middle", valign="baseline", rotate=90) => @PLACE(173.3, -723);
//   %wire_6464 @TEXT("VDD", size=1, halign="middle", valign="top", rotate=90) => @PLACE(99.7, -522);
//   %wire_6732 @TEXT("VDD", size=1, halign="middle", valign="baseline", rotate=90) => @PLACE(305.3, -513);
//   %wire_6803 @TEXT("VDD", size=1, halign="middle", valign="baseline", rotate=90) => @PLACE(281.3, -338);
//   %wire_6706 @TEXT("VDD", size=1, halign="middle", valign="baseline", rotate=90) => @PLACE(353.3, -128);
//   %wire_6766 @TEXT("VDD", size=1, halign="middle", valign="baseline", rotate=90) => @PLACE(413.3, -318);
//   %wire_6790 @TEXT("VDD", size=1, halign="middle", valign="baseline", rotate=90) => @PLACE(15.3, -303);
//   %wire_6763 @TEXT("VDD", size=1, halign="middle", valign="baseline", rotate=90) => @PLACE(197.3, -443);
//   %wire_6693 @TEXT("VDD", size=1, halign="middle", valign="baseline", rotate=90) => @PLACE(428.3, -727);
//   %wire_6697 @TEXT("VDD", size=1, halign="middle", valign="baseline", rotate=90) => @PLACE(353.3, -408);
//   %wire_6690 @TEXT("VDD", size=1, halign="middle", valign="baseline", rotate=90) => @PLACE(15.3, -548);
//   %wire_6442 @TEXT("VDD", size=1, halign="middle", valign="baseline", rotate=90) => @PLACE(197.3, -373);
//   %wire_6797 @TEXT("VDD", size=1, halign="middle", valign="baseline", rotate=90) => @PLACE(-44.7, 44);
//   %wire_6830 @TEXT("VDD", size=1, halign="middle", valign="baseline", rotate=90) => @PLACE(39.3, -443);
//   %wire_6692 @TEXT("VDD", size=1, halign="middle", valign="baseline", rotate=90) => @PLACE(305.3, -478);
//   %wire_6445 @TEXT("VDD", size=1, halign="middle", valign="baseline", rotate=90) => @PLACE(63.3, -373);
//   %wire_6698 @TEXT("VDD", size=1, halign="middle", valign="baseline", rotate=90) => @PLACE(281.3, -373);
//   %wire_6686 @TEXT("VDD", size=1, halign="middle", valign="baseline", rotate=90) => @PLACE(329.3, -443);
//   %wire_6686 @TEXT("VDD", size=1, halign="middle", valign="baseline", rotate=90) => @PLACE(329.3, -443);
//   %wire_6685 @TEXT("VDD", size=1, halign="middle", valign="baseline", rotate=90) => @PLACE(401.3, -408);
//   %wire_6689 @TEXT("VDD", size=1, halign="middle", valign="baseline", rotate=90) => @PLACE(15.3, -478);
//   %wire_6682 @TEXT("VDD", size=1, halign="middle", valign="baseline", rotate=90) => @PLACE(63.3, -478);
//   %wire_6694 @TEXT("VDD", size=1, halign="middle", valign="baseline", rotate=90) => @PLACE(39.3, -373);
//   %wire_6668 @TEXT("VDD", size=1, halign="middle", valign="baseline", rotate=90) => @PLACE(401.3, -233);
//   %wire_6807 @TEXT("VDD", size=1, halign="middle", valign="baseline", rotate=90) => @PLACE(87.3, -548);
//   %wire_6675 @TEXT("VDD", size=1, halign="middle", valign="baseline", rotate=90) => @PLACE(39.3, -338);
//   %wire_6565 @TEXT("VDD", size=1, halign="middle", valign="baseline", rotate=90) => @PLACE(-44.7, -236);
//   %wire_6683 @TEXT("VDD", size=1, halign="middle", valign="baseline", rotate=90) => @PLACE(257.3, -408);
//   %wire_6688 @TEXT("VDD", size=1, halign="middle", valign="baseline", rotate=90) => @PLACE(125.3, -373);
//   %wire_6500 @TEXT("VDD", size=1, halign="middle", valign="baseline", rotate=90) => @PLACE(233.3, -583);
//   %wire_6712 @TEXT("VDD", size=1, halign="middle", valign="baseline", rotate=90) => @PLACE(-55.7, -201);
//   %wire_6695 @TEXT("VDD", size=1, halign="middle", valign="baseline", rotate=90) => @PLACE(305.3, -303);
//   %wire_6695 @TEXT("VDD", size=1, halign="middle", valign="baseline", rotate=90) => @PLACE(305.3, -303);
//   %wire_6677 @TEXT("VDD", size=1, halign="middle", valign="baseline", rotate=90) => @PLACE(125.3, -478);
//   %wire_6833 @TEXT("VDD", size=1, halign="middle", valign="baseline", rotate=90) => @PLACE(125.3, -513);
//   %wire_6676 @TEXT("VDD", size=1, halign="middle", valign="baseline") => @PLACE(-7, -261.3);
//   %wire_6655 @TEXT("VDD", size=1, halign="middle", valign="baseline", rotate=90) => @PLACE(63.3, -513);
//   %wire_6508 @TEXT("VDD", size=1, halign="middle", valign="baseline", rotate=90) => @PLACE(257.3, -303);
//   %wire_6667 @TEXT("VDD", size=1, halign="middle", valign="baseline", rotate=90) => @PLACE(233.3, -268);
//   %wire_6440 @TEXT("VDD", size=1, halign="middle", valign="baseline") => @PLACE(-7, -121.3);
//   %wire_6659 @TEXT("VDD", size=1, halign="middle", valign="baseline", rotate=90) => @PLACE(63.3, -443);
//   %wire_6664 @TEXT("VDD", size=1, halign="middle", valign="baseline", rotate=90) => @PLACE(39.3, -198);
//   %wire_6663 @TEXT("VDD", size=1, halign="middle", valign="baseline", rotate=90) => @PLACE(173.3, -443);
//   %wire_6662 @TEXT("VDD", size=1, halign="middle", valign="baseline", rotate=90) => @PLACE(87.3, -198);
//   %wire_6496 @TEXT("VDD", size=1, halign="middle", valign="baseline", rotate=90) => @PLACE(257.3, -653);
//   %wire_6642 @TEXT("VDD", size=1, halign="middle", valign="baseline", rotate=90) => @PLACE(377.3, -513);
//   %wire_6660 @TEXT("VDD", size=1, halign="middle", valign="baseline", rotate=90) => @PLACE(305.3, -198);
//   %wire_6628 @TEXT("VDD", size=1, halign="middle", valign="baseline", rotate=90) => @PLACE(173.3, -198);
//   %wire_6632 @TEXT("VDD", size=1, halign="middle", valign="baseline", rotate=90) => @PLACE(329.3, -198);
//   %wire_6658 @TEXT("VDD", size=1, halign="middle", valign="baseline", rotate=90) => @PLACE(233.3, -408);
//   %wire_6623 @TEXT("VDD", size=1, halign="middle", valign="baseline", rotate=90) => @PLACE(-44.7, -96);
//   %wire_6656 @TEXT("VDD", size=1, halign="middle", valign="baseline", rotate=90) => @PLACE(125.3, -653);
//   %wire_6649 @TEXT("VDD", size=1, halign="middle", valign="baseline", rotate=90) => @PLACE(173.3, -513);
//   %wire_6645 @TEXT("VDD", size=1, halign="middle", valign="baseline", rotate=90) => @PLACE(329.3, 12);
//   %wire_6824 @TEXT("VDD", size=1, halign="middle", valign="baseline", rotate=90) => @PLACE(63.3, -23);
//   %wire_6652 @TEXT("VDD", size=1, halign="middle", valign="baseline") => @PLACE(-10, -296.3);
//   %wire_6650 @TEXT("VDD", size=1, halign="middle", valign="baseline", rotate=90) => @PLACE(305.3, -58);
//   %wire_6648 @TEXT("VDD", size=1, halign="middle", valign="baseline", rotate=90) => @PLACE(401.3, -268);
//   %wire_6644 @TEXT("VDD", size=1, halign="middle", valign="baseline", rotate=90) => @PLACE(15.3, -23);
//   %wire_6637 @TEXT("VDD", size=1, halign="middle", valign="baseline", rotate=90) => @PLACE(125.3, -23);
//   %wire_6646 @TEXT("VDD", size=1, halign="middle", valign="baseline", rotate=90) => @PLACE(-55.7, -26);
//   %wire_6597 @TEXT("VDD", size=1, halign="middle", valign="baseline", rotate=90) => @PLACE(353.3, 12);
//   %wire_6639 @TEXT("VDD", size=1, halign="middle", valign="baseline") => @PLACE(-14, -191.3);
//   %wire_6647 @TEXT("VDD", size=1, halign="middle", valign="baseline") => @PLACE(-7, -191.3);
//   %wire_6636 @TEXT("VDD", size=1, halign="middle", valign="baseline", rotate=90) => @PLACE(39.3, -268);
//   %wire_6642 @TEXT("VDD", size=1, halign="middle", valign="baseline", rotate=90) => @PLACE(377.3, -513);
//   %wire_6633 @TEXT("VDD", size=1, halign="middle", valign="baseline", rotate=90) => @PLACE(377.3, -583);
//   %wire_6640 @TEXT("VDD", size=1, halign="middle", valign="baseline", rotate=90) => @PLACE(413.3, -598);
//   %wire_6503 @TEXT("VDD", size=1, halign="middle", valign="baseline", rotate=90) => @PLACE(87.3, -268);
//   %wire_6340 @TEXT("VDD", size=1, halign="middle", valign="baseline", rotate=90) => @PLACE(-55.7, -551);
//   %wire_6499 @TEXT("VDD", size=1, halign="middle", valign="baseline", rotate=90) => @PLACE(173.3, -268);
//   %wire_6635 @TEXT("VDD", size=1, halign="middle", valign="baseline", rotate=90) => @PLACE(197.3, -268);
//   %wire_6498 @TEXT("VDD", size=1, halign="middle", valign="baseline", rotate=90) => @PLACE(281.3, -268);
//   %wire_6502 @TEXT("VDD", size=1, halign="middle", valign="baseline", rotate=90) => @PLACE(15.3, -653);
//   %wire_6474 @TEXT("VDD", size=1, halign="middle", valign="baseline") => @PLACE(-17, -506.3);
//   %wire_6621 @TEXT("VDD", size=1, halign="middle", valign="baseline", rotate=90) => @PLACE(281.3, -198);
//   %wire_6608 @TEXT("VDD", size=1, halign="middle", valign="top", rotate=90) => @PLACE(99.7, -382);
//   %wire_6603 @TEXT("VDD", size=1, halign="middle", valign="baseline", rotate=90) => @PLACE(281.3, -128);
//   %wire_6617 @TEXT("VDD", size=1, halign="middle", valign="baseline", rotate=90) => @PLACE(197.3, -198);
//   %wire_6625 @TEXT("VDD", size=1, halign="middle", valign="baseline", rotate=90) => @PLACE(-32.7, -376);
//   %wire_6624 @TEXT("VDD", size=1, halign="middle", valign="baseline", rotate=90) => @PLACE(-32.7, -446);
//   %wire_6444 @TEXT("VDD", size=1, halign="middle", valign="baseline", rotate=90) => @PLACE(329.3, -303);
//   %wire_6449 @TEXT("VDD", size=1, halign="middle", valign="baseline", rotate=90) => @PLACE(197.3, -583);
//   %wire_6451 @TEXT("VDD", size=1, halign="middle", valign="baseline", rotate=90) => @PLACE(149.3, -268);
//   %wire_6448 @TEXT("VDD", size=1, halign="middle", valign="baseline", rotate=90) => @PLACE(15.3, -338);
//   %wire_6511 @TEXT("VDD", size=1, halign="middle", valign="baseline", rotate=90) => @PLACE(149.3, -723);
//   %wire_6582 @TEXT("VDD", size=1, halign="middle", valign="baseline", rotate=90) => @PLACE(329.3, -513);
//   %wire_6507 @TEXT("VDD", size=1, halign="middle", valign="baseline", rotate=90) => @PLACE(-55.7, -306);
//   %wire_6497 @TEXT("VDD", size=1, halign="middle", valign="baseline", rotate=90) => @PLACE(149.3, -198);
//   %wire_6604 @TEXT("VDD", size=1, halign="middle", valign="top", rotate=90) => @PLACE(99.7, -732);
//   %wire_6446 @TEXT("VDD", size=1, halign="middle", valign="baseline", rotate=90) => @PLACE(413.3, -423);
//   %wire_6794 @TEXT("VDD", size=1, halign="middle", valign="baseline", rotate=90) => @PLACE(-55.7, -236);
//   %wire_6653 @TEXT("VDD", size=1, halign="middle", valign="baseline", rotate=90) => @PLACE(401.3, 12);
//   %wire_6453 @TEXT("VDD", size=1, halign="middle", valign="baseline", rotate=90) => @PLACE(413.3, -283);
//   %wire_6495 @TEXT("VDD", size=1, halign="middle", valign="baseline", rotate=90) => @PLACE(-44.7, -411);
//   %wire_6305 @TEXT("VDD", size=1, halign="middle", valign="baseline", rotate=90) => @PLACE(-44.7, 79);
//   %wire_6494 @TEXT("VDD", size=1, halign="middle", valign="baseline", rotate=90) => @PLACE(197.3, -128);
//   %wire_6482 @TEXT("VDD", size=1, halign="middle", valign="baseline", rotate=90) => @PLACE(413.3, -143);
//   %wire_6407 @TEXT("VDD", size=1, halign="middle", valign="baseline", rotate=90) => @PLACE(-55.7, -586);
//   %wire_6436 @TEXT("VDD", size=1, halign="middle", valign="baseline", rotate=90) => @PLACE(401.3, -653);
//   %wire_6627 @TEXT("VDD", size=1, halign="middle", valign="baseline", rotate=90) => @PLACE(63.3, -198);
//   %wire_6629 @TEXT("VDD", size=1, halign="middle", valign="baseline", rotate=90) => @PLACE(305.3, -128);
//   %wire_6600 @TEXT("VDD", size=1, halign="middle", valign="baseline", rotate=90) => @PLACE(413.3, -38);
//   %wire_6611 @TEXT("VDD", size=1, halign="middle", valign="baseline") => @PLACE(-14, -401.3);
//   %wire_6602 @TEXT("VDD", size=1, halign="middle", valign="baseline", rotate=90) => @PLACE(173.3, -58);
//   %wire_6601 @TEXT("VDD", size=1, halign="middle", valign="baseline") => @PLACE(-7, -401.3);
//   %wire_6486 @TEXT("VDD", size=1, halign="middle", valign="baseline", rotate=90) => @PLACE(329.3, -58);
//   %wire_6589 @TEXT("VDD", size=1, halign="middle", valign="baseline", rotate=90) => @PLACE(-55.7, -516);
//   %wire_6410 @TEXT("VDD", size=1, halign="middle", valign="baseline", rotate=90) => @PLACE(-55.7, -481);
//   %wire_6634 @TEXT("VDD", size=1, halign="middle", valign="baseline", rotate=90) => @PLACE(149.3, -58);
//   %wire_6743 @TEXT("VDD", size=1, halign="middle", valign="top", rotate=90) => @PLACE(99.7, -207);
//   %wire_6543 @TEXT("VDD", size=1, halign="middle", valign="baseline", rotate=90) => @PLACE(401.3, -23);
//   %wire_6487 @TEXT("VDD", size=1, halign="middle", valign="baseline", rotate=90) => @PLACE(281.3, -58);
//   %wire_6643 @TEXT("VDD", size=1, halign="middle", valign="baseline", rotate=90) => @PLACE(305.3, -23);
//   %wire_6598 @TEXT("VDD", size=1, halign="middle", valign="baseline", rotate=90) => @PLACE(39.3, 12);
//   %wire_6592 @TEXT("VDD", size=1, halign="middle", valign="baseline", rotate=90) => @PLACE(377.3, 12);
//   %wire_6434 @TEXT("VDD", size=1, halign="middle", valign="baseline", rotate=90) => @PLACE(329.3, -408);
//   %wire_6596 @TEXT("VDD", size=1, halign="middle", valign="baseline", rotate=90) => @PLACE(305.3, -443);
//   %wire_6594 @TEXT("VDD", size=1, halign="middle", valign="baseline", rotate=90) => @PLACE(197.3, -23);
//   %wire_6591 @TEXT("VDD", size=1, halign="middle", valign="baseline", rotate=90) => @PLACE(377.3, -268);
//   %wire_6595 @TEXT("VDD", size=1, halign="middle", valign="baseline", rotate=90) => @PLACE(-44.7, -446);
//   %wire_6405 @TEXT("VDD", size=1, halign="middle", valign="top", rotate=90) => @PLACE(99.7, -662);
//   %wire_6520 @TEXT("VDD", size=1, halign="middle", valign="baseline", rotate=90) => @PLACE(257.3, -23);
//   %wire_6585 @TEXT("VDD", size=1, halign="middle", valign="baseline", rotate=90) => @PLACE(-44.7, -376);
//   %wire_6593 @TEXT("VDD", size=1, halign="middle", valign="baseline", rotate=90) => @PLACE(-44.7, -61);
//   %wire_6249 @TEXT("VDD", size=1, halign="middle", valign="baseline", rotate=90) => @PLACE(-55.7, -446);
//   %wire_6557 @TEXT("VDD", size=1, halign="middle", valign="baseline", rotate=90) => @PLACE(149.3, -653);
//   %wire_6415 @TEXT("VDD", size=1, halign="middle", valign="baseline", rotate=90) => @PLACE(329.3, -653);
//   %wire_6437 @TEXT("VDD", size=1, halign="middle", valign="baseline", rotate=90) => @PLACE(257.3, -583);
//   %wire_6558 @TEXT("VDD", size=1, halign="middle", valign="baseline", rotate=90) => @PLACE(-55.7, -341);
//   %wire_6577 @TEXT("VDD", size=1, halign="middle", valign="baseline", rotate=90) => @PLACE(-44.7, -341);
//   %wire_6703 @TEXT("VDD", size=1, halign="middle", valign="baseline", rotate=90) => @PLACE(305.3, -653);
//   %wire_6568 @TEXT("VDD", size=1, halign="middle", valign="baseline", rotate=90) => @PLACE(413.3, -388);
//   %wire_6836 @TEXT("VDD", size=1, halign="middle", valign="baseline", rotate=90) => @PLACE(377.3, -373);
//   %wire_6566 @TEXT("VDD", size=1, halign="middle", valign="baseline", rotate=90) => @PLACE(401.3, -338);
//   %wire_6789 @TEXT("VDD", size=1, halign="middle", valign="baseline", rotate=90) => @PLACE(401.3, -513);
//   %wire_6580 @TEXT("VDD", size=1, halign="middle", valign="baseline", rotate=90) => @PLACE(377.3, -303);
//   %wire_6680 @TEXT("VDD", size=1, halign="middle", valign="baseline", rotate=90) => @PLACE(15.3, -373);
//   %wire_6575 @TEXT("VDD", size=1, halign="middle", valign="baseline", rotate=90) => @PLACE(87.3, -128);
//   %wire_6718 @TEXT("VDD", size=1, halign="middle", valign="baseline", rotate=90) => @PLACE(149.3, -128);
//   %wire_6713 @TEXT("VDD", size=1, halign="middle", valign="baseline", rotate=90) => @PLACE(281.3, -723);
//   %wire_6638 @TEXT("VDD", size=1, halign="middle", valign="baseline", rotate=90) => @PLACE(257.3, -513);
//   %wire_6832 @TEXT("VDD", size=1, halign="middle", valign="baseline", rotate=90) => @PLACE(15.3, -443);
//   %wire_6564 @TEXT("VDD", size=1, halign="middle", valign="baseline", rotate=90) => @PLACE(15.3, -408);
//   %wire_6554 @TEXT("VDD", size=1, halign="middle", valign="baseline", rotate=90) => @PLACE(-32.7, -236);
//   %wire_6847 @TEXT("VDD", size=1, halign="middle", valign="baseline", rotate=90) => @PLACE(233.3, -233);
//   %wire_6579 @TEXT("VDD", size=1, halign="middle", valign="baseline", rotate=90) => @PLACE(87.3, -23);
//   %wire_6701 @TEXT("VDD", size=1, halign="middle", valign="baseline", rotate=90) => @PLACE(149.3, -23);
//   %wire_6852 @TEXT("VDD", size=1, halign="middle", valign="baseline", rotate=90) => @PLACE(377.3, -58);
//   %wire_6785 @TEXT("VDD", size=1, halign="middle", valign="baseline", rotate=90) => @PLACE(329.3, -128);
//   %wire_6555 @TEXT("VDD", size=1, halign="middle", valign="baseline", rotate=90) => @PLACE(281.3, -478);
//   %wire_6552 @TEXT("VDD", size=1, halign="middle", valign="baseline", rotate=90) => @PLACE(257.3, -373);
//   %wire_6570 @TEXT("VDD", size=1, halign="middle", valign="baseline", rotate=90) => @PLACE(-44.7, -271);
//   %wire_6684 @TEXT("VDD", size=1, halign="middle", valign="baseline", rotate=90) => @PLACE(-44.7, -306);
//   %wire_6771 @TEXT("VDD", size=1, halign="middle", valign="baseline", rotate=90) => @PLACE(-55.7, -271);
//   %wire_6548 @TEXT("VDD", size=1, halign="middle", valign="baseline", rotate=90) => @PLACE(353.3, -198);
//   %wire_6576 @TEXT("VDD", size=1, halign="middle", valign="baseline", rotate=90) => @PLACE(-32.7, -306);
//   %wire_6546 @TEXT("VDD", size=1, halign="middle", valign="baseline", rotate=90) => @PLACE(353.3, -338);
//   %wire_6543 @TEXT("VDD", size=1, halign="middle", valign="baseline", rotate=90) => @PLACE(401.3, -23);
//   %wire_6837 @TEXT("VDD", size=1, halign="middle", valign="baseline", rotate=90) => @PLACE(305.3, -373);
//   %wire_6541 @TEXT("VDD", size=1, halign="middle", valign="baseline") => @PLACE(-17, -296.3);
//   %wire_6540 @TEXT("VDD", size=1, halign="middle", valign="baseline", rotate=90) => @PLACE(-32.7, -341);
//   %wire_6630 @TEXT("VDD", size=1, halign="middle", valign="baseline") => @PLACE(-14, -471.3);
//   %wire_6397 @TEXT("VDD", size=1, halign="middle", valign="top", rotate=90) => @PLACE(207.7, -627);
//   %wire_6581 @TEXT("VDD", size=1, halign="middle", valign="baseline") => @PLACE(-10, -366.3);
//   %wire_6752 @TEXT("VDD", size=1, halign="middle", valign="baseline", rotate=90) => @PLACE(233.3, -723);
//   %wire_6535 @TEXT("VDD", size=1, halign="middle", valign="baseline", rotate=90) => @PLACE(353.3, -653);
//   %wire_6533 @TEXT("VDD", size=1, halign="middle", valign="baseline", rotate=90) => @PLACE(39.3, -408);
//   %wire_6528 @TEXT("VDD", size=1, halign="middle", valign="baseline", rotate=90) => @PLACE(329.3, -373);
//   %wire_6531 @TEXT("VDD", size=1, halign="middle", valign="baseline") => @PLACE(-17, -156.3);
//   %wire_6780 @TEXT("VDD", size=1, halign="middle", valign="baseline", rotate=90) => @PLACE(377.3, -723);
//   %wire_6687 @TEXT("VDD", size=1, halign="middle", valign="baseline", rotate=90) => @PLACE(-55.7, 44);
//   %wire_6528 @TEXT("VDD", size=1, halign="middle", valign="baseline", rotate=90) => @PLACE(329.3, -373);
//   %wire_6437 @TEXT("VDD", size=1, halign="middle", valign="baseline", rotate=90) => @PLACE(257.3, -583);
//   %wire_6529 @TEXT("VDD", size=1, halign="middle", valign="baseline", rotate=90) => @PLACE(401.3, -303);
//   %wire_6529 @TEXT("VDD", size=1, halign="middle", valign="baseline", rotate=90) => @PLACE(401.3, -303);
//   %wire_6571 @TEXT("VDD", size=1, halign="middle", valign="baseline", rotate=90) => @PLACE(15.3, -723);
//   %wire_6587 @TEXT("VDD", size=1, halign="middle", valign="baseline", rotate=90) => @PLACE(173.3, -128);
//   %wire_6525 @TEXT("VDD", size=1, halign="middle", valign="baseline", rotate=90) => @PLACE(149.3, -408);
//   %wire_6583 @TEXT("VDD", size=1, halign="middle", valign="baseline", rotate=90) => @PLACE(173.3, -338);
//   %wire_6246 @TEXT("VDD", size=1, halign="middle", valign="baseline") => @PLACE(-17, -86.3);
//   %wire_6523 @TEXT("VDD", size=1, halign="middle", valign="baseline", rotate=90) => @PLACE(39.3, -548);
//   %wire_6522 @TEXT("VDD", size=1, halign="middle", valign="baseline", rotate=90) => @PLACE(173.3, -408);
//   %wire_6521 @TEXT("VDD", size=1, halign="middle", valign="baseline", rotate=90) => @PLACE(-55.7, -411);
//   %wire_6526 @TEXT("VDD", size=1, halign="middle", valign="baseline") => @PLACE(-10, -86.3);
//   %wire_6638 @TEXT("VDD", size=1, halign="middle", valign="baseline", rotate=90) => @PLACE(257.3, -513);
//   %wire_6739 @TEXT("VDD", size=1, halign="middle", valign="top", rotate=90) => @PLACE(99.7, -312);
//   %wire_6517 @TEXT("VDD", size=1, halign="middle", valign="baseline", rotate=90) => @PLACE(125.3, -723);
//   %wire_6619 @TEXT("VDD", size=1, halign="middle", valign="baseline", rotate=90) => @PLACE(173.3, -23);
//   %wire_6514 @TEXT("VDD", size=1, halign="middle", valign="baseline", rotate=90) => @PLACE(-32.7, -201);
//   %wire_6513 @TEXT("VDD", size=1, halign="middle", valign="baseline", rotate=90) => @PLACE(281.3, -408);
//   %wire_6700 @TEXT("VDD", size=1, halign="middle", valign="baseline", rotate=90) => @PLACE(39.3, -653);
//   %wire_6512 @TEXT("VDD", size=1, halign="middle", valign="baseline", rotate=90) => @PLACE(329.3, -268);
//   %wire_6520 @TEXT("VDD", size=1, halign="middle", valign="baseline", rotate=90) => @PLACE(257.3, -23);
//   %wire_6733 @TEXT("VDD", size=1, halign="middle", valign="baseline", rotate=90) => @PLACE(353.3, -268);
//   %wire_6786 @TEXT("VDD", size=1, halign="middle", valign="baseline", rotate=90) => @PLACE(305.3, -408);
//   %wire_6773 @TEXT("VDD", size=1, halign="middle", valign="baseline", rotate=90) => @PLACE(413.3, -458);
//   %wire_6509 @TEXT("VDD", size=1, halign="middle", valign="baseline", rotate=90) => @PLACE(377.3, -408);
//   %wire_6508 @TEXT("VDD", size=1, halign="middle", valign="baseline", rotate=90) => @PLACE(257.3, -303);
//   %wire_6506 @TEXT("VDD", size=1, halign="middle", valign="baseline", rotate=90) => @PLACE(39.3, -583);
//   %wire_6505 @TEXT("VDD", size=1, halign="middle", valign="baseline", rotate=90) => @PLACE(197.3, -338);
//   %wire_6605 @TEXT("VDD", size=1, halign="middle", valign="baseline", rotate=90) => @PLACE(149.3, -583);
//   %wire_6501 @TEXT("VDD", size=1, halign="middle", valign="baseline", rotate=90) => @PLACE(173.3, -583);
//   %wire_6726 @TEXT("VDD", size=1, halign="middle", valign="baseline", rotate=90) => @PLACE(377.3, -653);
//   %wire_6524 @TEXT("VDD", size=1, halign="middle", valign="baseline", rotate=90) => @PLACE(39.3, -723);
//   %wire_6493 @TEXT("VDD", size=1, halign="middle", valign="baseline", rotate=90) => @PLACE(125.3, -128);
//   %wire_6491 @TEXT("VDD", size=1, halign="middle", valign="baseline", rotate=90) => @PLACE(353.3, -58);
//   %wire_6804 @TEXT("VDD", size=1, halign="middle", valign="baseline", rotate=90) => @PLACE(233.3, -23);
//   %wire_6490 @TEXT("VDD", size=1, halign="middle", valign="baseline", rotate=90) => @PLACE(329.3, -338);
//   %wire_6489 @TEXT("VDD", size=1, halign="middle", valign="baseline", rotate=90) => @PLACE(15.3, 12);
//   %wire_6485 @TEXT("VDD", size=1, halign="middle", valign="top", rotate=90) => @PLACE(99.7, -452);
//   %wire_6259 @TEXT("VDD", size=1, halign="middle", valign="baseline") => @PLACE(-14, 18.7);
//   %wire_6654 @TEXT("VDD", size=1, halign="middle", valign="baseline", rotate=90) => @PLACE(233.3, -128);
//   %wire_6481 @TEXT("VDD", size=1, halign="middle", valign="baseline", rotate=90) => @PLACE(-0.7, -756);
//   %wire_6674 @TEXT("VDD", size=1, halign="middle", valign="baseline", rotate=90) => @PLACE(125.3, -583);
//   %wire_6584 @TEXT("VDD", size=1, halign="middle", valign="baseline", rotate=90) => @PLACE(413.3, -213);
//   %wire_6673 @TEXT("VDD", size=1, halign="middle", valign="baseline", rotate=90) => @PLACE(63.3, -268);
//   %wire_6626 @TEXT("VDD", size=1, halign="middle", valign="baseline", rotate=90) => @PLACE(63.3, -583);
//   %wire_6670 @TEXT("VDD", size=1, halign="middle", valign="baseline", rotate=90) => @PLACE(329.3, -583);
//   %wire_6672 @TEXT("VDD", size=1, halign="middle", valign="baseline", rotate=90) => @PLACE(353.3, -583);
//   %wire_6669 @TEXT("VDD", size=1, halign="middle", valign="baseline", rotate=90) => @PLACE(257.3, -268);
//   %wire_6678 @TEXT("VDD", size=1, halign="middle", valign="baseline", rotate=90) => @PLACE(233.3, -338);
//   %wire_6582 @TEXT("VDD", size=1, halign="middle", valign="baseline", rotate=90) => @PLACE(329.3, -513);
//   %wire_6542 @TEXT("VDD", size=1, halign="middle", valign="baseline", rotate=90) => @PLACE(353.3, -443);
//   %wire_6477 @TEXT("VDD", size=1, halign="middle", valign="baseline", rotate=90) => @PLACE(377.3, -443);
//   %wire_6443 @TEXT("VDD", size=1, halign="middle", valign="baseline", rotate=90) => @PLACE(173.3, -478);
//   %wire_6696 @TEXT("VDD", size=1, halign="middle", valign="baseline", rotate=90) => @PLACE(353.3, -233);
//   %wire_6668 @TEXT("VDD", size=1, halign="middle", valign="baseline", rotate=90) => @PLACE(401.3, -233);
//   %wire_6547 @TEXT("VDD", size=1, halign="middle", valign="baseline", rotate=90) => @PLACE(353.3, -23);
//   %wire_6657 @TEXT("VDD", size=1, halign="middle", valign="baseline", rotate=90) => @PLACE(-55.7, -166);
//   %wire_6472 @TEXT("VDD", size=1, halign="middle", valign="baseline", rotate=90) => @PLACE(100.3, -789);
//   %wire_6471 @TEXT("VDD", size=1, halign="middle", valign="baseline", rotate=90) => @PLACE(401.3, -58);
//   %wire_6641 @TEXT("VDD", size=1, halign="middle", valign="top", rotate=90) => @PLACE(99.7, -557);
//   %wire_6468 @TEXT("VDD", size=1, halign="middle", valign="baseline", rotate=90) => @PLACE(125.3, 12);
//   %wire_6467 @TEXT("VDD", size=1, halign="middle", valign="baseline", rotate=90) => @PLACE(87.3, 12);
//   %wire_6465 @TEXT("VDD", size=1, halign="middle", valign="baseline", rotate=90) => @PLACE(149.3, 12);
//   %wire_6466 @TEXT("VDD", size=1, halign="middle", valign="baseline", rotate=90) => @PLACE(63.3, 12);
//   %wire_6470 @TEXT("VDD", size=1, halign="middle", valign="baseline", rotate=90) => @PLACE(173.3, 12);
//   %wire_6643 @TEXT("VDD", size=1, halign="middle", valign="baseline", rotate=90) => @PLACE(305.3, -23);
//   %wire_6463 @TEXT("VDD", size=1, halign="middle", valign="baseline", rotate=90) => @PLACE(-44.7, -516);
//   %wire_6462 @TEXT("VDD", size=1, halign="middle", valign="baseline", rotate=90) => @PLACE(-32.7, 9);
//   %wire_6460 @TEXT("VDD", size=1, halign="middle", valign="baseline", rotate=90) => @PLACE(-44.7, 9);
//   %wire_6454 @TEXT("VDD", size=1, halign="middle", valign="baseline", rotate=90) => @PLACE(133.3, -756);
//   %wire_6651 @TEXT("VDD", size=1, halign="middle", valign="top", rotate=90) => @PLACE(99.7, -277);
//   %wire_6452 @TEXT("VDD", size=1, halign="middle", valign="baseline", rotate=90) => @PLACE(109.3, -756);
//   %wire_6823 @TEXT("VDD", size=1, halign="middle", valign="baseline", rotate=90) => @PLACE(305.3, -583);
//   %wire_6795 @TEXT("VDD", size=1, halign="middle", valign="baseline", rotate=90) => @PLACE(208.3, -778);
//   %wire_6670 @TEXT("VDD", size=1, halign="middle", valign="baseline", rotate=90) => @PLACE(329.3, -583);
//   %wire_6672 @TEXT("VDD", size=1, halign="middle", valign="baseline", rotate=90) => @PLACE(353.3, -583);
//   %wire_6633 @TEXT("VDD", size=1, halign="middle", valign="baseline", rotate=90) => @PLACE(377.3, -583);
//   %wire_6450 @TEXT("VDD", size=1, halign="middle", valign="baseline", rotate=90) => @PLACE(63.3, -653);
//   %wire_6709 @TEXT("VDD", size=1, halign="middle", valign="top", rotate=90) => @PLACE(99.7, -67);
//   %wire_6573 @TEXT("VDD", size=1, halign="middle", valign="baseline", rotate=90) => @PLACE(-32.7, -271);
//   %wire_6480 @TEXT("VDD", size=1, halign="middle", valign="baseline", rotate=90) => @PLACE(149.3, -513);
//   %wire_6562 @TEXT("VDD", size=1, halign="middle", valign="baseline") => @PLACE(-17, -226.3);
//   %wire_6479 @TEXT("VDD", size=1, halign="middle", valign="baseline", rotate=90) => @PLACE(233.3, -443);
//   %wire_6478 @TEXT("VDD", size=1, halign="middle", valign="baseline", rotate=90) => @PLACE(149.3, -478);
//   %wire_6622 @TEXT("VDD", size=1, halign="middle", valign="baseline", rotate=90) => @PLACE(257.3, -478);
//   %wire_6476 @TEXT("VDD", size=1, halign="middle", valign="baseline") => @PLACE(-10, -156.3);
//   %wire_6475 @TEXT("VDD", size=1, halign="middle", valign="baseline", rotate=90) => @PLACE(87.3, -478);
//   %wire_6423 @TEXT("VDD", size=1, halign="middle", valign="baseline", rotate=90) => @PLACE(401.3, -443);
//   %wire_6681 @TEXT("VDD", size=1, halign="middle", valign="baseline", rotate=90) => @PLACE(87.3, -653);
//   %wire_6435 @TEXT("VDD", size=1, halign="middle", valign="baseline", rotate=90) => @PLACE(47.3, -756);
//   %wire_6596 @TEXT("VDD", size=1, halign="middle", valign="baseline", rotate=90) => @PLACE(305.3, -443);
//   %wire_6433 @TEXT("VDD", size=1, halign="middle", valign="baseline", rotate=90) => @PLACE(125.3, -268);
//   %wire_6423 @TEXT("VDD", size=1, halign="middle", valign="baseline", rotate=90) => @PLACE(401.3, -443);
//   %wire_6741 @TEXT("VDD", size=1, halign="middle", valign="baseline", rotate=90) => @PLACE(125.3, -338);
//   %wire_6716 @TEXT("VDD", size=1, halign="middle", valign="baseline", rotate=90) => @PLACE(281.3, -513);
//   %wire_6444 @TEXT("VDD", size=1, halign="middle", valign="baseline", rotate=90) => @PLACE(329.3, -303);
//   %wire_6561 @TEXT("VDD", size=1, halign="middle", valign="baseline", rotate=90) => @PLACE(353.3, -303);
//   %wire_6431 @TEXT("VDD", size=1, halign="middle", valign="baseline", rotate=90) => @PLACE(23.3, -756);
//   %wire_6853 @TEXT("VDD", size=1, halign="middle", valign="baseline", rotate=90) => @PLACE(149.3, -338);
//   %wire_6430 @TEXT("VDD", size=1, halign="middle", valign="baseline") => @PLACE(-7, -51.3);
//   %wire_6504 @TEXT("VDD", size=1, halign="middle", valign="top", rotate=90) => @PLACE(99.7, -172);
//   %wire_6736 @TEXT("VDD", size=1, halign="middle", valign="top", rotate=90) => @PLACE(207.7, -732);
//   %wire_6801 @TEXT("VDD", size=1, halign="middle", valign="baseline", rotate=90) => @PLACE(15.3, -583);
//   %wire_6432 @TEXT("VDD", size=1, halign="middle", valign="baseline", rotate=90) => @PLACE(87.3, -408);
//   %wire_6727 @TEXT("VDD", size=1, halign="middle", valign="baseline", rotate=90) => @PLACE(63.3, -408);
//   %wire_6580 @TEXT("VDD", size=1, halign="middle", valign="baseline", rotate=90) => @PLACE(377.3, -303);
//   %wire_6422 @TEXT("VDD", size=1, halign="middle", valign="baseline", rotate=90) => @PLACE(39.3, -128);
//   %wire_6836 @TEXT("VDD", size=1, halign="middle", valign="baseline", rotate=90) => @PLACE(377.3, -373);
//   %wire_6136 @TEXT("VDD", size=1, halign="middle", valign="baseline") => @PLACE(450, -755.3);
//   %wire_6704 @TEXT("VDD", size=1, halign="middle", valign="baseline") => @PLACE(-7, 18.7);
//   %wire_6612 @TEXT("VDD", size=1, halign="middle", valign="baseline", rotate=90) => @PLACE(329.3, -23);
//   %wire_6421 @TEXT("VDD", size=1, halign="middle", valign="baseline", rotate=90) => @PLACE(71.3, -756);
//   %wire_6714 @TEXT("VDD", size=1, halign="middle", valign="baseline", rotate=90) => @PLACE(353.3, -513);
//   %wire_6420 @TEXT("VDD", size=1, halign="middle", valign="baseline", rotate=90) => @PLACE(173.3, -373);
//   %wire_6716 @TEXT("VDD", size=1, halign="middle", valign="baseline", rotate=90) => @PLACE(281.3, -513);
//   %wire_6419 @TEXT("VDD", size=1, halign="middle", valign="baseline", rotate=90) => @PLACE(377.3, -198);
//   %wire_6609 @TEXT("VDD", size=1, halign="middle", valign="baseline", rotate=90) => @PLACE(281.3, -583);
//   %wire_6414 @TEXT("VDD", size=1, halign="middle", valign="baseline", rotate=90) => @PLACE(377.3, -128);
//   %wire_6412 @TEXT("VDD", size=1, halign="middle", valign="top", rotate=90) => @PLACE(99.7, -592);
//   %wire_6839 @TEXT("VDD", size=1, halign="middle", valign="baseline") => @PLACE(-10, -506.3);
//   %wire_6810 @TEXT("VDD", size=1, halign="middle", valign="top", rotate=90) => @PLACE(99.7, -347);
//   %wire_6816 @TEXT("VDD", size=1, halign="middle", valign="baseline", rotate=90) => @PLACE(281.3, -23);
//   %wire_6488 @TEXT("VDD", size=1, halign="middle", valign="top", rotate=90) => @PLACE(99.7, -627);
//   %wire_6447 @TEXT("VDD", size=1, halign="middle", valign="baseline", rotate=90) => @PLACE(100.3, -778);
//   %wire_6403 @TEXT("VDD", size=1, halign="middle", valign="baseline", rotate=90) => @PLACE(-32.7, -26);
//   %wire_6815 @TEXT("VDD", size=1, halign="middle", valign="baseline", rotate=90) => @PLACE(39.3, -23);
//   %wire_6355 @TEXT("VDD", size=1, halign="middle", valign="baseline", rotate=90) => @PLACE(173.3, -303);
//   %wire_6402 @TEXT("VDD", size=1, halign="middle", valign="baseline", rotate=90) => @PLACE(329.3, -548);
//   %wire_6401 @TEXT("VDD", size=1, halign="middle", valign="baseline", rotate=90) => @PLACE(173.3, -233);
//   %wire_6394 @TEXT("VDD", size=1, halign="middle", valign="baseline", rotate=90) => @PLACE(329.3, -233);
//   %wire_6400 @TEXT("VDD", size=1, halign="middle", valign="baseline", rotate=90) => @PLACE(353.3, -548);
//   %wire_6399 @TEXT("VDD", size=1, halign="middle", valign="baseline", rotate=90) => @PLACE(197.3, -303);
//   %wire_6398 @TEXT("VDD", size=1, halign="middle", valign="top", rotate=90) => @PLACE(207.7, -662);
//   %wire_6396 @TEXT("VDD", size=1, halign="middle", valign="baseline", rotate=90) => @PLACE(377.3, -548);
//   %wire_6395 @TEXT("VDD", size=1, halign="middle", valign="baseline", rotate=90) => @PLACE(233.3, -303);
//   %wire_6394 @TEXT("VDD", size=1, halign="middle", valign="baseline", rotate=90) => @PLACE(329.3, -233);
//   %wire_6393 @TEXT("VDD", size=1, halign="middle", valign="baseline", rotate=90) => @PLACE(401.3, -548);
//   %wire_6392 @TEXT("VDD", size=1, halign="middle", valign="baseline", rotate=90) => @PLACE(413.3, -563);
//   %wire_6391 @TEXT("VDD", size=1, halign="middle", valign="baseline") => @PLACE(-14, -51.3);
//   %wire_6388 @TEXT("VDD", size=1, halign="middle", valign="baseline", rotate=90) => @PLACE(-32.7, -481);
//   %wire_6341 @TEXT("VDD", size=1, halign="middle", valign="baseline", rotate=90) => @PLACE(-32.7, -516);
//   %wire_6387 @TEXT("VDD", size=1, halign="middle", valign="baseline", rotate=90) => @PLACE(-32.7, -411);
//   %wire_6386 @TEXT("VDD", size=1, halign="middle", valign="baseline", rotate=90) => @PLACE(-55.7, -131);
//   %wire_6385 @TEXT("VDD", size=1, halign="middle", valign="baseline", rotate=90) => @PLACE(-44.7, -166);
//   %wire_6384 @TEXT("VDD", size=1, halign="middle", valign="baseline", rotate=90) => @PLACE(-44.7, -131);
//   %wire_6383 @TEXT("VDD", size=1, halign="middle", valign="baseline", rotate=90) => @PLACE(149.3, -163);
//   %wire_6382 @TEXT("VDD", size=1, halign="middle", valign="baseline", rotate=90) => @PLACE(15.3, -618);
//   %wire_6374 @TEXT("VDD", size=1, halign="middle", valign="baseline", rotate=90) => @PLACE(125.3, -163);
//   %wire_6381 @TEXT("VDD", size=1, halign="middle", valign="baseline", rotate=90) => @PLACE(173.3, -163);
//   %wire_6380 @TEXT("VDD", size=1, halign="middle", valign="baseline", rotate=90) => @PLACE(39.3, -618);
//   %wire_6379 @TEXT("VDD", size=1, halign="middle", valign="baseline", rotate=90) => @PLACE(197.3, -163);
//   %wire_6378 @TEXT("VDD", size=1, halign="middle", valign="baseline", rotate=90) => @PLACE(63.3, -618);
//   %wire_6377 @TEXT("VDD", size=1, halign="middle", valign="baseline", rotate=90) => @PLACE(233.3, -163);
//   %wire_6368 @TEXT("VDD", size=1, halign="middle", valign="baseline", rotate=90) => @PLACE(329.3, -163);
//   %wire_6376 @TEXT("VDD", size=1, halign="middle", valign="baseline", rotate=90) => @PLACE(87.3, -618);
//   %wire_6372 @TEXT("VDD", size=1, halign="middle", valign="baseline", rotate=90) => @PLACE(257.3, -163);
//   %wire_6372 @TEXT("VDD", size=1, halign="middle", valign="baseline", rotate=90) => @PLACE(257.3, -163);
//   %wire_6375 @TEXT("VDD", size=1, halign="middle", valign="baseline", rotate=90) => @PLACE(125.3, -618);
//   %wire_6373 @TEXT("VDD", size=1, halign="middle", valign="baseline", rotate=90) => @PLACE(281.3, -163);
//   %wire_6373 @TEXT("VDD", size=1, halign="middle", valign="baseline", rotate=90) => @PLACE(281.3, -163);
//   %wire_6371 @TEXT("VDD", size=1, halign="middle", valign="baseline", rotate=90) => @PLACE(149.3, -618);
//   %wire_6731 @TEXT("VDD", size=1, halign="middle", valign="baseline", rotate=90) => @PLACE(39.3, -303);
//   %wire_6370 @TEXT("VDD", size=1, halign="middle", valign="baseline", rotate=90) => @PLACE(305.3, -163);
//   %wire_6370 @TEXT("VDD", size=1, halign="middle", valign="baseline", rotate=90) => @PLACE(305.3, -163);
//   %wire_6369 @TEXT("VDD", size=1, halign="middle", valign="baseline", rotate=90) => @PLACE(173.3, -618);
//   %wire_6746 @TEXT("VDD", size=1, halign="middle", valign="baseline", rotate=90) => @PLACE(149.3, -303);
//   %wire_6368 @TEXT("VDD", size=1, halign="middle", valign="baseline", rotate=90) => @PLACE(329.3, -163);
//   %wire_6367 @TEXT("VDD", size=1, halign="middle", valign="baseline", rotate=90) => @PLACE(197.3, -618);
//   %wire_6366 @TEXT("VDD", size=1, halign="middle", valign="baseline", rotate=90) => @PLACE(353.3, -163);
//   %wire_6366 @TEXT("VDD", size=1, halign="middle", valign="baseline", rotate=90) => @PLACE(353.3, -163);
//   %wire_6747 @TEXT("VDD", size=1, halign="middle", valign="baseline", rotate=90) => @PLACE(257.3, -233);
//   %wire_6365 @TEXT("VDD", size=1, halign="middle", valign="baseline", rotate=90) => @PLACE(233.3, -618);
//   %wire_6364 @TEXT("VDD", size=1, halign="middle", valign="baseline", rotate=90) => @PLACE(377.3, -163);
//   %wire_6364 @TEXT("VDD", size=1, halign="middle", valign="baseline", rotate=90) => @PLACE(377.3, -163);
//   %wire_6363 @TEXT("VDD", size=1, halign="middle", valign="baseline", rotate=90) => @PLACE(401.3, -163);
//   %wire_6363 @TEXT("VDD", size=1, halign="middle", valign="baseline", rotate=90) => @PLACE(401.3, -163);
//   %wire_6361 @TEXT("VDD", size=1, halign="middle", valign="baseline", rotate=90) => @PLACE(413.3, -178);
//   %wire_6362 @TEXT("VDD", size=1, halign="middle", valign="baseline", rotate=90) => @PLACE(257.3, -618);
//   %wire_6360 @TEXT("VDD", size=1, halign="middle", valign="baseline", rotate=90) => @PLACE(281.3, -618);
//   %wire_6359 @TEXT("VDD", size=1, halign="middle", valign="baseline", rotate=90) => @PLACE(15.3, -233);
//   %wire_6357 @TEXT("VDD", size=1, halign="middle", valign="baseline", rotate=90) => @PLACE(305.3, -618);
//   %wire_6356 @TEXT("VDD", size=1, halign="middle", valign="baseline", rotate=90) => @PLACE(39.3, -233);
//   %wire_6354 @TEXT("VDD", size=1, halign="middle", valign="baseline", rotate=90) => @PLACE(87.3, -163);
//   %wire_6358 @TEXT("VDD", size=1, halign="middle", valign="baseline", rotate=90) => @PLACE(63.3, -233);
//   %wire_6353 @TEXT("VDD", size=1, halign="middle", valign="baseline", rotate=90) => @PLACE(329.3, -618);
//   %wire_6352 @TEXT("VDD", size=1, halign="middle", valign="baseline", rotate=90) => @PLACE(87.3, -233);
//   %wire_6351 @TEXT("VDD", size=1, halign="middle", valign="baseline", rotate=90) => @PLACE(353.3, -618);
//   %wire_6350 @TEXT("VDD", size=1, halign="middle", valign="baseline", rotate=90) => @PLACE(125.3, -233);
//   %wire_6349 @TEXT("VDD", size=1, halign="middle", valign="baseline", rotate=90) => @PLACE(377.3, -618);
//   %wire_6348 @TEXT("VDD", size=1, halign="middle", valign="baseline", rotate=90) => @PLACE(436.3, -712);
//   %wire_6347 @TEXT("VDD", size=1, halign="middle", valign="baseline", rotate=90) => @PLACE(401.3, -618);
//   %wire_6346 @TEXT("VDD", size=1, halign="middle", valign="baseline", rotate=90) => @PLACE(149.3, -233);
//   %wire_6345 @TEXT("VDD", size=1, halign="middle", valign="baseline", rotate=90) => @PLACE(413.3, -633);
//   %wire_6344 @TEXT("VDD", size=1, halign="middle", valign="baseline", rotate=90) => @PLACE(-55.7, -96);
//   %wire_6343 @TEXT("VDD", size=1, halign="middle", valign="baseline", rotate=90) => @PLACE(-55.7, -61);
//   %wire_6342 @TEXT("VDD", size=1, halign="middle", valign="baseline", rotate=90) => @PLACE(-44.7, -26);
//   %wire_6339 @TEXT("VDD", size=1, halign="middle", valign="baseline", rotate=90) => @PLACE(-32.7, -96);
//   %wire_6338 @TEXT("VDD", size=1, halign="middle", valign="baseline", rotate=90) => @PLACE(-32.7, -61);
//   %wire_6336 @TEXT("VDD", size=1, halign="middle", valign="baseline", rotate=90) => @PLACE(63.3, -93);
//   %wire_6335 @TEXT("VDD", size=1, halign="middle", valign="baseline", rotate=90) => @PLACE(15.3, -688);
//   %wire_6327 @TEXT("VDD", size=1, halign="middle", valign="baseline", rotate=90) => @PLACE(39.3, -93);
//   %wire_6337 @TEXT("VDD", size=1, halign="middle", valign="baseline", rotate=90) => @PLACE(87.3, -93);
//   %wire_6750 @TEXT("VDD", size=1, halign="middle", valign="top", rotate=90) => @PLACE(99.7, -137);
//   %wire_6334 @TEXT("VDD", size=1, halign="middle", valign="baseline", rotate=90) => @PLACE(39.3, -688);
//   %wire_6333 @TEXT("VDD", size=1, halign="middle", valign="baseline", rotate=90) => @PLACE(125.3, -93);
//   %wire_6332 @TEXT("VDD", size=1, halign="middle", valign="baseline", rotate=90) => @PLACE(63.3, -688);
//   %wire_6331 @TEXT("VDD", size=1, halign="middle", valign="baseline", rotate=90) => @PLACE(149.3, -93);
//   %wire_6330 @TEXT("VDD", size=1, halign="middle", valign="baseline", rotate=90) => @PLACE(87.3, -688);
//   %wire_6758 @TEXT("VDD", size=1, halign="middle", valign="top", rotate=90) => @PLACE(99.7, 3);
//   %wire_6329 @TEXT("VDD", size=1, halign="middle", valign="baseline", rotate=90) => @PLACE(173.3, -93);
//   %wire_6328 @TEXT("VDD", size=1, halign="middle", valign="baseline", rotate=90) => @PLACE(125.3, -688);
//   %wire_6326 @TEXT("VDD", size=1, halign="middle", valign="baseline", rotate=90) => @PLACE(197.3, -93);
//   %wire_6324 @TEXT("VDD", size=1, halign="middle", valign="baseline", rotate=90) => @PLACE(149.3, -688);
//   %wire_6325 @TEXT("VDD", size=1, halign="middle", valign="baseline", rotate=90) => @PLACE(233.3, -93);
//   %wire_6322 @TEXT("VDD", size=1, halign="middle", valign="baseline", rotate=90) => @PLACE(173.3, -688);
//   %wire_6321 @TEXT("VDD", size=1, halign="middle", valign="baseline", rotate=90) => @PLACE(257.3, -93);
//   %wire_6321 @TEXT("VDD", size=1, halign="middle", valign="baseline", rotate=90) => @PLACE(257.3, -93);
//   %wire_6315 @TEXT("VDD", size=1, halign="middle", valign="baseline", rotate=90) => @PLACE(329.3, -93);
//   %wire_6320 @TEXT("VDD", size=1, halign="middle", valign="baseline", rotate=90) => @PLACE(197.3, -688);
//   %wire_6319 @TEXT("VDD", size=1, halign="middle", valign="baseline", rotate=90) => @PLACE(281.3, -93);
//   %wire_6319 @TEXT("VDD", size=1, halign="middle", valign="baseline", rotate=90) => @PLACE(281.3, -93);
//   %wire_6317 @TEXT("VDD", size=1, halign="middle", valign="baseline", rotate=90) => @PLACE(233.3, -688);
//   %wire_6318 @TEXT("VDD", size=1, halign="middle", valign="baseline", rotate=90) => @PLACE(305.3, -93);
//   %wire_6318 @TEXT("VDD", size=1, halign="middle", valign="baseline", rotate=90) => @PLACE(305.3, -93);
//   %wire_6302 @TEXT("VDD", size=1, halign="middle", valign="baseline", rotate=90) => @PLACE(39.3, -163);
//   %wire_6315 @TEXT("VDD", size=1, halign="middle", valign="baseline", rotate=90) => @PLACE(329.3, -93);
//   %wire_6314 @TEXT("VDD", size=1, halign="middle", valign="baseline", rotate=90) => @PLACE(257.3, -688);
//   %wire_6308 @TEXT("VDD", size=1, halign="middle", valign="baseline", rotate=90) => @PLACE(401.3, -93);
//   %wire_6312 @TEXT("VDD", size=1, halign="middle", valign="baseline", rotate=90) => @PLACE(281.3, -688);
//   %wire_6313 @TEXT("VDD", size=1, halign="middle", valign="baseline", rotate=90) => @PLACE(353.3, -93);
//   %wire_6313 @TEXT("VDD", size=1, halign="middle", valign="baseline", rotate=90) => @PLACE(353.3, -93);
//   %wire_6309 @TEXT("VDD", size=1, halign="middle", valign="baseline", rotate=90) => @PLACE(305.3, -688);
//   %wire_6310 @TEXT("VDD", size=1, halign="middle", valign="baseline", rotate=90) => @PLACE(377.3, -93);
//   %wire_6310 @TEXT("VDD", size=1, halign="middle", valign="baseline", rotate=90) => @PLACE(377.3, -93);
//   %wire_6311 @TEXT("VDD", size=1, halign="middle", valign="baseline", rotate=90) => @PLACE(15.3, -93);
//   %wire_6308 @TEXT("VDD", size=1, halign="middle", valign="baseline", rotate=90) => @PLACE(401.3, -93);
//   %wire_6323 @TEXT("VDD", size=1, halign="middle", valign="baseline", rotate=90) => @PLACE(413.3, -108);
//   %wire_6306 @TEXT("VDD", size=1, halign="middle", valign="baseline", rotate=90) => @PLACE(329.3, -688);
//   %wire_6304 @TEXT("VDD", size=1, halign="middle", valign="baseline", rotate=90) => @PLACE(15.3, -163);
//   %wire_6303 @TEXT("VDD", size=1, halign="middle", valign="baseline", rotate=90) => @PLACE(353.3, -688);
//   %wire_6301 @TEXT("VDD", size=1, halign="middle", valign="baseline", rotate=90) => @PLACE(377.3, -688);
//   %wire_6300 @TEXT("VDD", size=1, halign="middle", valign="baseline", rotate=90) => @PLACE(401.3, -688);
//   %wire_6316 @TEXT("VDD", size=1, halign="middle", valign="baseline", rotate=90) => @PLACE(63.3, -163);
//   %wire_6299 @TEXT("VDD", size=1, halign="middle", valign="baseline", rotate=90) => @PLACE(413.3, -703);
//   %wire_6298 @TEXT("VDD", size=1, halign="middle", valign="baseline", rotate=90) => @PLACE(181.3, -756);
//   %wire_6297 @TEXT("VDD", size=1, halign="middle", valign="baseline", rotate=90) => @PLACE(324.3, -756);
//   %wire_6295 @TEXT("VDD", size=1, halign="middle", valign="baseline", rotate=90) => @PLACE(157.3, -756);
//   %wire_6294 @TEXT("VDD", size=1, halign="middle", valign="baseline", rotate=90) => @PLACE(372.3, -756);
//   %wire_6293 @TEXT("VDD", size=1, halign="middle", valign="baseline", rotate=90) => @PLACE(348.3, -756);
//   %wire_6291 @TEXT("VDD", size=1, halign="middle", valign="baseline", rotate=90) => @PLACE(396.3, -756);
//   %wire_6289 @TEXT("VDD", size=1, halign="middle", valign="baseline", rotate=90) => @PLACE(192.3, -756);
//   %wire_6287 @TEXT("VDD", size=1, halign="middle", valign="baseline", rotate=90) => @PLACE(252.3, -756);
//   %wire_6288 @TEXT("VDD", size=1, halign="middle", valign="baseline", rotate=90) => @PLACE(276.3, -756);
//   %wire_6290 @TEXT("VDD", size=1, halign="middle", valign="baseline", rotate=90) => @PLACE(228.3, -756);
//   %wire_6286 @TEXT("VDD", size=1, halign="middle", valign="baseline", rotate=90) => @PLACE(265.3, -756);
//   %wire_6285 @TEXT("VDD", size=1, halign="middle", valign="baseline", rotate=90) => @PLACE(289.3, -756);
//   %wire_6284 @TEXT("VDD", size=1, halign="middle", valign="baseline", rotate=90) => @PLACE(217.3, -756);
//   %wire_6283 @TEXT("VDD", size=1, halign="middle", valign="baseline", rotate=90) => @PLACE(300.3, -756);
//   %wire_6282 @TEXT("VDD", size=1, halign="middle", valign="baseline", rotate=90) => @PLACE(241.3, -756);
//   %wire_6281 @TEXT("VDD", size=1, halign="middle", valign="baseline", rotate=90) => @PLACE(337.3, -756);
//   %wire_6280 @TEXT("VDD", size=1, halign="middle", valign="baseline", rotate=90) => @PLACE(144.3, -756);
//   %wire_6273 @TEXT("VDD", size=1, halign="middle", valign="baseline", rotate=90) => @PLACE(120.3, -756);
//   %wire_6279 @TEXT("VDD", size=1, halign="middle", valign="baseline", rotate=90) => @PLACE(313.3, -756);
//   %wire_6278 @TEXT("VDD", size=1, halign="middle", valign="baseline", rotate=90) => @PLACE(385.3, -756);
//   %wire_6277 @TEXT("VDD", size=1, halign="middle", valign="baseline", rotate=90) => @PLACE(34.3, -756);
//   %wire_6276 @TEXT("VDD", size=1, halign="middle", valign="baseline", rotate=90) => @PLACE(361.3, -756);
//   %wire_6275 @TEXT("VDD", size=1, halign="middle", valign="baseline", rotate=90) => @PLACE(82.3, -756);
//   %wire_6274 @TEXT("VDD", size=1, halign="middle", valign="baseline", rotate=90) => @PLACE(58.3, -756);
//   %wire_6296 @TEXT("VDD", size=1, halign="middle", valign="baseline", rotate=90) => @PLACE(208.3, -789);
//   %wire_6730 @TEXT("VDD", size=1, halign="middle", valign="baseline", rotate=90) => @PLACE(197.3, -233);
//   %wire_6272 @TEXT("VDD", size=1, halign="middle", valign="baseline", rotate=90) => @PLACE(415.3, -755);
//   %wire_6271 @TEXT("VDD", size=1, halign="middle", valign="baseline", rotate=90) => @PLACE(436.3, -738);
//   %wire_6270 @TEXT("VDD", size=1, halign="middle", valign="top", rotate=90) => @PLACE(207.7, -557);
//   %wire_6269 @TEXT("VDD", size=1, halign="middle", valign="top", rotate=90) => @PLACE(207.7, -522);
//   %wire_6268 @TEXT("VDD", size=1, halign="middle", valign="top", rotate=90) => @PLACE(207.7, -487);
//   %wire_6267 @TEXT("VDD", size=1, halign="middle", valign="top", rotate=90) => @PLACE(207.7, -452);
//   %wire_6266 @TEXT("VDD", size=1, halign="middle", valign="top", rotate=90) => @PLACE(207.7, -417);
//   %wire_6265 @TEXT("VDD", size=1, halign="middle", valign="top", rotate=90) => @PLACE(207.7, -382);
//   %wire_6264 @TEXT("VDD", size=1, halign="middle", valign="top", rotate=90) => @PLACE(207.7, -347);
//   %wire_6263 @TEXT("VDD", size=1, halign="middle", valign="top", rotate=90) => @PLACE(207.7, -312);
//   %wire_6262 @TEXT("VDD", size=1, halign="middle", valign="top", rotate=90) => @PLACE(207.7, -277);
//   %wire_6261 @TEXT("VDD", size=1, halign="middle", valign="top", rotate=90) => @PLACE(207.7, -242);
//   %wire_6458 @TEXT("VDD", size=1, halign="middle", valign="baseline") => @PLACE(-17, -16.3);
//   %wire_6257 @TEXT("VDD", size=1, halign="middle", valign="top", rotate=90) => @PLACE(207.7, -207);
//   %wire_6256 @TEXT("VDD", size=1, halign="middle", valign="top", rotate=90) => @PLACE(207.7, -172);
//   %wire_6409 @TEXT("VDD", size=1, halign="middle", valign="baseline", rotate=90) => @PLACE(-44.7, -586);
//   %wire_6254 @TEXT("VDD", size=1, halign="middle", valign="top", rotate=90) => @PLACE(207.7, -137);
//   %wire_6253 @TEXT("VDD", size=1, halign="middle", valign="top", rotate=90) => @PLACE(207.7, -102);
//   %wire_6252 @TEXT("VDD", size=1, halign="middle", valign="top", rotate=90) => @PLACE(207.7, -67);
//   %wire_6248 @TEXT("VDD", size=1, halign="middle", valign="baseline", rotate=90) => @PLACE(-44.7, -551);
//   %wire_6251 @TEXT("VDD", size=1, halign="middle", valign="top", rotate=90) => @PLACE(207.7, -32);
//   %wire_6250 @TEXT("VDD", size=1, halign="middle", valign="top", rotate=90) => @PLACE(207.7, 3);
//   %wire_6559 @TEXT("VDD", size=1, halign="middle", valign="baseline", rotate=90) => @PLACE(-55.7, -376);
//   %wire_6247 @TEXT("VDD", size=1, halign="middle", valign="baseline") => @PLACE(-10, -16.3);
//   %wire_6556 @TEXT("VDD", size=1, halign="middle", valign="baseline", rotate=90) => @PLACE(-44.7, -201);
//   %wire_6536 @TEXT("VDD", size=1, halign="middle", valign="baseline", rotate=90) => @PLACE(-32.7, -131);
//   %wire_6534 @TEXT("VDD", size=1, halign="middle", valign="baseline", rotate=90) => @PLACE(-32.7, -166);
//   %wire_6258 @TEXT("VDD", size=1, halign="middle", valign="baseline", rotate=90) => @PLACE(-32.7, -586);
//   %wire_6245 @TEXT("VDD", size=1, halign="middle", valign="baseline", rotate=90) => @PLACE(-32.7, -551);
//   %wire_6244 @TEXT("VDD", size=1, halign="middle", valign="baseline") => @PLACE(-17, -576.3);
//   %wire_6243 @TEXT("VDD", size=1, halign="middle", valign="baseline") => @PLACE(-10, -576.3);
//   %wire_6238 @TEXT("VDD", size=1, halign="middle", valign="baseline") => @PLACE(-7, -541.3);
//   %wire_6237 @TEXT("VDD", size=1, halign="middle", valign="baseline") => @PLACE(-14, -541.3);
//   %wire_6232 @TEXT("VDD", size=1, halign="middle", valign="baseline", rotate=90) => @PLACE(-55.7, -656);
//   %wire_6231 @TEXT("VDD", size=1, halign="middle", valign="baseline", rotate=90) => @PLACE(-55.7, -621);
//   %wire_6230 @TEXT("VDD", size=1, halign="middle", valign="baseline", rotate=90) => @PLACE(-44.7, -656);
//   %wire_6229 @TEXT("VDD", size=1, halign="middle", valign="baseline", rotate=90) => @PLACE(-44.7, -621);
//   %wire_6228 @TEXT("VDD", size=1, halign="middle", valign="baseline", rotate=90) => @PLACE(-32.7, -656);
//   %wire_6227 @TEXT("VDD", size=1, halign="middle", valign="baseline", rotate=90) => @PLACE(-32.7, -621);
//   %wire_6226 @TEXT("VDD", size=1, halign="middle", valign="baseline") => @PLACE(-17, -646.3);
//   %wire_6225 @TEXT("VDD", size=1, halign="middle", valign="baseline") => @PLACE(-10, -646.3);
//   %wire_6220 @TEXT("VDD", size=1, halign="middle", valign="baseline") => @PLACE(-7, -611.3);
//   %wire_6219 @TEXT("VDD", size=1, halign="middle", valign="baseline") => @PLACE(-14, -611.3);
//   %wire_6214 @TEXT("VDD", size=1, halign="middle", valign="baseline", rotate=90) => @PLACE(-55.7, -726);
//   %wire_6213 @TEXT("VDD", size=1, halign="middle", valign="baseline", rotate=90) => @PLACE(-55.7, -691);
//   %wire_6212 @TEXT("VDD", size=1, halign="middle", valign="baseline", rotate=90) => @PLACE(-44.7, -726);
//   %wire_6211 @TEXT("VDD", size=1, halign="middle", valign="baseline", rotate=90) => @PLACE(-44.7, -691);
//   %wire_6210 @TEXT("VDD", size=1, halign="middle", valign="baseline", rotate=90) => @PLACE(-32.7, -726);
//   %wire_6209 @TEXT("VDD", size=1, halign="middle", valign="baseline", rotate=90) => @PLACE(-32.7, -691);
//   %wire_6208 @TEXT("VDD", size=1, halign="middle", valign="baseline") => @PLACE(-17, -716.3);
//   %wire_6207 @TEXT("VDD", size=1, halign="middle", valign="baseline") => @PLACE(-10, -716.3);
//   %wire_6202 @TEXT("VDD", size=1, halign="middle", valign="baseline") => @PLACE(-7, -681.3);
//   %wire_6201 @TEXT("VDD", size=1, halign="middle", valign="baseline") => @PLACE(-14, -681.3);
//   %wire_6196 @TEXT("VDD", size=1, halign="middle", valign="baseline", rotate=90) => @PLACE(-32.7, 44);
//   %wire_6195 @TEXT("VDD", size=1, halign="middle", valign="baseline", rotate=90) => @PLACE(-32.7, 79);
//   %wire_6190 @TEXT("VDD", size=1, halign="middle", valign="baseline") => @PLACE(-17, 53.7);
//   %wire_6189 @TEXT("VDD", size=1, halign="middle", valign="baseline") => @PLACE(-14, 88.7);
//   %wire_6188 @TEXT("VDD", size=1, halign="middle", valign="baseline") => @PLACE(-10, 53.7);
//   %wire_6187 @TEXT("VDD", size=1, halign="middle", valign="baseline") => @PLACE(-7, 88.7);
//   %wire_6182 @TEXT("VDD", size=1, halign="middle", valign="baseline", rotate=90) => @PLACE(15.3, 82);
//   %wire_6181 @TEXT("VDD", size=1, halign="middle", valign="baseline", rotate=90) => @PLACE(15.3, 47);
//   %wire_6180 @TEXT("VDD", size=1, halign="middle", valign="baseline", rotate=90) => @PLACE(39.3, 82);
//   %wire_6179 @TEXT("VDD", size=1, halign="middle", valign="baseline", rotate=90) => @PLACE(39.3, 47);
//   %wire_6178 @TEXT("VDD", size=1, halign="middle", valign="baseline", rotate=90) => @PLACE(63.3, 82);
//   %wire_6177 @TEXT("VDD", size=1, halign="middle", valign="baseline", rotate=90) => @PLACE(63.3, 47);
//   %wire_6176 @TEXT("VDD", size=1, halign="middle", valign="baseline", rotate=90) => @PLACE(87.3, 82);
//   %wire_6175 @TEXT("VDD", size=1, halign="middle", valign="baseline", rotate=90) => @PLACE(87.3, 47);
//   %wire_6174 @TEXT("VDD", size=1, halign="middle", valign="top", rotate=90) => @PLACE(99.7, 73);
//   %wire_6173 @TEXT("VDD", size=1, halign="middle", valign="top", rotate=90) => @PLACE(99.7, 38);
//   %wire_6172 @TEXT("VDD", size=1, halign="middle", valign="baseline", rotate=90) => @PLACE(125.3, 82);
//   %wire_6171 @TEXT("VDD", size=1, halign="middle", valign="baseline", rotate=90) => @PLACE(125.3, 47);
//   %wire_6170 @TEXT("VDD", size=1, halign="middle", valign="baseline", rotate=90) => @PLACE(149.3, 82);
//   %wire_6169 @TEXT("VDD", size=1, halign="middle", valign="baseline", rotate=90) => @PLACE(149.3, 47);
//   %wire_6168 @TEXT("VDD", size=1, halign="middle", valign="baseline", rotate=90) => @PLACE(173.3, 82);
//   %wire_6167 @TEXT("VDD", size=1, halign="middle", valign="baseline", rotate=90) => @PLACE(173.3, 47);
//   %wire_6166 @TEXT("VDD", size=1, halign="middle", valign="baseline", rotate=90) => @PLACE(197.3, 82);
//   %wire_6165 @TEXT("VDD", size=1, halign="middle", valign="baseline", rotate=90) => @PLACE(197.3, 47);
//   %wire_6164 @TEXT("VDD", size=1, halign="middle", valign="top", rotate=90) => @PLACE(207.7, 73);
//   %wire_6163 @TEXT("VDD", size=1, halign="middle", valign="top", rotate=90) => @PLACE(207.7, 38);
//   %wire_6162 @TEXT("VDD", size=1, halign="middle", valign="baseline", rotate=90) => @PLACE(233.3, 47);
//   %wire_6161 @TEXT("VDD", size=1, halign="middle", valign="baseline", rotate=90) => @PLACE(233.3, 82);
//   %wire_6160 @TEXT("VDD", size=1, halign="middle", valign="baseline", rotate=90) => @PLACE(257.3, 82);
//   %wire_6159 @TEXT("VDD", size=1, halign="middle", valign="baseline", rotate=90) => @PLACE(257.3, 47);
//   %wire_6159 @TEXT("VDD", size=1, halign="middle", valign="baseline", rotate=90) => @PLACE(257.3, 47);
//   %wire_6158 @TEXT("VDD", size=1, halign="middle", valign="baseline", rotate=90) => @PLACE(281.3, 82);
//   %wire_6157 @TEXT("VDD", size=1, halign="middle", valign="baseline", rotate=90) => @PLACE(281.3, 47);
//   %wire_6157 @TEXT("VDD", size=1, halign="middle", valign="baseline", rotate=90) => @PLACE(281.3, 47);
//   %wire_6156 @TEXT("VDD", size=1, halign="middle", valign="baseline", rotate=90) => @PLACE(305.3, 47);
//   %wire_6156 @TEXT("VDD", size=1, halign="middle", valign="baseline", rotate=90) => @PLACE(305.3, 47);
//   %wire_6155 @TEXT("VDD", size=1, halign="middle", valign="baseline", rotate=90) => @PLACE(305.3, 82);
//   %wire_6154 @TEXT("VDD", size=1, halign="middle", valign="baseline", rotate=90) => @PLACE(329.3, 47);
//   %wire_6154 @TEXT("VDD", size=1, halign="middle", valign="baseline", rotate=90) => @PLACE(329.3, 47);
//   %wire_6153 @TEXT("VDD", size=1, halign="middle", valign="baseline", rotate=90) => @PLACE(329.3, 82);
//   %wire_6152 @TEXT("VDD", size=1, halign="middle", valign="baseline", rotate=90) => @PLACE(353.3, 47);
//   %wire_6152 @TEXT("VDD", size=1, halign="middle", valign="baseline", rotate=90) => @PLACE(353.3, 47);
//   %wire_6151 @TEXT("VDD", size=1, halign="middle", valign="baseline", rotate=90) => @PLACE(353.3, 82);
//   %wire_6150 @TEXT("VDD", size=1, halign="middle", valign="baseline", rotate=90) => @PLACE(377.3, 47);
//   %wire_6150 @TEXT("VDD", size=1, halign="middle", valign="baseline", rotate=90) => @PLACE(377.3, 47);
//   %wire_6149 @TEXT("VDD", size=1, halign="middle", valign="baseline", rotate=90) => @PLACE(377.3, 82);
//   %wire_6148 @TEXT("VDD", size=1, halign="middle", valign="baseline", rotate=90) => @PLACE(401.3, 47);
//   %wire_6148 @TEXT("VDD", size=1, halign="middle", valign="baseline", rotate=90) => @PLACE(401.3, 47);
//   %wire_6147 @TEXT("VDD", size=1, halign="middle", valign="baseline", rotate=90) => @PLACE(401.3, 82);
//   %wire_6146 @TEXT("VDD", size=1, halign="middle", valign="baseline", rotate=90) => @PLACE(413.3, 32);
//   %wire_6145 @TEXT("VDD", size=1, halign="middle", valign="baseline", rotate=90) => @PLACE(413.3, 67);
//   %wire_6144 @TEXT("VDD", size=1, halign="middle", valign="top", rotate=90) => @PLACE(433.7, 91);
//   %wire_6142 @TEXT("VDD", size=1, halign="middle", valign="baseline") => @PLACE(-99, 37.7);
//   %wire_6139 @TEXT("VDD", size=1, halign="middle", valign="baseline") => @PLACE(-99, 29.7);
//   %wire_6138 @TEXT("VDD", size=1, halign="middle", valign="baseline") => @PLACE(453, -739.3);
//   %wire_6137 @TEXT("VDD", size=1, halign="middle", valign="baseline") => @PLACE(468, -739.3);
//   $JUNCTION @ATTACH %p1 => @PLACE(34, 86);
//   $JUNCTION @ATTACH %p4 => @PLACE(14, 53);
//   $JUNCTION @ATTACH %p6 => @PLACE(104, -780);
//   $JUNCTION @ATTACH %p9 => @PLACE(82, 86);
//   $JUNCTION @ATTACH %p12 => @PLACE(62, 53);
//   $JUNCTION @ATTACH %p15 => @PLACE(38, 53);
//   $JUNCTION @ATTACH %p18 => @PLACE(58, 86);
//   $JUNCTION @ATTACH %p21 => @PLACE(97, 74);
//   $JUNCTION @ATTACH %p22 => @PLACE(-6, 74);
//   $JUNCTION @ATTACH %p25 => @PLACE(97, 39);
//   $JUNCTION @ATTACH %p26 => @PLACE(-18, 39);
//   $JUNCTION @ATTACH %p29 => @PLACE(144, 86);
//   $JUNCTION @ATTACH %p32 => @PLACE(124, 53);
//   $JUNCTION @ATTACH %p35 => @PLACE(86, 53);
//   $JUNCTION @ATTACH %p38 => @PLACE(120, 86);
//   $JUNCTION @ATTACH %p40 => @PLACE(212, -780);
//   $JUNCTION @ATTACH %p43 => @PLACE(205, 39);
//   $JUNCTION @ATTACH %p44 => @PLACE(107, 39);
//   $JUNCTION @ATTACH %p47 => @PLACE(205, 74);
//   $JUNCTION @ATTACH %p48 => @PLACE(107, 74);
//   $JUNCTION @ATTACH %p51 => @PLACE(192, 86);
//   $JUNCTION @ATTACH %p54 => @PLACE(172, 53);
//   $JUNCTION @ATTACH %p57 => @PLACE(148, 53);
//   $JUNCTION @ATTACH %p60 => @PLACE(168, 86);
//   $JUNCTION @ATTACH %p63 => @PLACE(276, 86);
//   $JUNCTION @ATTACH %p66 => @PLACE(252, 86);
//   $JUNCTION @ATTACH %p69 => @PLACE(232, 53);
//   $JUNCTION @ATTACH %p72 => @PLACE(256, 53);
//   $JUNCTION @ATTACH %p75 => @PLACE(228, 86);
//   $JUNCTION @ATTACH %p78 => @PLACE(196, 53);
//   $JUNCTION @ATTACH %p81 => @PLACE(348, 86);
//   $JUNCTION @ATTACH %p84 => @PLACE(324, 86);
//   $JUNCTION @ATTACH %p87 => @PLACE(304, 53);
//   $JUNCTION @ATTACH %p90 => @PLACE(328, 53);
//   $JUNCTION @ATTACH %p93 => @PLACE(300, 86);
//   $JUNCTION @ATTACH %p96 => @PLACE(280, 53);
//   $JUNCTION @ATTACH %p99 => @PLACE(396, 86);
//   $JUNCTION @ATTACH %p102 => @PLACE(376, 53);
//   $JUNCTION @ATTACH %p107 => @PLACE(352, 53);
//   $JUNCTION @ATTACH %p110 => @PLACE(370, 90);
//   $JUNCTION @ATTACH %p111 => @PLACE(346, 90);
//   $JUNCTION @ATTACH %p112 => @PLACE(322, 90);
//   $JUNCTION @ATTACH %p113 => @PLACE(298, 90);
//   $JUNCTION @ATTACH %p114 => @PLACE(274, 90);
//   $JUNCTION @ATTACH %p115 => @PLACE(250, 90);
//   $JUNCTION @ATTACH %p116 => @PLACE(226, 90);
//   $JUNCTION @ATTACH %p117 => @PLACE(190, 90);
//   $JUNCTION @ATTACH %p118 => @PLACE(166, 90);
//   $JUNCTION @ATTACH %p119 => @PLACE(142, 90);
//   $JUNCTION @ATTACH %p120 => @PLACE(118, 90);
//   $JUNCTION @ATTACH %p121 => @PLACE(80, 90);
//   $JUNCTION @ATTACH %p122 => @PLACE(56, 90);
//   $JUNCTION @ATTACH %p123 => @PLACE(32, 90);
//   $JUNCTION @ATTACH %p124 => @PLACE(10, 90);
//   $JUNCTION @ATTACH %p127 => @PLACE(370, 55);
//   $JUNCTION @ATTACH %p128 => @PLACE(346, 55);
//   $JUNCTION @ATTACH %p129 => @PLACE(322, 55);
//   $JUNCTION @ATTACH %p130 => @PLACE(298, 55);
//   $JUNCTION @ATTACH %p131 => @PLACE(274, 55);
//   $JUNCTION @ATTACH %p132 => @PLACE(250, 55);
//   $JUNCTION @ATTACH %p133 => @PLACE(226, 55);
//   $JUNCTION @ATTACH %p134 => @PLACE(190, 55);
//   $JUNCTION @ATTACH %p135 => @PLACE(166, 55);
//   $JUNCTION @ATTACH %p136 => @PLACE(142, 55);
//   $JUNCTION @ATTACH %p137 => @PLACE(118, 55);
//   $JUNCTION @ATTACH %p138 => @PLACE(80, 55);
//   $JUNCTION @ATTACH %p139 => @PLACE(56, 55);
//   $JUNCTION @ATTACH %p140 => @PLACE(32, 55);
//   $JUNCTION @ATTACH %p141 => @PLACE(10, 55);
//   $JUNCTION @ATTACH %p143 => @PLACE(215, 74);
//   $JUNCTION @ATTACH %p145 => @PLACE(215, 39);
//   $JUNCTION @ATTACH %p148 => @PLACE(372, 86);
//   $JUNCTION @ATTACH %p150 => @PLACE(400, 27);
//   $JUNCTION @ATTACH %p151 => @PLACE(376, 27);
//   $JUNCTION @ATTACH %p152 => @PLACE(352, 27);
//   $JUNCTION @ATTACH %p153 => @PLACE(328, 27);
//   $JUNCTION @ATTACH %p154 => @PLACE(304, 27);
//   $JUNCTION @ATTACH %p155 => @PLACE(280, 27);
//   $JUNCTION @ATTACH %p156 => @PLACE(256, 27);
//   $JUNCTION @ATTACH %p157 => @PLACE(232, 27);
//   $JUNCTION @ATTACH %p158 => @PLACE(196, 27);
//   $JUNCTION @ATTACH %p159 => @PLACE(172, 27);
//   $JUNCTION @ATTACH %p160 => @PLACE(148, 27);
//   $JUNCTION @ATTACH %p161 => @PLACE(124, 27);
//   $JUNCTION @ATTACH %p162 => @PLACE(86, 27);
//   $JUNCTION @ATTACH %p163 => @PLACE(62, 27);
//   $JUNCTION @ATTACH %p164 => @PLACE(38, 27);
//   $JUNCTION @ATTACH %p165 => @PLACE(14, 27);
//   $JUNCTION @ATTACH %p167 => @PLACE(400, 62);
//   $JUNCTION @ATTACH %p168 => @PLACE(376, 62);
//   $JUNCTION @ATTACH %p169 => @PLACE(352, 62);
//   $JUNCTION @ATTACH %p170 => @PLACE(328, 62);
//   $JUNCTION @ATTACH %p171 => @PLACE(304, 62);
//   $JUNCTION @ATTACH %p172 => @PLACE(280, 62);
//   $JUNCTION @ATTACH %p173 => @PLACE(256, 62);
//   $JUNCTION @ATTACH %p174 => @PLACE(232, 62);
//   $JUNCTION @ATTACH %p175 => @PLACE(196, 62);
//   $JUNCTION @ATTACH %p176 => @PLACE(172, 62);
//   $JUNCTION @ATTACH %p177 => @PLACE(148, 62);
//   $JUNCTION @ATTACH %p178 => @PLACE(124, 62);
//   $JUNCTION @ATTACH %p179 => @PLACE(86, 62);
//   $JUNCTION @ATTACH %p180 => @PLACE(62, 62);
//   $JUNCTION @ATTACH %p181 => @PLACE(38, 62);
//   $JUNCTION @ATTACH %p182 => @PLACE(14, 62);
//   $JUNCTION @ATTACH %p188 => @PLACE(444, -743);
//   $JUNCTION @ATTACH %p189 => @PLACE(29, -760);
//   $JUNCTION @ATTACH %p190 => @PLACE(53, -760);
//   $JUNCTION @ATTACH %p191 => @PLACE(77, -760);
//   $JUNCTION @ATTACH %p192 => @PLACE(115, -760);
//   $JUNCTION @ATTACH %p193 => @PLACE(187, -760);
//   $JUNCTION @ATTACH %p194 => @PLACE(223, -760);
//   $JUNCTION @ATTACH %p195 => @PLACE(367, -760);
//   $JUNCTION @ATTACH %p196 => @PLACE(391, -760);
//   $JUNCTION @ATTACH %p197 => @PLACE(319, -760);
//   $JUNCTION @ATTACH %p198 => @PLACE(343, -760);
//   $JUNCTION @ATTACH %p199 => @PLACE(247, -760);
//   $JUNCTION @ATTACH %p200 => @PLACE(295, -760);
//   $JUNCTION @ATTACH %p201 => @PLACE(271, -760);
//   $JUNCTION @ATTACH %p202 => @PLACE(163, -760);
//   $JUNCTION @ATTACH %p204 => @PLACE(139, -760);
//   $JUNCTION @ATTACH %p211 => @PLACE(252, 16);
//   $JUNCTION @ATTACH %p214 => @PLACE(215, 4);
//   $JUNCTION @ATTACH %p216 => @PLACE(14, -8);
//   $JUNCTION @ATTACH %p217 => @PLACE(38, -8);
//   $JUNCTION @ATTACH %p218 => @PLACE(196, -8);
//   $JUNCTION @ATTACH %p219 => @PLACE(232, -8);
//   $JUNCTION @ATTACH %p221 => @PLACE(148, -8);
//   $JUNCTION @ATTACH %p222 => @PLACE(172, -8);
//   $JUNCTION @ATTACH %p223 => @PLACE(256, -8);
//   $JUNCTION @ATTACH %p224 => @PLACE(328, -8);
//   $JUNCTION @ATTACH %p225 => @PLACE(352, -8);
//   $JUNCTION @ATTACH %p226 => @PLACE(86, -8);
//   $JUNCTION @ATTACH %p227 => @PLACE(124, -8);
//   $JUNCTION @ATTACH %p228 => @PLACE(304, -8);
//   $JUNCTION @ATTACH %p229 => @PLACE(280, -8);
//   $JUNCTION @ATTACH %p230 => @PLACE(400, -8);
//   $JUNCTION @ATTACH %p231 => @PLACE(376, -8);
//   $JUNCTION @ATTACH %p232 => @PLACE(62, -8);
//   $JUNCTION @ATTACH %p233 => @PLACE(276, 16);
//   $JUNCTION @ATTACH %p237 => @PLACE(32, 20);
//   $JUNCTION @ATTACH %p238 => @PLACE(56, 20);
//   $JUNCTION @ATTACH %p239 => @PLACE(322, 20);
//   $JUNCTION @ATTACH %p240 => @PLACE(346, 20);
//   $JUNCTION @ATTACH %p241 => @PLACE(370, 20);
//   $JUNCTION @ATTACH %p242 => @PLACE(142, 20);
//   $JUNCTION @ATTACH %p243 => @PLACE(166, 20);
//   $JUNCTION @ATTACH %p245 => @PLACE(298, 20);
//   $JUNCTION @ATTACH %p246 => @PLACE(250, 20);
//   $JUNCTION @ATTACH %p247 => @PLACE(274, 20);
//   $JUNCTION @ATTACH %p248 => @PLACE(80, 20);
//   $JUNCTION @ATTACH %p249 => @PLACE(118, 20);
//   $JUNCTION @ATTACH %p250 => @PLACE(226, 20);
//   $JUNCTION @ATTACH %p251 => @PLACE(10, 20);
//   $JUNCTION @ATTACH %p253 => @PLACE(190, 20);
//   $JUNCTION @ATTACH %p254 => @PLACE(205, 4);
//   $JUNCTION @ATTACH %p257 => @PLACE(107, 4);
//   $JUNCTION @ATTACH %p260 => @PLACE(97, 4);
//   $JUNCTION @ATTACH %p261 => @PLACE(-6, 4);
//   $JUNCTION @ATTACH %p263 => @PLACE(168, 16);
//   $JUNCTION @ATTACH %p266 => @PLACE(192, 16);
//   $JUNCTION @ATTACH %p270 => @PLACE(376, -17);
//   $JUNCTION @ATTACH %p272 => @PLACE(228, 16);
//   $JUNCTION @ATTACH %p277 => @PLACE(324, 16);
//   $JUNCTION @ATTACH %p279 => @PLACE(348, 16);
//   $JUNCTION @ATTACH %p283 => @PLACE(148, -17);
//   $JUNCTION @ATTACH %p286 => @PLACE(372, 16);
//   $JUNCTION @ATTACH %p293 => @PLACE(396, 16);
//   $JUNCTION @ATTACH %p295 => @PLACE(215, -31);
//   $JUNCTION @ATTACH %p302 => @PLACE(62, -17);
//   $JUNCTION @ATTACH %p304 => @PLACE(58, 16);
//   $JUNCTION @ATTACH %p308 => @PLACE(82, 16);
//   $JUNCTION @ATTACH %p311 => @PLACE(120, 16);
//   $JUNCTION @ATTACH %p314 => @PLACE(118, -15);
//   $JUNCTION @ATTACH %p315 => @PLACE(142, -15);
//   $JUNCTION @ATTACH %p316 => @PLACE(370, -15);
//   $JUNCTION @ATTACH %p318 => @PLACE(32, -15);
//   $JUNCTION @ATTACH %p319 => @PLACE(346, -15);
//   $JUNCTION @ATTACH %p320 => @PLACE(226, -15);
//   $JUNCTION @ATTACH %p321 => @PLACE(250, -15);
//   $JUNCTION @ATTACH %p322 => @PLACE(190, -15);
//   $JUNCTION @ATTACH %p323 => @PLACE(298, -15);
//   $JUNCTION @ATTACH %p324 => @PLACE(322, -15);
//   $JUNCTION @ATTACH %p325 => @PLACE(274, -15);
//   $JUNCTION @ATTACH %p326 => @PLACE(56, -15);
//   $JUNCTION @ATTACH %p328 => @PLACE(10, -15);
//   $JUNCTION @ATTACH %p329 => @PLACE(80, -15);
//   $JUNCTION @ATTACH %p330 => @PLACE(166, -15);
//   $JUNCTION @ATTACH %p331 => @PLACE(144, 16);
//   $JUNCTION @ATTACH %p338 => @PLACE(328, -17);
//   $JUNCTION @ATTACH %p341 => @PLACE(352, -17);
//   $JUNCTION @ATTACH %p343 => @PLACE(304, -17);
//   $JUNCTION @ATTACH %p346 => @PLACE(38, -17);
//   $JUNCTION @ATTACH %p350 => @PLACE(14, -17);
//   $JUNCTION @ATTACH %p353 => @PLACE(172, -17);
//   $JUNCTION @ATTACH %p357 => @PLACE(34, 16);
//   $JUNCTION @ATTACH %p360 => @PLACE(14, -43);
//   $JUNCTION @ATTACH %p361 => @PLACE(172, -43);
//   $JUNCTION @ATTACH %p362 => @PLACE(280, -43);
//   $JUNCTION @ATTACH %p363 => @PLACE(304, -43);
//   $JUNCTION @ATTACH %p364 => @PLACE(256, -43);
//   $JUNCTION @ATTACH %p365 => @PLACE(400, -43);
//   $JUNCTION @ATTACH %p366 => @PLACE(328, -43);
//   $JUNCTION @ATTACH %p367 => @PLACE(232, -43);
//   $JUNCTION @ATTACH %p368 => @PLACE(86, -43);
//   $JUNCTION @ATTACH %p369 => @PLACE(148, -43);
//   $JUNCTION @ATTACH %p370 => @PLACE(38, -43);
//   $JUNCTION @ATTACH %p371 => @PLACE(62, -43);
//   $JUNCTION @ATTACH %p372 => @PLACE(352, -43);
//   $JUNCTION @ATTACH %p373 => @PLACE(196, -43);
//   $JUNCTION @ATTACH %p374 => @PLACE(124, -43);
//   $JUNCTION @ATTACH %p375 => @PLACE(376, -43);
//   $JUNCTION @ATTACH %p379 => @PLACE(107, -31);
//   $JUNCTION @ATTACH %p380 => @PLACE(205, -31);
//   $JUNCTION @ATTACH %p382 => @PLACE(300, 16);
//   $JUNCTION @ATTACH %p386 => @PLACE(97, -31);
//   $JUNCTION @ATTACH %p388 => @PLACE(-18, -31);
//   $JUNCTION @ATTACH %p392 => @PLACE(196, -17);
//   $JUNCTION @ATTACH %p403 => @PLACE(14, -367);
//   $JUNCTION @ATTACH %p414 => @PLACE(-6, -696);
//   $JUNCTION @ATTACH %p417 => @PLACE(97, -696);
//   $JUNCTION @ATTACH %p419 => @PLACE(14, -708);
//   $JUNCTION @ATTACH %p420 => @PLACE(400, -708);
//   $JUNCTION @ATTACH %p421 => @PLACE(376, -708);
//   $JUNCTION @ATTACH %p422 => @PLACE(352, -708);
//   $JUNCTION @ATTACH %p423 => @PLACE(328, -708);
//   $JUNCTION @ATTACH %p424 => @PLACE(304, -708);
//   $JUNCTION @ATTACH %p425 => @PLACE(280, -708);
//   $JUNCTION @ATTACH %p426 => @PLACE(256, -708);
//   $JUNCTION @ATTACH %p427 => @PLACE(232, -708);
//   $JUNCTION @ATTACH %p428 => @PLACE(196, -708);
//   $JUNCTION @ATTACH %p429 => @PLACE(172, -708);
//   $JUNCTION @ATTACH %p430 => @PLACE(148, -708);
//   $JUNCTION @ATTACH %p431 => @PLACE(124, -708);
//   $JUNCTION @ATTACH %p432 => @PLACE(86, -708);
//   $JUNCTION @ATTACH %p433 => @PLACE(62, -708);
//   $JUNCTION @ATTACH %p434 => @PLACE(38, -708);
//   $JUNCTION @ATTACH %p436 => @PLACE(370, -680);
//   $JUNCTION @ATTACH %p437 => @PLACE(346, -680);
//   $JUNCTION @ATTACH %p438 => @PLACE(322, -680);
//   $JUNCTION @ATTACH %p439 => @PLACE(298, -680);
//   $JUNCTION @ATTACH %p440 => @PLACE(274, -680);
//   $JUNCTION @ATTACH %p441 => @PLACE(250, -680);
//   $JUNCTION @ATTACH %p442 => @PLACE(226, -680);
//   $JUNCTION @ATTACH %p443 => @PLACE(190, -680);
//   $JUNCTION @ATTACH %p444 => @PLACE(166, -680);
//   $JUNCTION @ATTACH %p445 => @PLACE(142, -680);
//   $JUNCTION @ATTACH %p446 => @PLACE(118, -680);
//   $JUNCTION @ATTACH %p447 => @PLACE(80, -680);
//   $JUNCTION @ATTACH %p448 => @PLACE(56, -680);
//   $JUNCTION @ATTACH %p449 => @PLACE(32, -680);
//   $JUNCTION @ATTACH %p450 => @PLACE(10, -680);
//   $JUNCTION @ATTACH %p453 => @PLACE(34, -684);
//   $JUNCTION @ATTACH %p456 => @PLACE(58, -684);
//   $JUNCTION @ATTACH %p459 => @PLACE(82, -684);
//   $JUNCTION @ATTACH %p462 => @PLACE(120, -684);
//   $JUNCTION @ATTACH %p465 => @PLACE(280, -227);
//   $JUNCTION @ATTACH %p467 => @PLACE(215, -241);
//   $JUNCTION @ATTACH %p469 => @PLACE(352, -253);
//   $JUNCTION @ATTACH %p470 => @PLACE(376, -253);
//   $JUNCTION @ATTACH %p471 => @PLACE(148, -253);
//   $JUNCTION @ATTACH %p472 => @PLACE(38, -253);
//   $JUNCTION @ATTACH %p473 => @PLACE(62, -253);
//   $JUNCTION @ATTACH %p474 => @PLACE(124, -253);
//   $JUNCTION @ATTACH %p475 => @PLACE(86, -253);
//   $JUNCTION @ATTACH %p476 => @PLACE(14, -253);
//   $JUNCTION @ATTACH %p477 => @PLACE(328, -253);
//   $JUNCTION @ATTACH %p478 => @PLACE(304, -253);
//   $JUNCTION @ATTACH %p479 => @PLACE(232, -253);
//   $JUNCTION @ATTACH %p480 => @PLACE(256, -253);
//   $JUNCTION @ATTACH %p482 => @PLACE(172, -253);
//   $JUNCTION @ATTACH %p483 => @PLACE(196, -253);
//   $JUNCTION @ATTACH %p484 => @PLACE(280, -253);
//   $JUNCTION @ATTACH %p485 => @PLACE(400, -253);
//   $JUNCTION @ATTACH %p486 => @PLACE(232, -227);
//   $JUNCTION @ATTACH %p491 => @PLACE(256, -227);
//   $JUNCTION @ATTACH %p492 => @PLACE(166, -225);
//   $JUNCTION @ATTACH %p493 => @PLACE(142, -225);
//   $JUNCTION @ATTACH %p494 => @PLACE(118, -225);
//   $JUNCTION @ATTACH %p495 => @PLACE(80, -225);
//   $JUNCTION @ATTACH %p496 => @PLACE(56, -225);
//   $JUNCTION @ATTACH %p497 => @PLACE(32, -225);
//   $JUNCTION @ATTACH %p498 => @PLACE(10, -225);
//   $JUNCTION @ATTACH %p500 => @PLACE(346, -225);
//   $JUNCTION @ATTACH %p501 => @PLACE(322, -225);
//   $JUNCTION @ATTACH %p502 => @PLACE(226, -225);
//   $JUNCTION @ATTACH %p503 => @PLACE(298, -225);
//   $JUNCTION @ATTACH %p504 => @PLACE(370, -225);
//   $JUNCTION @ATTACH %p505 => @PLACE(250, -225);
//   $JUNCTION @ATTACH %p506 => @PLACE(274, -225);
//   $JUNCTION @ATTACH %p508 => @PLACE(190, -225);
//   $JUNCTION @ATTACH %p510 => @PLACE(352, -367);
//   $JUNCTION @ATTACH %p512 => @PLACE(215, -381);
//   $JUNCTION @ATTACH %p514 => @PLACE(328, -393);
//   $JUNCTION @ATTACH %p515 => @PLACE(124, -393);
//   $JUNCTION @ATTACH %p516 => @PLACE(38, -393);
//   $JUNCTION @ATTACH %p517 => @PLACE(62, -393);
//   $JUNCTION @ATTACH %p518 => @PLACE(86, -393);
//   $JUNCTION @ATTACH %p519 => @PLACE(14, -393);
//   $JUNCTION @ATTACH %p520 => @PLACE(256, -393);
//   $JUNCTION @ATTACH %p521 => @PLACE(280, -393);
//   $JUNCTION @ATTACH %p523 => @PLACE(400, -393);
//   $JUNCTION @ATTACH %p524 => @PLACE(352, -393);
//   $JUNCTION @ATTACH %p525 => @PLACE(376, -393);
//   $JUNCTION @ATTACH %p526 => @PLACE(196, -393);
//   $JUNCTION @ATTACH %p527 => @PLACE(172, -393);
//   $JUNCTION @ATTACH %p528 => @PLACE(304, -393);
//   $JUNCTION @ATTACH %p529 => @PLACE(232, -393);
//   $JUNCTION @ATTACH %p530 => @PLACE(148, -393);
//   $JUNCTION @ATTACH %p532 => @PLACE(304, -367);
//   $JUNCTION @ATTACH %p535 => @PLACE(328, -367);
//   $JUNCTION @ATTACH %p538 => @PLACE(-18, -731);
//   $JUNCTION @ATTACH %p539 => @PLACE(97, -731);
//   $JUNCTION @ATTACH %p544 => @PLACE(252, -684);
//   $JUNCTION @ATTACH %p547 => @PLACE(215, -696);
//   $JUNCTION @ATTACH %p549 => @PLACE(276, -684);
//   $JUNCTION @ATTACH %p552 => @PLACE(228, -684);
//   $JUNCTION @ATTACH %p555 => @PLACE(192, -684);
//   $JUNCTION @ATTACH %p557 => @PLACE(205, -696);
//   $JUNCTION @ATTACH %p559 => @PLACE(107, -696);
//   $JUNCTION @ATTACH %p562 => @PLACE(168, -684);
//   $JUNCTION @ATTACH %p564 => @PLACE(346, -365);
//   $JUNCTION @ATTACH %p565 => @PLACE(370, -365);
//   $JUNCTION @ATTACH %p566 => @PLACE(226, -365);
//   $JUNCTION @ATTACH %p567 => @PLACE(10, -365);
//   $JUNCTION @ATTACH %p568 => @PLACE(32, -365);
//   $JUNCTION @ATTACH %p570 => @PLACE(250, -365);
//   $JUNCTION @ATTACH %p571 => @PLACE(274, -365);
//   $JUNCTION @ATTACH %p572 => @PLACE(190, -365);
//   $JUNCTION @ATTACH %p573 => @PLACE(322, -365);
//   $JUNCTION @ATTACH %p574 => @PLACE(118, -365);
//   $JUNCTION @ATTACH %p575 => @PLACE(142, -365);
//   $JUNCTION @ATTACH %p576 => @PLACE(56, -365);
//   $JUNCTION @ATTACH %p577 => @PLACE(80, -365);
//   $JUNCTION @ATTACH %p578 => @PLACE(298, -365);
//   $JUNCTION @ATTACH %p579 => @PLACE(166, -365);
//   $JUNCTION @ATTACH %p582 => @PLACE(172, -87);
//   $JUNCTION @ATTACH %p585 => @PLACE(205, -101);
//   $JUNCTION @ATTACH %p586 => @PLACE(107, -101);
//   $JUNCTION @ATTACH %p588 => @PLACE(14, -113);
//   $JUNCTION @ATTACH %p589 => @PLACE(400, -113);
//   $JUNCTION @ATTACH %p590 => @PLACE(376, -113);
//   $JUNCTION @ATTACH %p591 => @PLACE(352, -113);
//   $JUNCTION @ATTACH %p592 => @PLACE(328, -113);
//   $JUNCTION @ATTACH %p593 => @PLACE(304, -113);
//   $JUNCTION @ATTACH %p594 => @PLACE(38, -113);
//   $JUNCTION @ATTACH %p595 => @PLACE(280, -113);
//   $JUNCTION @ATTACH %p596 => @PLACE(256, -113);
//   $JUNCTION @ATTACH %p597 => @PLACE(232, -113);
//   $JUNCTION @ATTACH %p598 => @PLACE(196, -113);
//   $JUNCTION @ATTACH %p599 => @PLACE(172, -113);
//   $JUNCTION @ATTACH %p600 => @PLACE(148, -113);
//   $JUNCTION @ATTACH %p601 => @PLACE(124, -113);
//   $JUNCTION @ATTACH %p602 => @PLACE(86, -113);
//   $JUNCTION @ATTACH %p603 => @PLACE(62, -113);
//   $JUNCTION @ATTACH %p606 => @PLACE(124, -87);
//   $JUNCTION @ATTACH %p610 => @PLACE(14, -87);
//   $JUNCTION @ATTACH %p614 => @PLACE(396, -684);
//   $JUNCTION @ATTACH %p619 => @PLACE(372, -684);
//   $JUNCTION @ATTACH %p622 => @PLACE(348, -684);
//   $JUNCTION @ATTACH %p625 => @PLACE(324, -684);
//   $JUNCTION @ATTACH %p628 => @PLACE(300, -684);
//   $JUNCTION @ATTACH %p631 => @PLACE(148, -87);
//   $JUNCTION @ATTACH %p634 => @PLACE(370, -85);
//   $JUNCTION @ATTACH %p635 => @PLACE(346, -85);
//   $JUNCTION @ATTACH %p636 => @PLACE(32, -85);
//   $JUNCTION @ATTACH %p637 => @PLACE(322, -85);
//   $JUNCTION @ATTACH %p638 => @PLACE(298, -85);
//   $JUNCTION @ATTACH %p639 => @PLACE(10, -85);
//   $JUNCTION @ATTACH %p640 => @PLACE(274, -85);
//   $JUNCTION @ATTACH %p641 => @PLACE(250, -85);
//   $JUNCTION @ATTACH %p642 => @PLACE(226, -85);
//   $JUNCTION @ATTACH %p643 => @PLACE(190, -85);
//   $JUNCTION @ATTACH %p644 => @PLACE(166, -85);
//   $JUNCTION @ATTACH %p645 => @PLACE(142, -85);
//   $JUNCTION @ATTACH %p646 => @PLACE(118, -85);
//   $JUNCTION @ATTACH %p647 => @PLACE(56, -85);
//   $JUNCTION @ATTACH %p648 => @PLACE(80, -85);
//   $JUNCTION @ATTACH %p651 => @PLACE(196, -87);
//   $JUNCTION @ATTACH %p654 => @PLACE(232, -87);
//   $JUNCTION @ATTACH %p657 => @PLACE(256, -87);
//   $JUNCTION @ATTACH %p660 => @PLACE(34, -194);
//   $JUNCTION @ATTACH %p663 => @PLACE(58, -194);
//   $JUNCTION @ATTACH %p665 => @PLACE(215, -101);
//   $JUNCTION @ATTACH %p667 => @PLACE(97, -241);
//   $JUNCTION @ATTACH %p669 => @PLACE(-18, -241);
//   $JUNCTION @ATTACH %p672 => @PLACE(304, -87);
//   $JUNCTION @ATTACH %p675 => @PLACE(280, -87);
//   $JUNCTION @ATTACH %p678 => @PLACE(-18, -661);
//   $JUNCTION @ATTACH %p680 => @PLACE(97, -661);
//   $JUNCTION @ATTACH %p682 => @PLACE(86, -157);
//   $JUNCTION @ATTACH %p684 => @PLACE(62, -183);
//   $JUNCTION @ATTACH %p685 => @PLACE(86, -183);
//   $JUNCTION @ATTACH %p686 => @PLACE(38, -183);
//   $JUNCTION @ATTACH %p687 => @PLACE(14, -183);
//   $JUNCTION @ATTACH %p688 => @PLACE(400, -183);
//   $JUNCTION @ATTACH %p689 => @PLACE(376, -183);
//   $JUNCTION @ATTACH %p690 => @PLACE(352, -183);
//   $JUNCTION @ATTACH %p691 => @PLACE(124, -183);
//   $JUNCTION @ATTACH %p692 => @PLACE(328, -183);
//   $JUNCTION @ATTACH %p693 => @PLACE(304, -183);
//   $JUNCTION @ATTACH %p694 => @PLACE(280, -183);
//   $JUNCTION @ATTACH %p695 => @PLACE(256, -183);
//   $JUNCTION @ATTACH %p696 => @PLACE(232, -183);
//   $JUNCTION @ATTACH %p697 => @PLACE(196, -183);
//   $JUNCTION @ATTACH %p698 => @PLACE(172, -183);
//   $JUNCTION @ATTACH %p699 => @PLACE(148, -183);
//   $JUNCTION @ATTACH %p702 => @PLACE(38, -157);
//   $JUNCTION @ATTACH %p706 => @PLACE(300, -544);
//   $JUNCTION @ATTACH %p707 => @PLACE(215, -556);
//   $JUNCTION @ATTACH %p710 => @PLACE(14, -568);
//   $JUNCTION @ATTACH %p711 => @PLACE(400, -568);
//   $JUNCTION @ATTACH %p712 => @PLACE(376, -568);
//   $JUNCTION @ATTACH %p713 => @PLACE(352, -568);
//   $JUNCTION @ATTACH %p714 => @PLACE(328, -568);
//   $JUNCTION @ATTACH %p715 => @PLACE(304, -568);
//   $JUNCTION @ATTACH %p716 => @PLACE(124, -568);
//   $JUNCTION @ATTACH %p717 => @PLACE(86, -568);
//   $JUNCTION @ATTACH %p718 => @PLACE(38, -568);
//   $JUNCTION @ATTACH %p719 => @PLACE(62, -568);
//   $JUNCTION @ATTACH %p720 => @PLACE(148, -568);
//   $JUNCTION @ATTACH %p721 => @PLACE(232, -568);
//   $JUNCTION @ATTACH %p722 => @PLACE(256, -568);
//   $JUNCTION @ATTACH %p723 => @PLACE(280, -568);
//   $JUNCTION @ATTACH %p724 => @PLACE(196, -568);
//   $JUNCTION @ATTACH %p725 => @PLACE(172, -568);
//   $JUNCTION @ATTACH %p727 => @PLACE(324, -544);
//   $JUNCTION @ATTACH %p730 => @PLACE(370, -540);
//   $JUNCTION @ATTACH %p731 => @PLACE(346, -540);
//   $JUNCTION @ATTACH %p732 => @PLACE(322, -540);
//   $JUNCTION @ATTACH %p733 => @PLACE(118, -540);
//   $JUNCTION @ATTACH %p734 => @PLACE(32, -540);
//   $JUNCTION @ATTACH %p735 => @PLACE(56, -540);
//   $JUNCTION @ATTACH %p736 => @PLACE(80, -540);
//   $JUNCTION @ATTACH %p738 => @PLACE(10, -540);
//   $JUNCTION @ATTACH %p739 => @PLACE(274, -540);
//   $JUNCTION @ATTACH %p740 => @PLACE(298, -540);
//   $JUNCTION @ATTACH %p741 => @PLACE(142, -540);
//   $JUNCTION @ATTACH %p742 => @PLACE(190, -540);
//   $JUNCTION @ATTACH %p743 => @PLACE(226, -540);
//   $JUNCTION @ATTACH %p744 => @PLACE(166, -540);
//   $JUNCTION @ATTACH %p745 => @PLACE(250, -540);
//   $JUNCTION @ATTACH %p747 => @PLACE(62, -157);
//   $JUNCTION @ATTACH %p749 => @PLACE(80, -155);
//   $JUNCTION @ATTACH %p750 => @PLACE(56, -155);
//   $JUNCTION @ATTACH %p751 => @PLACE(32, -155);
//   $JUNCTION @ATTACH %p752 => @PLACE(10, -155);
//   $JUNCTION @ATTACH %p754 => @PLACE(118, -155);
//   $JUNCTION @ATTACH %p756 => @PLACE(370, -155);
//   $JUNCTION @ATTACH %p757 => @PLACE(346, -155);
//   $JUNCTION @ATTACH %p758 => @PLACE(322, -155);
//   $JUNCTION @ATTACH %p759 => @PLACE(298, -155);
//   $JUNCTION @ATTACH %p760 => @PLACE(274, -155);
//   $JUNCTION @ATTACH %p761 => @PLACE(250, -155);
//   $JUNCTION @ATTACH %p762 => @PLACE(226, -155);
//   $JUNCTION @ATTACH %p763 => @PLACE(190, -155);
//   $JUNCTION @ATTACH %p764 => @PLACE(166, -155);
//   $JUNCTION @ATTACH %p765 => @PLACE(142, -155);
//   $JUNCTION @ATTACH %p766 => @PLACE(205, -416);
//   $JUNCTION @ATTACH %p769 => @PLACE(107, -416);
//   $JUNCTION @ATTACH %p770 => @PLACE(-6, -416);
//   $JUNCTION @ATTACH %p771 => @PLACE(97, -416);
//   $JUNCTION @ATTACH %p774 => @PLACE(252, -404);
//   $JUNCTION @ATTACH %p777 => @PLACE(215, -416);
//   $JUNCTION @ATTACH %p779 => @PLACE(280, -428);
//   $JUNCTION @ATTACH %p780 => @PLACE(196, -428);
//   $JUNCTION @ATTACH %p781 => @PLACE(148, -428);
//   $JUNCTION @ATTACH %p782 => @PLACE(38, -428);
//   $JUNCTION @ATTACH %p783 => @PLACE(62, -428);
//   $JUNCTION @ATTACH %p784 => @PLACE(86, -428);
//   $JUNCTION @ATTACH %p785 => @PLACE(400, -428);
//   $JUNCTION @ATTACH %p786 => @PLACE(352, -428);
//   $JUNCTION @ATTACH %p787 => @PLACE(376, -428);
//   $JUNCTION @ATTACH %p788 => @PLACE(304, -428);
//   $JUNCTION @ATTACH %p789 => @PLACE(232, -428);
//   $JUNCTION @ATTACH %p790 => @PLACE(328, -428);
//   $JUNCTION @ATTACH %p791 => @PLACE(256, -428);
//   $JUNCTION @ATTACH %p793 => @PLACE(14, -428);
//   $JUNCTION @ATTACH %p794 => @PLACE(124, -428);
//   $JUNCTION @ATTACH %p795 => @PLACE(172, -428);
//   $JUNCTION @ATTACH %p797 => @PLACE(276, -404);
//   $JUNCTION @ATTACH %p800 => @PLACE(370, -400);
//   $JUNCTION @ATTACH %p801 => @PLACE(80, -400);
//   $JUNCTION @ATTACH %p802 => @PLACE(118, -400);
//   $JUNCTION @ATTACH %p803 => @PLACE(32, -400);
//   $JUNCTION @ATTACH %p804 => @PLACE(56, -400);
//   $JUNCTION @ATTACH %p805 => @PLACE(142, -400);
//   $JUNCTION @ATTACH %p807 => @PLACE(10, -400);
//   $JUNCTION @ATTACH %p808 => @PLACE(250, -400);
//   $JUNCTION @ATTACH %p809 => @PLACE(274, -400);
//   $JUNCTION @ATTACH %p810 => @PLACE(322, -400);
//   $JUNCTION @ATTACH %p811 => @PLACE(346, -400);
//   $JUNCTION @ATTACH %p812 => @PLACE(190, -400);
//   $JUNCTION @ATTACH %p813 => @PLACE(226, -400);
//   $JUNCTION @ATTACH %p814 => @PLACE(166, -400);
//   $JUNCTION @ATTACH %p815 => @PLACE(298, -400);
//   $JUNCTION @ATTACH %p817 => @PLACE(328, -87);
//   $JUNCTION @ATTACH %p820 => @PLACE(352, -87);
//   $JUNCTION @ATTACH %p822 => @PLACE(376, -87);
//   $JUNCTION @ATTACH %p826 => @PLACE(14, -437);
//   $JUNCTION @ATTACH %p828 => @PLACE(34, -404);
//   $JUNCTION @ATTACH %p833 => @PLACE(-18, -451);
//   $JUNCTION @ATTACH %p834 => @PLACE(97, -451);
//   $JUNCTION @ATTACH %p839 => @PLACE(300, -334);
//   $JUNCTION @ATTACH %p842 => @PLACE(215, -346);
//   $JUNCTION @ATTACH %p844 => @PLACE(352, -358);
//   $JUNCTION @ATTACH %p845 => @PLACE(14, -358);
//   $JUNCTION @ATTACH %p846 => @PLACE(38, -358);
//   $JUNCTION @ATTACH %p847 => @PLACE(86, -358);
//   $JUNCTION @ATTACH %p848 => @PLACE(124, -358);
//   $JUNCTION @ATTACH %p849 => @PLACE(256, -358);
//   $JUNCTION @ATTACH %p850 => @PLACE(304, -358);
//   $JUNCTION @ATTACH %p851 => @PLACE(328, -358);
//   $JUNCTION @ATTACH %p852 => @PLACE(62, -358);
//   $JUNCTION @ATTACH %p853 => @PLACE(232, -358);
//   $JUNCTION @ATTACH %p854 => @PLACE(400, -358);
//   $JUNCTION @ATTACH %p856 => @PLACE(376, -358);
//   $JUNCTION @ATTACH %p857 => @PLACE(280, -358);
//   $JUNCTION @ATTACH %p858 => @PLACE(148, -358);
//   $JUNCTION @ATTACH %p859 => @PLACE(172, -358);
//   $JUNCTION @ATTACH %p860 => @PLACE(196, -358);
//   $JUNCTION @ATTACH %p862 => @PLACE(324, -334);
//   $JUNCTION @ATTACH %p864 => @PLACE(226, -330);
//   $JUNCTION @ATTACH %p865 => @PLACE(274, -330);
//   $JUNCTION @ATTACH %p866 => @PLACE(298, -330);
//   $JUNCTION @ATTACH %p867 => @PLACE(250, -330);
//   $JUNCTION @ATTACH %p868 => @PLACE(322, -330);
//   $JUNCTION @ATTACH %p869 => @PLACE(32, -330);
//   $JUNCTION @ATTACH %p870 => @PLACE(56, -330);
//   $JUNCTION @ATTACH %p871 => @PLACE(10, -330);
//   $JUNCTION @ATTACH %p872 => @PLACE(346, -330);
//   $JUNCTION @ATTACH %p873 => @PLACE(142, -330);
//   $JUNCTION @ATTACH %p874 => @PLACE(166, -330);
//   $JUNCTION @ATTACH %p875 => @PLACE(370, -330);
//   $JUNCTION @ATTACH %p877 => @PLACE(190, -330);
//   $JUNCTION @ATTACH %p878 => @PLACE(80, -330);
//   $JUNCTION @ATTACH %p880 => @PLACE(118, -330);
//   $JUNCTION @ATTACH %p882 => @PLACE(124, -157);
//   $JUNCTION @ATTACH %p885 => @PLACE(-18, -311);
//   $JUNCTION @ATTACH %p886 => @PLACE(97, -311);
//   $JUNCTION @ATTACH %p889 => @PLACE(256, -577);
//   $JUNCTION @ATTACH %p891 => @PLACE(215, -591);
//   $JUNCTION @ATTACH %p894 => @PLACE(14, -603);
//   $JUNCTION @ATTACH %p895 => @PLACE(232, -603);
//   $JUNCTION @ATTACH %p896 => @PLACE(376, -603);
//   $JUNCTION @ATTACH %p897 => @PLACE(400, -603);
//   $JUNCTION @ATTACH %p898 => @PLACE(352, -603);
//   $JUNCTION @ATTACH %p899 => @PLACE(124, -603);
//   $JUNCTION @ATTACH %p900 => @PLACE(148, -603);
//   $JUNCTION @ATTACH %p901 => @PLACE(304, -603);
//   $JUNCTION @ATTACH %p902 => @PLACE(328, -603);
//   $JUNCTION @ATTACH %p903 => @PLACE(256, -603);
//   $JUNCTION @ATTACH %p904 => @PLACE(280, -603);
//   $JUNCTION @ATTACH %p905 => @PLACE(62, -603);
//   $JUNCTION @ATTACH %p906 => @PLACE(172, -603);
//   $JUNCTION @ATTACH %p907 => @PLACE(38, -603);
//   $JUNCTION @ATTACH %p908 => @PLACE(86, -603);
//   $JUNCTION @ATTACH %p909 => @PLACE(196, -603);
//   $JUNCTION @ATTACH %p910 => @PLACE(300, -194);
//   $JUNCTION @ATTACH %p913 => @PLACE(324, -194);
//   $JUNCTION @ATTACH %p917 => @PLACE(196, -577);
//   $JUNCTION @ATTACH %p921 => @PLACE(232, -577);
//   $JUNCTION @ATTACH %p922 => @PLACE(298, -575);
//   $JUNCTION @ATTACH %p923 => @PLACE(322, -575);
//   $JUNCTION @ATTACH %p924 => @PLACE(346, -575);
//   $JUNCTION @ATTACH %p925 => @PLACE(250, -575);
//   $JUNCTION @ATTACH %p926 => @PLACE(274, -575);
//   $JUNCTION @ATTACH %p928 => @PLACE(370, -575);
//   $JUNCTION @ATTACH %p929 => @PLACE(142, -575);
//   $JUNCTION @ATTACH %p930 => @PLACE(166, -575);
//   $JUNCTION @ATTACH %p931 => @PLACE(10, -575);
//   $JUNCTION @ATTACH %p932 => @PLACE(32, -575);
//   $JUNCTION @ATTACH %p933 => @PLACE(80, -575);
//   $JUNCTION @ATTACH %p934 => @PLACE(56, -575);
//   $JUNCTION @ATTACH %p935 => @PLACE(118, -575);
//   $JUNCTION @ATTACH %p936 => @PLACE(226, -575);
//   $JUNCTION @ATTACH %p937 => @PLACE(190, -575);
//   $JUNCTION @ATTACH %p940 => @PLACE(192, -194);
//   $JUNCTION @ATTACH %p942 => @PLACE(205, -206);
//   $JUNCTION @ATTACH %p945 => @PLACE(107, -206);
//   $JUNCTION @ATTACH %p947 => @PLACE(228, -194);
//   $JUNCTION @ATTACH %p950 => @PLACE(280, -577);
//   $JUNCTION @ATTACH %p953 => @PLACE(14, -227);
//   $JUNCTION @ATTACH %p955 => @PLACE(205, -171);
//   $JUNCTION @ATTACH %p958 => @PLACE(107, -171);
//   $JUNCTION @ATTACH %p959 => @PLACE(124, -437);
//   $JUNCTION @ATTACH %p963 => @PLACE(14, -463);
//   $JUNCTION @ATTACH %p964 => @PLACE(400, -463);
//   $JUNCTION @ATTACH %p965 => @PLACE(256, -463);
//   $JUNCTION @ATTACH %p966 => @PLACE(280, -463);
//   $JUNCTION @ATTACH %p967 => @PLACE(38, -463);
//   $JUNCTION @ATTACH %p968 => @PLACE(376, -463);
//   $JUNCTION @ATTACH %p969 => @PLACE(196, -463);
//   $JUNCTION @ATTACH %p970 => @PLACE(232, -463);
//   $JUNCTION @ATTACH %p971 => @PLACE(124, -463);
//   $JUNCTION @ATTACH %p972 => @PLACE(62, -463);
//   $JUNCTION @ATTACH %p973 => @PLACE(172, -463);
//   $JUNCTION @ATTACH %p974 => @PLACE(148, -463);
//   $JUNCTION @ATTACH %p975 => @PLACE(86, -463);
//   $JUNCTION @ATTACH %p976 => @PLACE(304, -463);
//   $JUNCTION @ATTACH %p977 => @PLACE(352, -463);
//   $JUNCTION @ATTACH %p978 => @PLACE(328, -463);
//   $JUNCTION @ATTACH %p979 => @PLACE(-6, -276);
//   $JUNCTION @ATTACH %p980 => @PLACE(97, -276);
//   $JUNCTION @ATTACH %p984 => @PLACE(348, -614);
//   $JUNCTION @ATTACH %p986 => @PLACE(215, -626);
//   $JUNCTION @ATTACH %p989 => @PLACE(14, -638);
//   $JUNCTION @ATTACH %p990 => @PLACE(400, -638);
//   $JUNCTION @ATTACH %p991 => @PLACE(376, -638);
//   $JUNCTION @ATTACH %p992 => @PLACE(352, -638);
//   $JUNCTION @ATTACH %p993 => @PLACE(328, -638);
//   $JUNCTION @ATTACH %p994 => @PLACE(304, -638);
//   $JUNCTION @ATTACH %p995 => @PLACE(280, -638);
//   $JUNCTION @ATTACH %p996 => @PLACE(256, -638);
//   $JUNCTION @ATTACH %p997 => @PLACE(232, -638);
//   $JUNCTION @ATTACH %p998 => @PLACE(196, -638);
//   $JUNCTION @ATTACH %p999 => @PLACE(172, -638);
//   $JUNCTION @ATTACH %p1000 => @PLACE(148, -638);
//   $JUNCTION @ATTACH %p1001 => @PLACE(124, -638);
//   $JUNCTION @ATTACH %p1002 => @PLACE(86, -638);
//   $JUNCTION @ATTACH %p1003 => @PLACE(62, -638);
//   $JUNCTION @ATTACH %p1004 => @PLACE(38, -638);
//   $JUNCTION @ATTACH %p1006 => @PLACE(372, -614);
//   $JUNCTION @ATTACH %p1009 => @PLACE(370, -610);
//   $JUNCTION @ATTACH %p1010 => @PLACE(346, -610);
//   $JUNCTION @ATTACH %p1011 => @PLACE(322, -610);
//   $JUNCTION @ATTACH %p1012 => @PLACE(298, -610);
//   $JUNCTION @ATTACH %p1013 => @PLACE(274, -610);
//   $JUNCTION @ATTACH %p1014 => @PLACE(250, -610);
//   $JUNCTION @ATTACH %p1015 => @PLACE(226, -610);
//   $JUNCTION @ATTACH %p1016 => @PLACE(190, -610);
//   $JUNCTION @ATTACH %p1017 => @PLACE(166, -610);
//   $JUNCTION @ATTACH %p1018 => @PLACE(142, -610);
//   $JUNCTION @ATTACH %p1019 => @PLACE(118, -610);
//   $JUNCTION @ATTACH %p1020 => @PLACE(80, -610);
//   $JUNCTION @ATTACH %p1021 => @PLACE(56, -610);
//   $JUNCTION @ATTACH %p1022 => @PLACE(32, -610);
//   $JUNCTION @ATTACH %p1023 => @PLACE(10, -610);
//   $JUNCTION @ATTACH %p1026 => @PLACE(62, -437);
//   $JUNCTION @ATTACH %p1029 => @PLACE(86, -437);
//   $JUNCTION @ATTACH %p1031 => @PLACE(274, -435);
//   $JUNCTION @ATTACH %p1032 => @PLACE(370, -435);
//   $JUNCTION @ATTACH %p1033 => @PLACE(56, -435);
//   $JUNCTION @ATTACH %p1034 => @PLACE(32, -435);
//   $JUNCTION @ATTACH %p1035 => @PLACE(80, -435);
//   $JUNCTION @ATTACH %p1036 => @PLACE(118, -435);
//   $JUNCTION @ATTACH %p1037 => @PLACE(346, -435);
//   $JUNCTION @ATTACH %p1038 => @PLACE(142, -435);
//   $JUNCTION @ATTACH %p1039 => @PLACE(10, -435);
//   $JUNCTION @ATTACH %p1040 => @PLACE(226, -435);
//   $JUNCTION @ATTACH %p1041 => @PLACE(298, -435);
//   $JUNCTION @ATTACH %p1042 => @PLACE(322, -435);
//   $JUNCTION @ATTACH %p1043 => @PLACE(190, -435);
//   $JUNCTION @ATTACH %p1044 => @PLACE(250, -435);
//   $JUNCTION @ATTACH %p1046 => @PLACE(166, -435);
//   $JUNCTION @ATTACH %p1048 => @PLACE(205, -626);
//   $JUNCTION @ATTACH %p1050 => @PLACE(107, -626);
//   $JUNCTION @ATTACH %p1052 => @PLACE(-6, -626);
//   $JUNCTION @ATTACH %p1054 => @PLACE(97, -626);
//   $JUNCTION @ATTACH %p1059 => @PLACE(252, -614);
//   $JUNCTION @ATTACH %p1062 => @PLACE(276, -614);
//   $JUNCTION @ATTACH %p1065 => @PLACE(232, -367);
//   $JUNCTION @ATTACH %p1068 => @PLACE(205, -381);
//   $JUNCTION @ATTACH %p1070 => @PLACE(107, -381);
//   $JUNCTION @ATTACH %p1071 => @PLACE(172, -367);
//   $JUNCTION @ATTACH %p1075 => @PLACE(14, -647);
//   $JUNCTION @ATTACH %p1078 => @PLACE(34, -614);
//   $JUNCTION @ATTACH %p1081 => @PLACE(196, -367);
//   $JUNCTION @ATTACH %p1083 => @PLACE(38, -367);
//   $JUNCTION @ATTACH %p1088 => @PLACE(280, -507);
//   $JUNCTION @ATTACH %p1089 => @PLACE(215, -521);
//   $JUNCTION @ATTACH %p1091 => @PLACE(14, -533);
//   $JUNCTION @ATTACH %p1092 => @PLACE(38, -533);
//   $JUNCTION @ATTACH %p1093 => @PLACE(196, -533);
//   $JUNCTION @ATTACH %p1094 => @PLACE(232, -533);
//   $JUNCTION @ATTACH %p1095 => @PLACE(328, -533);
//   $JUNCTION @ATTACH %p1096 => @PLACE(148, -533);
//   $JUNCTION @ATTACH %p1097 => @PLACE(172, -533);
//   $JUNCTION @ATTACH %p1098 => @PLACE(62, -533);
//   $JUNCTION @ATTACH %p1100 => @PLACE(124, -533);
//   $JUNCTION @ATTACH %p1101 => @PLACE(400, -533);
//   $JUNCTION @ATTACH %p1102 => @PLACE(376, -533);
//   $JUNCTION @ATTACH %p1103 => @PLACE(304, -533);
//   $JUNCTION @ATTACH %p1104 => @PLACE(86, -533);
//   $JUNCTION @ATTACH %p1105 => @PLACE(280, -533);
//   $JUNCTION @ATTACH %p1106 => @PLACE(352, -533);
//   $JUNCTION @ATTACH %p1107 => @PLACE(256, -533);
//   $JUNCTION @ATTACH %p1109 => @PLACE(144, -474);
//   $JUNCTION @ATTACH %p1111 => @PLACE(205, -486);
//   $JUNCTION @ATTACH %p1113 => @PLACE(107, -486);
//   $JUNCTION @ATTACH %p1115 => @PLACE(62, -498);
//   $JUNCTION @ATTACH %p1116 => @PLACE(86, -498);
//   $JUNCTION @ATTACH %p1117 => @PLACE(232, -498);
//   $JUNCTION @ATTACH %p1118 => @PLACE(256, -498);
//   $JUNCTION @ATTACH %p1119 => @PLACE(376, -498);
//   $JUNCTION @ATTACH %p1120 => @PLACE(400, -498);
//   $JUNCTION @ATTACH %p1121 => @PLACE(172, -498);
//   $JUNCTION @ATTACH %p1122 => @PLACE(196, -498);
//   $JUNCTION @ATTACH %p1123 => @PLACE(148, -498);
//   $JUNCTION @ATTACH %p1124 => @PLACE(352, -498);
//   $JUNCTION @ATTACH %p1126 => @PLACE(14, -498);
//   $JUNCTION @ATTACH %p1127 => @PLACE(38, -498);
//   $JUNCTION @ATTACH %p1128 => @PLACE(328, -498);
//   $JUNCTION @ATTACH %p1129 => @PLACE(280, -498);
//   $JUNCTION @ATTACH %p1130 => @PLACE(304, -498);
//   $JUNCTION @ATTACH %p1131 => @PLACE(124, -498);
//   $JUNCTION @ATTACH %p1132 => @PLACE(168, -474);
//   $JUNCTION @ATTACH %p1135 => @PLACE(298, -470);
//   $JUNCTION @ATTACH %p1136 => @PLACE(322, -470);
//   $JUNCTION @ATTACH %p1137 => @PLACE(166, -470);
//   $JUNCTION @ATTACH %p1138 => @PLACE(190, -470);
//   $JUNCTION @ATTACH %p1140 => @PLACE(56, -470);
//   $JUNCTION @ATTACH %p1141 => @PLACE(80, -470);
//   $JUNCTION @ATTACH %p1142 => @PLACE(10, -470);
//   $JUNCTION @ATTACH %p1143 => @PLACE(32, -470);
//   $JUNCTION @ATTACH %p1144 => @PLACE(226, -470);
//   $JUNCTION @ATTACH %p1145 => @PLACE(274, -470);
//   $JUNCTION @ATTACH %p1146 => @PLACE(250, -470);
//   $JUNCTION @ATTACH %p1147 => @PLACE(346, -470);
//   $JUNCTION @ATTACH %p1148 => @PLACE(370, -470);
//   $JUNCTION @ATTACH %p1149 => @PLACE(118, -470);
//   $JUNCTION @ATTACH %p1150 => @PLACE(142, -470);
//   $JUNCTION @ATTACH %p1153 => @PLACE(232, -507);
//   $JUNCTION @ATTACH %p1157 => @PLACE(256, -507);
//   $JUNCTION @ATTACH %p1158 => @PLACE(118, -505);
//   $JUNCTION @ATTACH %p1159 => @PLACE(142, -505);
//   $JUNCTION @ATTACH %p1160 => @PLACE(322, -505);
//   $JUNCTION @ATTACH %p1161 => @PLACE(346, -505);
//   $JUNCTION @ATTACH %p1162 => @PLACE(32, -505);
//   $JUNCTION @ATTACH %p1163 => @PLACE(56, -505);
//   $JUNCTION @ATTACH %p1164 => @PLACE(370, -505);
//   $JUNCTION @ATTACH %p1165 => @PLACE(250, -505);
//   $JUNCTION @ATTACH %p1166 => @PLACE(274, -505);
//   $JUNCTION @ATTACH %p1167 => @PLACE(298, -505);
//   $JUNCTION @ATTACH %p1169 => @PLACE(10, -505);
//   $JUNCTION @ATTACH %p1171 => @PLACE(166, -505);
//   $JUNCTION @ATTACH %p1172 => @PLACE(190, -505);
//   $JUNCTION @ATTACH %p1173 => @PLACE(80, -505);
//   $JUNCTION @ATTACH %p1174 => @PLACE(226, -505);
//   $JUNCTION @ATTACH %p1175 => @PLACE(-6, -486);
//   $JUNCTION @ATTACH %p1177 => @PLACE(97, -486);
//   $JUNCTION @ATTACH %p1179 => @PLACE(97, -521);
//   $JUNCTION @ATTACH %p1181 => @PLACE(-18, -521);
//   $JUNCTION @ATTACH %p1184 => @PLACE(348, -404);
//   $JUNCTION @ATTACH %p1187 => @PLACE(372, -404);
//   $JUNCTION @ATTACH %p1191 => @PLACE(107, -276);
//   $JUNCTION @ATTACH %p1192 => @PLACE(205, -276);
//   $JUNCTION @ATTACH %p1193 => @PLACE(252, -264);
//   $JUNCTION @ATTACH %p1196 => @PLACE(215, -276);
//   $JUNCTION @ATTACH %p1198 => @PLACE(14, -288);
//   $JUNCTION @ATTACH %p1199 => @PLACE(304, -288);
//   $JUNCTION @ATTACH %p1200 => @PLACE(328, -288);
//   $JUNCTION @ATTACH %p1201 => @PLACE(352, -288);
//   $JUNCTION @ATTACH %p1202 => @PLACE(196, -288);
//   $JUNCTION @ATTACH %p1203 => @PLACE(232, -288);
//   $JUNCTION @ATTACH %p1204 => @PLACE(256, -288);
//   $JUNCTION @ATTACH %p1205 => @PLACE(280, -288);
//   $JUNCTION @ATTACH %p1206 => @PLACE(172, -288);
//   $JUNCTION @ATTACH %p1207 => @PLACE(62, -288);
//   $JUNCTION @ATTACH %p1208 => @PLACE(86, -288);
//   $JUNCTION @ATTACH %p1210 => @PLACE(376, -288);
//   $JUNCTION @ATTACH %p1211 => @PLACE(400, -288);
//   $JUNCTION @ATTACH %p1212 => @PLACE(148, -288);
//   $JUNCTION @ATTACH %p1213 => @PLACE(124, -288);
//   $JUNCTION @ATTACH %p1214 => @PLACE(38, -288);
//   $JUNCTION @ATTACH %p1215 => @PLACE(276, -264);
//   $JUNCTION @ATTACH %p1218 => @PLACE(142, -260);
//   $JUNCTION @ATTACH %p1219 => @PLACE(226, -260);
//   $JUNCTION @ATTACH %p1220 => @PLACE(56, -260);
//   $JUNCTION @ATTACH %p1221 => @PLACE(10, -260);
//   $JUNCTION @ATTACH %p1222 => @PLACE(32, -260);
//   $JUNCTION @ATTACH %p1223 => @PLACE(80, -260);
//   $JUNCTION @ATTACH %p1224 => @PLACE(118, -260);
//   $JUNCTION @ATTACH %p1225 => @PLACE(346, -260);
//   $JUNCTION @ATTACH %p1226 => @PLACE(370, -260);
//   $JUNCTION @ATTACH %p1227 => @PLACE(166, -260);
//   $JUNCTION @ATTACH %p1228 => @PLACE(190, -260);
//   $JUNCTION @ATTACH %p1229 => @PLACE(322, -260);
//   $JUNCTION @ATTACH %p1230 => @PLACE(298, -260);
//   $JUNCTION @ATTACH %p1232 => @PLACE(250, -260);
//   $JUNCTION @ATTACH %p1233 => @PLACE(274, -260);
//   $JUNCTION @ATTACH %p1237 => @PLACE(86, -647);
//   $JUNCTION @ATTACH %p1239 => @PLACE(14, -297);
//   $JUNCTION @ATTACH %p1242 => @PLACE(34, -264);
//   $JUNCTION @ATTACH %p1245 => @PLACE(324, -614);
//   $JUNCTION @ATTACH %p1248 => @PLACE(14, -673);
//   $JUNCTION @ATTACH %p1249 => @PLACE(124, -673);
//   $JUNCTION @ATTACH %p1250 => @PLACE(148, -673);
//   $JUNCTION @ATTACH %p1251 => @PLACE(304, -673);
//   $JUNCTION @ATTACH %p1252 => @PLACE(328, -673);
//   $JUNCTION @ATTACH %p1253 => @PLACE(232, -673);
//   $JUNCTION @ATTACH %p1254 => @PLACE(38, -673);
//   $JUNCTION @ATTACH %p1255 => @PLACE(172, -673);
//   $JUNCTION @ATTACH %p1256 => @PLACE(196, -673);
//   $JUNCTION @ATTACH %p1257 => @PLACE(376, -673);
//   $JUNCTION @ATTACH %p1258 => @PLACE(86, -673);
//   $JUNCTION @ATTACH %p1259 => @PLACE(62, -673);
//   $JUNCTION @ATTACH %p1260 => @PLACE(400, -673);
//   $JUNCTION @ATTACH %p1261 => @PLACE(256, -673);
//   $JUNCTION @ATTACH %p1262 => @PLACE(280, -673);
//   $JUNCTION @ATTACH %p1263 => @PLACE(352, -673);
//   $JUNCTION @ATTACH %p1265 => @PLACE(228, -614);
//   $JUNCTION @ATTACH %p1268 => @PLACE(38, -647);
//   $JUNCTION @ATTACH %p1271 => @PLACE(58, -614);
//   $JUNCTION @ATTACH %p1273 => @PLACE(62, -647);
//   $JUNCTION @ATTACH %p1278 => @PLACE(120, -474);
//   $JUNCTION @ATTACH %p1279 => @PLACE(10, -645);
//   $JUNCTION @ATTACH %p1280 => @PLACE(166, -645);
//   $JUNCTION @ATTACH %p1281 => @PLACE(142, -645);
//   $JUNCTION @ATTACH %p1283 => @PLACE(56, -645);
//   $JUNCTION @ATTACH %p1284 => @PLACE(80, -645);
//   $JUNCTION @ATTACH %p1285 => @PLACE(298, -645);
//   $JUNCTION @ATTACH %p1286 => @PLACE(32, -645);
//   $JUNCTION @ATTACH %p1287 => @PLACE(226, -645);
//   $JUNCTION @ATTACH %p1288 => @PLACE(250, -645);
//   $JUNCTION @ATTACH %p1289 => @PLACE(322, -645);
//   $JUNCTION @ATTACH %p1290 => @PLACE(346, -645);
//   $JUNCTION @ATTACH %p1291 => @PLACE(118, -645);
//   $JUNCTION @ATTACH %p1292 => @PLACE(370, -645);
//   $JUNCTION @ATTACH %p1293 => @PLACE(274, -645);
//   $JUNCTION @ATTACH %p1294 => @PLACE(190, -645);
//   $JUNCTION @ATTACH %p1297 => @PLACE(328, -577);
//   $JUNCTION @ATTACH %p1300 => @PLACE(324, -264);
//   $JUNCTION @ATTACH %p1304 => @PLACE(348, -264);
//   $JUNCTION @ATTACH %p1306 => @PLACE(304, -577);
//   $JUNCTION @ATTACH %p1308 => @PLACE(205, -591);
//   $JUNCTION @ATTACH %p1311 => @PLACE(107, -591);
//   $JUNCTION @ATTACH %p1313 => @PLACE(148, -577);
//   $JUNCTION @ATTACH %p1315 => @PLACE(228, -264);
//   $JUNCTION @ATTACH %p1318 => @PLACE(86, -577);
//   $JUNCTION @ATTACH %p1321 => @PLACE(58, -264);
//   $JUNCTION @ATTACH %p1325 => @PLACE(300, -614);
//   $JUNCTION @ATTACH %p1327 => @PLACE(124, -577);
//   $JUNCTION @ATTACH %p1331 => @PLACE(192, -614);
//   $JUNCTION @ATTACH %p1335 => @PLACE(196, -507);
//   $JUNCTION @ATTACH %p1337 => @PLACE(82, -614);
//   $JUNCTION @ATTACH %p1339 => @PLACE(205, -521);
//   $JUNCTION @ATTACH %p1342 => @PLACE(107, -521);
//   $JUNCTION @ATTACH %p1344 => @PLACE(252, -474);
//   $JUNCTION @ATTACH %p1346 => @PLACE(215, -486);
//   $JUNCTION @ATTACH %p1348 => @PLACE(276, -474);
//   $JUNCTION @ATTACH %p1351 => @PLACE(148, -507);
//   $JUNCTION @ATTACH %p1355 => @PLACE(-18, -381);
//   $JUNCTION @ATTACH %p1356 => @PLACE(97, -381);
//   $JUNCTION @ATTACH %p1359 => @PLACE(172, -507);
//   $JUNCTION @ATTACH %p1362 => @PLACE(304, -157);
//   $JUNCTION @ATTACH %p1364 => @PLACE(215, -171);
//   $JUNCTION @ATTACH %p1368 => @PLACE(300, -264);
//   $JUNCTION @ATTACH %p1370 => @PLACE(256, -157);
//   $JUNCTION @ATTACH %p1374 => @PLACE(192, -264);
//   $JUNCTION @ATTACH %p1376 => @PLACE(280, -157);
//   $JUNCTION @ATTACH %p1379 => @PLACE(82, -264);
//   $JUNCTION @ATTACH %p1383 => @PLACE(215, -311);
//   $JUNCTION @ATTACH %p1386 => @PLACE(168, -614);
//   $JUNCTION @ATTACH %p1388 => @PLACE(280, -323);
//   $JUNCTION @ATTACH %p1389 => @PLACE(304, -323);
//   $JUNCTION @ATTACH %p1390 => @PLACE(14, -323);
//   $JUNCTION @ATTACH %p1391 => @PLACE(124, -323);
//   $JUNCTION @ATTACH %p1392 => @PLACE(232, -323);
//   $JUNCTION @ATTACH %p1393 => @PLACE(196, -323);
//   $JUNCTION @ATTACH %p1394 => @PLACE(172, -323);
//   $JUNCTION @ATTACH %p1395 => @PLACE(256, -323);
//   $JUNCTION @ATTACH %p1396 => @PLACE(328, -323);
//   $JUNCTION @ATTACH %p1397 => @PLACE(376, -323);
//   $JUNCTION @ATTACH %p1399 => @PLACE(400, -323);
//   $JUNCTION @ATTACH %p1400 => @PLACE(352, -323);
//   $JUNCTION @ATTACH %p1401 => @PLACE(38, -323);
//   $JUNCTION @ATTACH %p1402 => @PLACE(86, -323);
//   $JUNCTION @ATTACH %p1403 => @PLACE(62, -323);
//   $JUNCTION @ATTACH %p1404 => @PLACE(148, -323);
//   $JUNCTION @ATTACH %p1406 => @PLACE(120, -614);
//   $JUNCTION @ATTACH %p1409 => @PLACE(352, -297);
//   $JUNCTION @ATTACH %p1412 => @PLACE(376, -297);
//   $JUNCTION @ATTACH %p1414 => @PLACE(250, -295);
//   $JUNCTION @ATTACH %p1415 => @PLACE(226, -295);
//   $JUNCTION @ATTACH %p1416 => @PLACE(190, -295);
//   $JUNCTION @ATTACH %p1417 => @PLACE(166, -295);
//   $JUNCTION @ATTACH %p1418 => @PLACE(322, -295);
//   $JUNCTION @ATTACH %p1419 => @PLACE(346, -295);
//   $JUNCTION @ATTACH %p1420 => @PLACE(298, -295);
//   $JUNCTION @ATTACH %p1421 => @PLACE(10, -295);
//   $JUNCTION @ATTACH %p1422 => @PLACE(274, -295);
//   $JUNCTION @ATTACH %p1423 => @PLACE(370, -295);
//   $JUNCTION @ATTACH %p1425 => @PLACE(32, -295);
//   $JUNCTION @ATTACH %p1426 => @PLACE(56, -295);
//   $JUNCTION @ATTACH %p1427 => @PLACE(118, -295);
//   $JUNCTION @ATTACH %p1428 => @PLACE(80, -295);
//   $JUNCTION @ATTACH %p1430 => @PLACE(142, -295);
//   $JUNCTION @ATTACH %p1432 => @PLACE(300, -404);
//   $JUNCTION @ATTACH %p1434 => @PLACE(-6, -346);
//   $JUNCTION @ATTACH %p1435 => @PLACE(97, -346);
//   $JUNCTION @ATTACH %p1439 => @PLACE(232, -297);
//   $JUNCTION @ATTACH %p1441 => @PLACE(205, -311);
//   $JUNCTION @ATTACH %p1444 => @PLACE(107, -311);
//   $JUNCTION @ATTACH %p1446 => @PLACE(172, -297);
//   $JUNCTION @ATTACH %p1450 => @PLACE(168, -264);
//   $JUNCTION @ATTACH %p1452 => @PLACE(196, -297);
//   $JUNCTION @ATTACH %p1456 => @PLACE(120, -264);
//   $JUNCTION @ATTACH %p1458 => @PLACE(124, -297);
//   $JUNCTION @ATTACH %p1462 => @PLACE(148, -297);
//   $JUNCTION @ATTACH %p1464 => @PLACE(328, -157);
//   $JUNCTION @ATTACH %p1467 => @PLACE(352, -157);
//   $JUNCTION @ATTACH %p1470 => @PLACE(-18, -591);
//   $JUNCTION @ATTACH %p1472 => @PLACE(97, -591);
//   $JUNCTION @ATTACH %p1473 => @PLACE(328, -297);
//   $JUNCTION @ATTACH %p1477 => @PLACE(304, -297);
//   $JUNCTION @ATTACH %p1480 => @PLACE(300, -474);
//   $JUNCTION @ATTACH %p1482 => @PLACE(324, -474);
//   $JUNCTION @ATTACH %p1485 => @PLACE(396, -474);
//   $JUNCTION @ATTACH %p1491 => @PLACE(256, -297);
//   $JUNCTION @ATTACH %p1495 => @PLACE(280, -297);
//   $JUNCTION @ATTACH %p1496 => @PLACE(62, -577);
//   $JUNCTION @ATTACH %p1500 => @PLACE(205, -346);
//   $JUNCTION @ATTACH %p1502 => @PLACE(107, -346);
//   $JUNCTION @ATTACH %p1503 => @PLACE(168, -334);
//   $JUNCTION @ATTACH %p1506 => @PLACE(192, -334);
//   $JUNCTION @ATTACH %p1510 => @PLACE(376, -157);
//   $JUNCTION @ATTACH %p1517 => @PLACE(86, -367);
//   $JUNCTION @ATTACH %p1520 => @PLACE(62, -367);
//   $JUNCTION @ATTACH %p1522 => @PLACE(38, -437);
//   $JUNCTION @ATTACH %p1526 => @PLACE(38, -577);
//   $JUNCTION @ATTACH %p1529 => @PLACE(328, -507);
//   $JUNCTION @ATTACH %p1531 => @PLACE(215, -136);
//   $JUNCTION @ATTACH %p1535 => @PLACE(107, -136);
//   $JUNCTION @ATTACH %p1536 => @PLACE(205, -136);
//   $JUNCTION @ATTACH %p1537 => @PLACE(168, -124);
//   $JUNCTION @ATTACH %p1540 => @PLACE(86, -148);
//   $JUNCTION @ATTACH %p1541 => @PLACE(352, -148);
//   $JUNCTION @ATTACH %p1542 => @PLACE(376, -148);
//   $JUNCTION @ATTACH %p1543 => @PLACE(232, -148);
//   $JUNCTION @ATTACH %p1544 => @PLACE(256, -148);
//   $JUNCTION @ATTACH %p1545 => @PLACE(280, -148);
//   $JUNCTION @ATTACH %p1546 => @PLACE(124, -148);
//   $JUNCTION @ATTACH %p1547 => @PLACE(14, -148);
//   $JUNCTION @ATTACH %p1548 => @PLACE(38, -148);
//   $JUNCTION @ATTACH %p1549 => @PLACE(400, -148);
//   $JUNCTION @ATTACH %p1550 => @PLACE(62, -148);
//   $JUNCTION @ATTACH %p1551 => @PLACE(304, -148);
//   $JUNCTION @ATTACH %p1553 => @PLACE(328, -148);
//   $JUNCTION @ATTACH %p1554 => @PLACE(148, -148);
//   $JUNCTION @ATTACH %p1555 => @PLACE(196, -148);
//   $JUNCTION @ATTACH %p1556 => @PLACE(172, -148);
//   $JUNCTION @ATTACH %p1558 => @PLACE(192, -124);
//   $JUNCTION @ATTACH %p1560 => @PLACE(370, -120);
//   $JUNCTION @ATTACH %p1561 => @PLACE(346, -120);
//   $JUNCTION @ATTACH %p1562 => @PLACE(142, -120);
//   $JUNCTION @ATTACH %p1563 => @PLACE(80, -120);
//   $JUNCTION @ATTACH %p1564 => @PLACE(32, -120);
//   $JUNCTION @ATTACH %p1566 => @PLACE(190, -120);
//   $JUNCTION @ATTACH %p1567 => @PLACE(226, -120);
//   $JUNCTION @ATTACH %p1568 => @PLACE(56, -120);
//   $JUNCTION @ATTACH %p1570 => @PLACE(10, -120);
//   $JUNCTION @ATTACH %p1571 => @PLACE(298, -120);
//   $JUNCTION @ATTACH %p1572 => @PLACE(166, -120);
//   $JUNCTION @ATTACH %p1573 => @PLACE(322, -120);
//   $JUNCTION @ATTACH %p1574 => @PLACE(250, -120);
//   $JUNCTION @ATTACH %p1575 => @PLACE(274, -120);
//   $JUNCTION @ATTACH %p1576 => @PLACE(118, -120);
//   $JUNCTION @ATTACH %p1578 => @PLACE(304, -507);
//   $JUNCTION @ATTACH %p1580 => @PLACE(97, -171);
//   $JUNCTION @ATTACH %p1581 => @PLACE(-18, -171);
//   $JUNCTION @ATTACH %p1585 => @PLACE(124, -227);
//   $JUNCTION @ATTACH %p1588 => @PLACE(62, -227);
//   $JUNCTION @ATTACH %p1592 => @PLACE(82, -544);
//   $JUNCTION @ATTACH %p1593 => @PLACE(-6, -556);
//   $JUNCTION @ATTACH %p1595 => @PLACE(97, -556);
//   $JUNCTION @ATTACH %p1597 => @PLACE(120, -544);
//   $JUNCTION @ATTACH %p1600 => @PLACE(86, -227);
//   $JUNCTION @ATTACH %p1605 => @PLACE(348, -474);
//   $JUNCTION @ATTACH %p1607 => @PLACE(14, -577);
//   $JUNCTION @ATTACH %p1609 => @PLACE(396, -334);
//   $JUNCTION @ATTACH %p1615 => @PLACE(38, -227);
//   $JUNCTION @ATTACH %p1618 => @PLACE(144, -334);
//   $JUNCTION @ATTACH %p1622 => @PLACE(300, -124);
//   $JUNCTION @ATTACH %p1624 => @PLACE(324, -124);
//   $JUNCTION @ATTACH %p1626 => @PLACE(396, -124);
//   $JUNCTION @ATTACH %p1630 => @PLACE(124, -367);
//   $JUNCTION @ATTACH %p1633 => @PLACE(144, -124);
//   $JUNCTION @ATTACH %p1637 => @PLACE(252, -124);
//   $JUNCTION @ATTACH %p1638 => @PLACE(276, -124);
//   $JUNCTION @ATTACH %p1641 => @PLACE(280, -437);
//   $JUNCTION @ATTACH %p1644 => @PLACE(58, -544);
//   $JUNCTION @ATTACH %p1647 => @PLACE(215, -451);
//   $JUNCTION @ATTACH %p1652 => @PLACE(372, -474);
//   $JUNCTION @ATTACH %p1654 => @PLACE(232, -437);
//   $JUNCTION @ATTACH %p1658 => @PLACE(372, -334);
//   $JUNCTION @ATTACH %p1660 => @PLACE(256, -437);
//   $JUNCTION @ATTACH %p1664 => @PLACE(352, -507);
//   $JUNCTION @ATTACH %p1667 => @PLACE(38, -87);
//   $JUNCTION @ATTACH %p1670 => @PLACE(86, -87);
//   $JUNCTION @ATTACH %p1672 => @PLACE(205, -241);
//   $JUNCTION @ATTACH %p1674 => @PLACE(107, -241);
//   $JUNCTION @ATTACH %p1676 => @PLACE(372, -124);
//   $JUNCTION @ATTACH %p1680 => @PLACE(172, -227);
//   $JUNCTION @ATTACH %p1684 => @PLACE(196, -227);
//   $JUNCTION @ATTACH %p1688 => @PLACE(120, -124);
//   $JUNCTION @ATTACH %p1692 => @PLACE(228, -124);
//   $JUNCTION @ATTACH %p1695 => @PLACE(352, -437);
//   $JUNCTION @ATTACH %p1699 => @PLACE(348, -544);
//   $JUNCTION @ATTACH %p1702 => @PLACE(372, -544);
//   $JUNCTION @ATTACH %p1704 => @PLACE(376, -437);
//   $JUNCTION @ATTACH %p1708 => @PLACE(304, -437);
//   $JUNCTION @ATTACH %p1710 => @PLACE(205, -556);
//   $JUNCTION @ATTACH %p1713 => @PLACE(107, -556);
//   $JUNCTION @ATTACH %p1715 => @PLACE(252, -544);
//   $JUNCTION @ATTACH %p1718 => @PLACE(276, -544);
//   $JUNCTION @ATTACH %p1721 => @PLACE(196, -437);
//   $JUNCTION @ATTACH %p1723 => @PLACE(376, -647);
//   $JUNCTION @ATTACH %p1727 => @PLACE(348, -334);
//   $JUNCTION @ATTACH %p1729 => @PLACE(215, -661);
//   $JUNCTION @ATTACH %p1731 => @PLACE(348, -194);
//   $JUNCTION @ATTACH %p1735 => @PLACE(328, -647);
//   $JUNCTION @ATTACH %p1738 => @PLACE(352, -647);
//   $JUNCTION @ATTACH %p1740 => @PLACE(252, -194);
//   $JUNCTION @ATTACH %p1744 => @PLACE(276, -194);
//   $JUNCTION @ATTACH %p1747 => @PLACE(232, -647);
//   $JUNCTION @ATTACH %p1749 => @PLACE(205, -661);
//   $JUNCTION @ATTACH %p1751 => @PLACE(107, -661);
//   $JUNCTION @ATTACH %p1755 => @PLACE(172, -647);
//   $JUNCTION @ATTACH %p1758 => @PLACE(256, -17);
//   $JUNCTION @ATTACH %p1760 => @PLACE(196, -647);
//   $JUNCTION @ATTACH %p1762 => @PLACE(324, -54);
//   $JUNCTION @ATTACH %p1765 => @PLACE(215, -66);
//   $JUNCTION @ATTACH %p1767 => @PLACE(400, -78);
//   $JUNCTION @ATTACH %p1768 => @PLACE(376, -78);
//   $JUNCTION @ATTACH %p1769 => @PLACE(232, -78);
//   $JUNCTION @ATTACH %p1770 => @PLACE(124, -78);
//   $JUNCTION @ATTACH %p1771 => @PLACE(148, -78);
//   $JUNCTION @ATTACH %p1772 => @PLACE(256, -78);
//   $JUNCTION @ATTACH %p1773 => @PLACE(280, -78);
//   $JUNCTION @ATTACH %p1774 => @PLACE(352, -78);
//   $JUNCTION @ATTACH %p1776 => @PLACE(14, -78);
//   $JUNCTION @ATTACH %p1777 => @PLACE(38, -78);
//   $JUNCTION @ATTACH %p1778 => @PLACE(328, -78);
//   $JUNCTION @ATTACH %p1779 => @PLACE(304, -78);
//   $JUNCTION @ATTACH %p1780 => @PLACE(196, -78);
//   $JUNCTION @ATTACH %p1781 => @PLACE(86, -78);
//   $JUNCTION @ATTACH %p1782 => @PLACE(62, -78);
//   $JUNCTION @ATTACH %p1783 => @PLACE(172, -78);
//   $JUNCTION @ATTACH %p1785 => @PLACE(348, -54);
//   $JUNCTION @ATTACH %p1787 => @PLACE(298, -50);
//   $JUNCTION @ATTACH %p1788 => @PLACE(142, -50);
//   $JUNCTION @ATTACH %p1789 => @PLACE(166, -50);
//   $JUNCTION @ATTACH %p1790 => @PLACE(274, -50);
//   $JUNCTION @ATTACH %p1791 => @PLACE(190, -50);
//   $JUNCTION @ATTACH %p1793 => @PLACE(80, -50);
//   $JUNCTION @ATTACH %p1794 => @PLACE(118, -50);
//   $JUNCTION @ATTACH %p1795 => @PLACE(32, -50);
//   $JUNCTION @ATTACH %p1796 => @PLACE(226, -50);
//   $JUNCTION @ATTACH %p1797 => @PLACE(56, -50);
//   $JUNCTION @ATTACH %p1798 => @PLACE(250, -50);
//   $JUNCTION @ATTACH %p1799 => @PLACE(322, -50);
//   $JUNCTION @ATTACH %p1800 => @PLACE(346, -50);
//   $JUNCTION @ATTACH %p1801 => @PLACE(10, -50);
//   $JUNCTION @ATTACH %p1802 => @PLACE(370, -50);
//   $JUNCTION @ATTACH %p1804 => @PLACE(372, -54);
//   $JUNCTION @ATTACH %p1807 => @PLACE(396, -54);
//   $JUNCTION @ATTACH %p1810 => @PLACE(97, -101);
//   $JUNCTION @ATTACH %p1813 => @PLACE(-18, -101);
//   $JUNCTION @ATTACH %p1815 => @PLACE(148, -227);
//   $JUNCTION @ATTACH %p1818 => @PLACE(328, -437);
//   $JUNCTION @ATTACH %p1824 => @PLACE(304, -647);
//   $JUNCTION @ATTACH %p1826 => @PLACE(256, -647);
//   $JUNCTION @ATTACH %p1829 => @PLACE(-6, -66);
//   $JUNCTION @ATTACH %p1830 => @PLACE(97, -66);
//   $JUNCTION @ATTACH %p1834 => @PLACE(34, -54);
//   $JUNCTION @ATTACH %p1836 => @PLACE(58, -54);
//   $JUNCTION @ATTACH %p1839 => @PLACE(82, -54);
//   $JUNCTION @ATTACH %p1842 => @PLACE(120, -54);
//   $JUNCTION @ATTACH %p1845 => @PLACE(280, -647);
//   $JUNCTION @ATTACH %p1848 => @PLACE(124, -507);
//   $JUNCTION @ATTACH %p1851 => @PLACE(62, -507);
//   $JUNCTION @ATTACH %p1854 => @PLACE(86, -507);
//   $JUNCTION @ATTACH %p1856 => @PLACE(205, -451);
//   $JUNCTION @ATTACH %p1859 => @PLACE(107, -451);
//   $JUNCTION @ATTACH %p1861 => @PLACE(148, -437);
//   $JUNCTION @ATTACH %p1863 => @PLACE(172, -437);
//   $JUNCTION @ATTACH %p1866 => @PLACE(300, -54);
//   $JUNCTION @ATTACH %p1870 => @PLACE(276, -54);
//   $JUNCTION @ATTACH %p1876 => @PLACE(376, -227);
//   $JUNCTION @ATTACH %p1880 => @PLACE(14, -157);
//   $JUNCTION @ATTACH %p1882 => @PLACE(-6, -136);
//   $JUNCTION @ATTACH %p1885 => @PLACE(97, -136);
//   $JUNCTION @ATTACH %p1888 => @PLACE(34, -124);
//   $JUNCTION @ATTACH %p1890 => @PLACE(58, -124);
//   $JUNCTION @ATTACH %p1894 => @PLACE(82, -124);
//   $JUNCTION @ATTACH %p1896 => @PLACE(38, -507);
//   $JUNCTION @ATTACH %p1900 => @PLACE(34, -544);
//   $JUNCTION @ATTACH %p1904 => @PLACE(376, -577);
//   $JUNCTION @ATTACH %p1909 => @PLACE(232, -17);
//   $JUNCTION @ATTACH %p1911 => @PLACE(228, -334);
//   $JUNCTION @ATTACH %p1914 => @PLACE(58, -334);
//   $JUNCTION @ATTACH %p1918 => @PLACE(82, -334);
//   $JUNCTION @ATTACH %p1922 => @PLACE(172, -577);
//   $JUNCTION @ATTACH %p1925 => @PLACE(62, -297);
//   $JUNCTION @ATTACH %p1929 => @PLACE(86, -297);
//   $JUNCTION @ATTACH %p1932 => @PLACE(256, -367);
//   $JUNCTION @ATTACH %p1933 => @PLACE(252, -54);
//   $JUNCTION @ATTACH %p1937 => @PLACE(228, -54);
//   $JUNCTION @ATTACH %p1939 => @PLACE(192, -54);
//   $JUNCTION @ATTACH %p1942 => @PLACE(205, -66);
//   $JUNCTION @ATTACH %p1944 => @PLACE(107, -66);
//   $JUNCTION @ATTACH %p1946 => @PLACE(168, -54);
//   $JUNCTION @ATTACH %p1949 => @PLACE(144, -54);
//   $JUNCTION @ATTACH %p1953 => @PLACE(280, -17);
//   $JUNCTION @ATTACH %p1955 => @PLACE(280, -367);
//   $JUNCTION @ATTACH %p1959 => @PLACE(148, -367);
//   $JUNCTION @ATTACH %p1962 => @PLACE(124, -647);
//   $JUNCTION @ATTACH %p1964 => @PLACE(38, -717);
//   $JUNCTION @ATTACH %p1968 => @PLACE(14, -743);
//   $JUNCTION @ATTACH %p1969 => @PLACE(400, -743);
//   $JUNCTION @ATTACH %p1970 => @PLACE(232, -743);
//   $JUNCTION @ATTACH %p1971 => @PLACE(256, -743);
//   $JUNCTION @ATTACH %p1972 => @PLACE(38, -743);
//   $JUNCTION @ATTACH %p1973 => @PLACE(148, -743);
//   $JUNCTION @ATTACH %p1974 => @PLACE(172, -743);
//   $JUNCTION @ATTACH %p1975 => @PLACE(280, -743);
//   $JUNCTION @ATTACH %p1976 => @PLACE(196, -743);
//   $JUNCTION @ATTACH %p1977 => @PLACE(124, -743);
//   $JUNCTION @ATTACH %p1978 => @PLACE(86, -743);
//   $JUNCTION @ATTACH %p1979 => @PLACE(328, -743);
//   $JUNCTION @ATTACH %p1980 => @PLACE(352, -743);
//   $JUNCTION @ATTACH %p1981 => @PLACE(304, -743);
//   $JUNCTION @ATTACH %p1982 => @PLACE(376, -743);
//   $JUNCTION @ATTACH %p1983 => @PLACE(62, -743);
//   $JUNCTION @ATTACH %p1984 => @PLACE(226, -715);
//   $JUNCTION @ATTACH %p1985 => @PLACE(166, -715);
//   $JUNCTION @ATTACH %p1986 => @PLACE(190, -715);
//   $JUNCTION @ATTACH %p1987 => @PLACE(322, -715);
//   $JUNCTION @ATTACH %p1988 => @PLACE(346, -715);
//   $JUNCTION @ATTACH %p1989 => @PLACE(118, -715);
//   $JUNCTION @ATTACH %p1990 => @PLACE(142, -715);
//   $JUNCTION @ATTACH %p1991 => @PLACE(10, -715);
//   $JUNCTION @ATTACH %p1992 => @PLACE(32, -715);
//   $JUNCTION @ATTACH %p1994 => @PLACE(370, -715);
//   $JUNCTION @ATTACH %p1995 => @PLACE(274, -715);
//   $JUNCTION @ATTACH %p1996 => @PLACE(298, -715);
//   $JUNCTION @ATTACH %p1997 => @PLACE(250, -715);
//   $JUNCTION @ATTACH %p1999 => @PLACE(80, -715);
//   $JUNCTION @ATTACH %p2000 => @PLACE(56, -715);
//   $JUNCTION @ATTACH %p2002 => @PLACE(62, -717);
//   $JUNCTION @ATTACH %p2005 => @PLACE(86, -717);
//   $JUNCTION @ATTACH %p2009 => @PLACE(62, -87);
//   $JUNCTION @ATTACH %p2010 => @PLACE(252, -334);
//   $JUNCTION @ATTACH %p2013 => @PLACE(276, -334);
//   $JUNCTION @ATTACH %p2017 => @PLACE(144, -544);
//   $JUNCTION @ATTACH %p2020 => @PLACE(168, -544);
//   $JUNCTION @ATTACH %p2024 => @PLACE(280, -717);
//   $JUNCTION @ATTACH %p2026 => @PLACE(215, -731);
//   $JUNCTION @ATTACH %p2028 => @PLACE(396, -544);
//   $JUNCTION @ATTACH %p2034 => @PLACE(232, -717);
//   $JUNCTION @ATTACH %p2035 => @PLACE(396, -404);
//   $JUNCTION @ATTACH %p2039 => @PLACE(396, -264);
//   $JUNCTION @ATTACH %p2042 => @PLACE(422, 27);
//   $JUNCTION @ATTACH %p2044 => @PLACE(422, -8);
//   $JUNCTION @ATTACH %p2045 => @PLACE(422, -743);
//   $JUNCTION @ATTACH %p2046 => @PLACE(422, -43);
//   $JUNCTION @ATTACH %p2047 => @PLACE(422, -78);
//   $JUNCTION @ATTACH %p2048 => @PLACE(422, -148);
//   $JUNCTION @ATTACH %p2049 => @PLACE(422, -113);
//   $JUNCTION @ATTACH %p2050 => @PLACE(422, -218);
//   $JUNCTION @ATTACH %p2051 => @PLACE(422, -183);
//   $JUNCTION @ATTACH %p2052 => @PLACE(422, -288);
//   $JUNCTION @ATTACH %p2053 => @PLACE(422, -253);
//   $JUNCTION @ATTACH %p2054 => @PLACE(422, -358);
//   $JUNCTION @ATTACH %p2055 => @PLACE(422, -323);
//   $JUNCTION @ATTACH %p2056 => @PLACE(422, -428);
//   $JUNCTION @ATTACH %p2057 => @PLACE(422, -393);
//   $JUNCTION @ATTACH %p2058 => @PLACE(422, -498);
//   $JUNCTION @ATTACH %p2059 => @PLACE(422, -463);
//   $JUNCTION @ATTACH %p2060 => @PLACE(422, -568);
//   $JUNCTION @ATTACH %p2061 => @PLACE(422, -533);
//   $JUNCTION @ATTACH %p2062 => @PLACE(422, -638);
//   $JUNCTION @ATTACH %p2063 => @PLACE(422, -603);
//   $JUNCTION @ATTACH %p2064 => @PLACE(422, -708);
//   $JUNCTION @ATTACH %p2065 => @PLACE(422, -673);
//   $JUNCTION @ATTACH %p2066 => @PLACE(422, -732);
//   $JUNCTION @ATTACH %p2067 => @PLACE(348, -124);
//   $JUNCTION @ATTACH %p2070 => @PLACE(120, -334);
//   $JUNCTION @ATTACH %p2074 => @PLACE(256, -717);
//   $JUNCTION @ATTACH %p2078 => @PLACE(196, -717);
//   $JUNCTION @ATTACH %p2079 => @PLACE(168, -194);
//   $JUNCTION @ATTACH %p2082 => @PLACE(205, -731);
//   $JUNCTION @ATTACH %p2085 => @PLACE(107, -731);
//   $JUNCTION @ATTACH %p2086 => @PLACE(14, -507);
//   $JUNCTION @ATTACH %p2089 => @PLACE(58, -474);
//   $JUNCTION @ATTACH %p2092 => @PLACE(82, -474);
//   $JUNCTION @ATTACH %p2096 => @PLACE(172, -717);
//   $JUNCTION @ATTACH %p2099 => @PLACE(148, -647);
//   $JUNCTION @ATTACH %p2101 => @PLACE(192, -474);
//   $JUNCTION @ATTACH %p2105 => @PLACE(228, -474);
//   $JUNCTION @ATTACH %p2108 => @PLACE(86, -17);
//   $JUNCTION @ATTACH %p2110 => @PLACE(148, -717);
//   $JUNCTION @ATTACH %p2114 => @PLACE(58, -404);
//   $JUNCTION @ATTACH %p2118 => @PLACE(124, -717);
//   $JUNCTION @ATTACH %p2120 => @PLACE(228, -404);
//   $JUNCTION @ATTACH %p2122 => @PLACE(376, -717);
//   $JUNCTION @ATTACH %p2127 => @PLACE(192, -544);
//   $JUNCTION @ATTACH %p2131 => @PLACE(144, -614);
//   $JUNCTION @ATTACH %p2134 => @PLACE(352, -717);
//   $JUNCTION @ATTACH %p2137 => @PLACE(328, -717);
//   $JUNCTION @ATTACH %p2140 => @PLACE(304, -717);
//   $JUNCTION @ATTACH %p2143 => @PLACE(168, -404);
//   $JUNCTION @ATTACH %p2146 => @PLACE(328, -227);
//   $JUNCTION @ATTACH %p2149 => @PLACE(324, -404);
//   $JUNCTION @ATTACH %p2152 => @PLACE(372, -264);
//   $JUNCTION @ATTACH %p2155 => @PLACE(192, -404);
//   $JUNCTION @ATTACH %p2158 => @PLACE(144, -194);
//   $JUNCTION @ATTACH %p2160 => @PLACE(82, -404);
//   $JUNCTION @ATTACH %p2164 => @PLACE(352, -227);
//   $JUNCTION @ATTACH %p2167 => @PLACE(34, -474);
//   $JUNCTION @ATTACH %p2170 => @PLACE(144, -684);
//   $JUNCTION @ATTACH %p2173 => @PLACE(124, -17);
//   $JUNCTION @ATTACH %p2177 => @PLACE(172, -157);
//   $JUNCTION @ATTACH %p2178 => @PLACE(34, -334);
//   $JUNCTION @ATTACH %p2183 => @PLACE(148, -157);
//   $JUNCTION @ATTACH %p2185 => @PLACE(396, -614);
//   $JUNCTION @ATTACH %p2188 => @PLACE(144, -264);
//   $JUNCTION @ATTACH %p2191 => @PLACE(352, -577);
//   $JUNCTION @ATTACH %p2195 => @PLACE(228, -544);
//   $JUNCTION @ATTACH %p2197 => @PLACE(38, -297);
//   $JUNCTION @ATTACH %p2200 => @PLACE(120, -404);
//   $JUNCTION @ATTACH %p2203 => @PLACE(304, -227);
//   $JUNCTION @ATTACH %p2208 => @PLACE(196, -157);
//   $JUNCTION @ATTACH %p2210 => @PLACE(144, -404);
//   $JUNCTION @ATTACH %p2214 => @PLACE(232, -157);
//   $JUNCTION @ATTACH %p2219 => @PLACE(82, -194);
//   $JUNCTION @ATTACH %p2224 => @PLACE(396, -194);
//   $JUNCTION @ATTACH %p2875 => @PLACE(14, -717);
//   $JUNCTION @ATTACH %p2884 => @PLACE(419, -719);
//   $JUNCTION @ATTACH %p2886 => @PLACE(215, -206);
//   $JUNCTION @ATTACH %p2889 => @PLACE(376, -367);
//   $JUNCTION @ATTACH %p2893 => @PLACE(372, -194);
//   $JUNCTION @ATTACH %p2896 => @PLACE(376, -507);
//   $JUNCTION @ATTACH %p2903 => @PLACE(402, -763);
//   $JUNCTION @ATTACH %p2905 => @PLACE(64, -763);
//   $JUNCTION @ATTACH %p2906 => @PLACE(88, -763);
//   $JUNCTION @ATTACH %p2907 => @PLACE(126, -763);
//   $JUNCTION @ATTACH %p2908 => @PLACE(234, -763);
//   $JUNCTION @ATTACH %p2909 => @PLACE(258, -763);
//   $JUNCTION @ATTACH %p2910 => @PLACE(330, -763);
//   $JUNCTION @ATTACH %p2911 => @PLACE(306, -763);
//   $JUNCTION @ATTACH %p2912 => @PLACE(378, -763);
//   $JUNCTION @ATTACH %p2913 => @PLACE(354, -763);
//   $JUNCTION @ATTACH %p2914 => @PLACE(282, -763);
//   $JUNCTION @ATTACH %p2915 => @PLACE(198, -763);
//   $JUNCTION @ATTACH %p2916 => @PLACE(174, -763);
//   $JUNCTION @ATTACH %p2917 => @PLACE(150, -763);
//   $JUNCTION @ATTACH %p2919 => @PLACE(120, -194);
//   $JUNCTION @ATTACH %p2922 => @PLACE(124, -218);
//   $JUNCTION @ATTACH %p2923 => @PLACE(148, -218);
//   $JUNCTION @ATTACH %p2924 => @PLACE(14, -218);
//   $JUNCTION @ATTACH %p2925 => @PLACE(38, -218);
//   $JUNCTION @ATTACH %p2926 => @PLACE(62, -218);
//   $JUNCTION @ATTACH %p2927 => @PLACE(86, -218);
//   $JUNCTION @ATTACH %p2928 => @PLACE(256, -218);
//   $JUNCTION @ATTACH %p2929 => @PLACE(280, -218);
//   $JUNCTION @ATTACH %p2930 => @PLACE(304, -218);
//   $JUNCTION @ATTACH %p2931 => @PLACE(328, -218);
//   $JUNCTION @ATTACH %p2932 => @PLACE(232, -218);
//   $JUNCTION @ATTACH %p2933 => @PLACE(172, -218);
//   $JUNCTION @ATTACH %p2934 => @PLACE(196, -218);
//   $JUNCTION @ATTACH %p2935 => @PLACE(352, -218);
//   $JUNCTION @ATTACH %p2936 => @PLACE(400, -218);
//   $JUNCTION @ATTACH %p2937 => @PLACE(376, -218);
//   $JUNCTION @ATTACH %p2939 => @PLACE(226, -190);
//   $JUNCTION @ATTACH %p2940 => @PLACE(250, -190);
//   $JUNCTION @ATTACH %p2941 => @PLACE(298, -190);
//   $JUNCTION @ATTACH %p2942 => @PLACE(56, -190);
//   $JUNCTION @ATTACH %p2943 => @PLACE(80, -190);
//   $JUNCTION @ATTACH %p2944 => @PLACE(32, -190);
//   $JUNCTION @ATTACH %p2945 => @PLACE(274, -190);
//   $JUNCTION @ATTACH %p2946 => @PLACE(10, -190);
//   $JUNCTION @ATTACH %p2947 => @PLACE(370, -190);
//   $JUNCTION @ATTACH %p2950 => @PLACE(118, -190);
//   $JUNCTION @ATTACH %p2951 => @PLACE(322, -190);
//   $JUNCTION @ATTACH %p2952 => @PLACE(346, -190);
//   $JUNCTION @ATTACH %p2953 => @PLACE(142, -190);
//   $JUNCTION @ATTACH %p2954 => @PLACE(190, -190);
//   $JUNCTION @ATTACH %p2955 => @PLACE(166, -190);
//   $JUNCTION @ATTACH %p2958 => @PLACE(-6, -206);
//   $JUNCTION @ATTACH %p2959 => @PLACE(97, -206);
//   @LINE {(407, -97) (410, -100)};
//   @LINE {(418, -97) (407, -97) (410, -94)};
//   @LINE {(407, -377) (410, -380)};
//   @LINE {(418, -307) (407, -307) (410, -304)};
//   @LINE {(407, 9) (418, 9) (415, 12)};
//   @LINE {(418, -657) (407, -657) (410, -654)};
//   @LINE {(407, -657) (410, -660)};
//   @LINE {(418, -551) (415, -554)};
//   @LINE {(418, -447) (407, -447) (410, -444)};
//   @LINE {(407, -341) (418, -341) (415, -338)};
//   @LINE {(418, 79) (415, 76)};
//   @LINE {(418, -727) (407, -727) (410, -724)};
//   @LINE {(407, -271) (418, -271) (415, -268)};
//   @LINE {(407, -447) (410, -450)};
//   @LINE {(407, -307) (410, -310)};
//   @LINE {(418, -587) (407, -587) (410, -584)};
//   @LINE {(407, -411) (418, -411) (415, -408)};
//   @LINE {(418, -377) (407, -377) (410, -374)};
//   @LINE {(407, 79) (418, 79) (415, 82)};
//   @LINE {(407, -61) (418, -61) (415, -58)};
//   @LINE {(418, -131) (415, -134)};
//   @LINE {(407, -727) (410, -730)};
//   @LINE {(418, -341) (415, -344)};
//   @LINE {(407, -131) (418, -131) (415, -128)};
//   @LINE {(418, -481) (415, -484)};
//   @LINE {(407, -551) (418, -551) (415, -548)};
//   @LINE {(418, -271) (415, -274)};
//   @LINE {(418, -201) (415, -204)};
//   @LINE {(407, -201) (418, -201) (415, -198)};
//   @LINE {(407, -517) (410, -520)};
//   @LINE {(418, -517) (407, -517) (410, -514)};
//   @LINE {(407, 43) (410, 40)};
//   @LINE {(418, -27) (407, -27) (410, -24)};
//   @LINE {(418, 9) (415, 6)};
//   @LINE {(407, -27) (410, -30)};
//   @LINE {(418, -61) (415, -64)};
//   @LINE {(407, -587) (410, -590)};
//   @LINE {(418, -411) (415, -414)};
//   @LINE {(407, -481) (418, -481) (415, -478)};
//   @LINE {(407, -621) (418, -621) (415, -618)};
//   @LINE {(418, -621) (415, -624)};
//   @LINE {(418, -237) (407, -237) (410, -234)};
//   @LINE {(407, -237) (410, -240)};
//   @LINE {(407, -691) (418, -691) (415, -688)};
//   @LINE {(418, -691) (415, -694)};
//   @LINE {(418, 43) (407, 43) (410, 46)};
//   @LINE {(418, -167) (407, -167) (410, -164)};
//   @LINE {(407, -167) (410, -170)}
// }
// @RNL(author="gemini-4-argon") {
//   @USE-PACKAGE(name="risca-semantics", version="0.3", path="risca_semantics.rnl");
//   /* L3_clk_mux_V1: 16x24 SPI-Programmable Dynamic Crossbar Clock Synthesizer (384 LB_crossbar_cell Matrix) */
//   {#"I1260" #"I1215" #"I1220" #"I1218" #"I1213" #"I1210" #"I1205" #"I1207" #"I1212" #"I1199" #"I1204" #"I1202" #"I1197" #"I1195" #"I1193" #"I1191" #"I1189"}(frame_row_gates) {#"I1637" #"I1621" #"I1622" #"I1623" #"I1635" #"I1624" #"I1625" #"I1626" #"I1627" #"I1628" #"I1629" #"I1630" #"I1631" #"I1632" #"I1633" #"I1634"}(repet_row_gates) {#"I415" #"I879" #"I903" #"I1569" #"I1607"}(crossbar_384_cells) {#"I1535" #"I1538" #"I1537" #"I1487" #"I1490" #"I1489" #"I1552" #"I1551" #"I1550"}(column_eval_and_shapers) @AS(role="16x24_SPI_programmable_frame_to_clock_crossbar") $CROSSBAR_MATRIX_ARRAY;
//   /* Representative 50ps Rising-Edge De-Glitch Pulse Shapers on Output Columns OUT_0, OUT_12, OUT_23 */
//   #"I1535"(delay_50ps) #"I1538"(nor_gate) #"I1537"(out_buffer) @AS(role="OUT0_50ps_deglitch_pulse_shaper") $DEGLITCH_PULSE_SHAPER;
//   #"I1487"(delay_50ps) #"I1490"(nor_gate) #"I1489"(out_buffer) @AS(role="OUT12_50ps_deglitch_pulse_shaper") $DEGLITCH_PULSE_SHAPER;
//   #"I1552"(delay_50ps) #"I1551"(nor_gate) #"I1550"(out_buffer) @AS(role="OUT23_50ps_deglitch_pulse_shaper") $DEGLITCH_PULSE_SHAPER;
//   {#"I1215" #"I1220" #"I1218" #"I1213" #"I1210" #"I1205" #"I1207" #"I1212" #"I1199" #"I1204" #"I1202" #"I1197" #"I1195" #"I1193" #"I1191" #"I1189"}(members) @AS $MATCHED;
//   {#"I1535" #"I1538" #"I1537"}(path) @AS $SIGNAL_FLOW; {#I1535 #I1538 #I1537} @ORDER("left-to-right", priority="low");
//   /* rnl upgrade: BRANCH adds SERIES routing/topology and a low-priority top-to-bottom ORDER; the old definition only aligned x (16.3) */
// {#"I1260" #"I1215" #"I1220" #"I1218" #"I1213" #"I1210" #"I1205" #"I1207" #"I1212" #"I1199" #"I1204" #"I1202" #"I1197" #"I1195" #"I1193" #"I1191" #"I1189"} @ALIGN("x", priority="low");
//   /* rnl upgrade: BRANCH adds SERIES routing/topology and a low-priority top-to-bottom ORDER; the old definition only aligned x (16.3) */
// {#"I1637" #"I1621" #"I1622" #"I1623" #"I1635" #"I1624" #"I1625" #"I1626" #"I1627" #"I1628" #"I1629" #"I1630" #"I1631" #"I1632" #"I1633" #"I1634"} @ALIGN("x", priority="low");
//   /* Note Box & Author Header (Placed in Empty Region Above Schematic) */
//   (-130, 185.12) @TEXT("Comment by Gemini-4-Argon", size=4.2) => @SET-STYLE $risca_author_style;
//   @RECTANGLE {(-130, 142.05) (259.79, 180.86)} => @SET-STYLE $risca_note_box;
//   (-124, 170.64) @TEXT("L3_clk_mux_V1: 16-Phase x 24-Operation SPI-Programmable Crossbar Clock Synthesizer (384 LB_crossbar_cell + 25 Extra DFFs = 409 SPI Bits)", size=4.5) => @SET-STYLE $risca_title_style;
//   (-124, 163.14) @TEXT("1. Row Gating: 16 CKAN2D4 gates enable FRAME<15:0> via channel-enable DFF I1260 (net69); 15 CKAN2D4 gates mask REPET<17:1> during RST=1.", size=3.8) => @SET-STYLE $risca_digital_style;
//   (-124, 155.64) @TEXT("2. 24 Dynamic Evaluation Columns: Each column ORs selected FRAME<15:0> phases onto dynamic row wire, with repetition precharge/hold controlled by REPET_4 & REPET_9.", size=3.8) => @SET-STYLE $risca_digital_style;
//   (-124, 148.14) @TEXT("3. 50ps De-Glitch Pulse Shapers: Each column output passes through DEL050D1 + NR2D1 + BUFFD4 to suppress <50ps crossbar transition glitches before driving OUT<23:0>.", size=3.8) => @SET-STYLE $risca_digital_style
// }
ends L3_clk_mux_V1
