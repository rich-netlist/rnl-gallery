// Telescopic cascode OTA with a cascode mirror load, single-ended, and its testbench
// An NMOS input pair with NMOS cascodes, loaded by a PMOS cascode current mirror; three bias sources set the cascodes
// and the load. The top level is an open-loop testbench.
// @RNL(type="header") { @USE-PACKAGE(name="rnl-std-all", version="0.4"); @VERSION("0.4") }
simulator lang=spectre

model nch mos1 type=n vto=0.5 kp=200u lambda=0.1
model pch mos1 type=p vto=-0.5 kp=80u lambda=0.1

subckt telescopic inp inn out vdd vss vbn vbp vbt
M1 (xa inp tail vss) nch w=10u l=0.5u
M2 (xb inn tail vss) nch w=10u l=0.5u
M3 (outn vbn xa vss) nch w=10u l=0.5u
M4 (out vbn xb vss) nch w=10u l=0.5u
M5 (outn vbp ya vdd) pch w=20u l=0.5u
M6 (out vbp yb vdd) pch w=20u l=0.5u
M7 (ya outn vdd vdd) pch w=20u l=1u
M8 (yb outn vdd vdd) pch w=20u l=1u
M9 (tail vbt vss vss) nch w=20u l=1u
// @RNL {
//   &vdd @ADD-TO $SUPPLY_NET_SET;
//   &vss @ADD-TO $GROUND_NET_SET;
//   {&vbn &vbp &vbt} @ADD-TO $BIAS_NET_SET;
//   $IO_PORT @ATTACH &inp => %p_inp;
//   $IO_PORT @ATTACH &inn => %p_inn;
//   $IO_PORT @ATTACH &out => %p_out;
//
//   %routed_nets = # @SELECT-NET;
//   %routed_nets @ROUTE-NET;
//
//   /* the static currents (15.2), for the solver to draw them downwards; not criteria */
//   {#M1:d #M2:d #M3:d #M4:d #M9:d #M5:s #M6:s #M7:s #M8:s} @CURRENT("in");
//   {#M1:s #M2:s #M3:s #M4:s #M9:s #M5:d #M6:d #M7:d #M8:d} @CURRENT("out");
//
//   /* what the circuit is: an NMOS pair M1/M2 with NMOS cascodes M3/M4, loaded by a PMOS cascode current mirror M5-M8;
//      the gate pins of the cascodes face the center */
//   %dp = #M1(left) #M2(right) #M9(tail) @AS $DIFFERENTIAL_PAIR_N;
//   %cas_l = #M1(source) #M3(cascode) @AS $CASCODE;
//   %nmos_cascode_mirror = #M3(left) #M4(right) #M9(axis) @AS $MIRRORED_LAYOUT;
//   %m3_gate_orient = #M3:g @ORIENT("left");
//   %cas_r = #M2(source) #M4(cascode) @AS $CASCODE;
//   %pmos_cascode_mirror = #M5(left) #M6(right) #M9(axis) @AS $MIRRORED_LAYOUT;
//   %m5_gate_orient = #M5:g @ORIENT("left");
//   %cm = {#M7}(ref) {#M8}(out) {#M5}(refcascode) {#M6}(outcascode) @AS $CASCODE_CURRENT_MIRROR_P;
//   %load_mirror = #M7(left) #M8(right) #M9(axis) @AS $MIRRORED_LAYOUT;
//   %m7_gate_orient = #M7:g @ORIENT("right");
//   %load_group = {#M7 #M8 #M5 #M6} @GROUP;
//   %input_group = {#M1 #M2 #M3 #M4 #M9} @GROUP;
//   %tail_gate_orient = #M9:g @ORIENT("left");
//   %flow_ota = {%dp %cas_l %cas_r %cm}(path) {&inp &inn}(source) {&out}(load) @AS $SIGNAL_FLOW;
//
//   /* the two sides are branches from the top down: the PMOS load, the PMOS cascode, the NMOS cascode and the input
//      transistor; the tail below the pair is the pair's own */
//   %br_left = {#M7 #M5 #M3 #M1} @AS $BRANCH;
//   %br_right = {#M8 #M6 #M4 #M2} @AS $BRANCH;
//
//   /* the amplifier core with its signal ports; the bias ports stay outside */
//   %core_group = %dp %br_left %br_right %p_inp %p_inn %p_out @GROUP;
//
//   /* from left to right the input port, the two branches, the output port */
//   %port_order = {%p_inp %dp {%p_inn %p_out}} @ORDER("left-to-right");
//
//   /* the block symbol drawn for the instances: bias pins along the bottom */
//   $TELESCOPIC_SYM = @DEFINE-SYMBOL(box=[-8, -8, 8, 8]) {
//     (-8, 2) @PIN(terminal="inp", direction="left");
//     (-8, -2) @PIN(terminal="inn", direction="left");
//     (8, 0) @PIN(terminal="out", direction="right");
//     (0, 8) @PIN(terminal="vdd", direction="up");
//     (-6, -8) @PIN(terminal="vbt", direction="down");
//     (-2, -8) @PIN(terminal="vbn", direction="down");
//     (2, -8) @PIN(terminal="vbp", direction="down");
//     (6, -8) @PIN(terminal="vss", direction="down");
//     @LINE {(-7, 7.5) (7, 0) (-7, -7.5) (-7, 7.5)};
//     @LINE {(-8, 2) (-7, 2)};
//     @LINE {(-8, -2) (-7, -2)};
//     @LINE {(7, 0) (8, 0)};
//     @LINE {(0, 3.75) (0, 8)};
//     @LINE {(-6, -6.96) (-6, -8)};
//     @LINE {(-2, -4.82) (-2, -8)};
//     @LINE {(2, -2.68) (2, -8)};
//     @LINE {(6, -0.54) (6, -8)};
//     @LINE {(-6.4, 2) (-5.6, 2)};
//     @LINE {(-6, 2.4) (-6, 1.6)};
//     @LINE {(-6.4, -2) (-5.6, -2)};
//     ? @TEXT("${name}", key="name") => @PLACE(1.5, 5)
//   };
//   # @SET-SYMBOL $TELESCOPIC_SYM
// }
// @RNL(type="generated", priority="high", author="rnl-solver 0.1", hash="sig2:180288471dbda919.1965677fb5dbf2db", numbering="914b53c3b2d887eb") {
//   %ground_stub_M9_s = $GROUND_STUB @ATTACH(gap=3) #M9::s;
//   %supply_stub_M7_s = $SUPPLY_STUB @ATTACH(gap=3) #M7::s;
//   %supply_stub_M8_s = $SUPPLY_STUB @ATTACH(gap=3) #M8::s;
//   %bias_stub_M3_g = $BIAS_STUB @ATTACH #M3::g;
//   %bias_stub_M4_g = $BIAS_STUB @ATTACH #M4::g;
//   %bias_stub_M5_g = $BIAS_STUB @ATTACH #M5::g;
//   %bias_stub_M6_g = $BIAS_STUB @ATTACH #M6::g;
//   %bias_stub_M9_g = $BIAS_STUB @ATTACH #M9::g;
//   %io_port_vdd = $IO_PORT @ATTACH &vdd;
//   %io_port_vss = $IO_PORT @ATTACH &vss;
//   %io_port_vbn = $IO_PORT @ATTACH &vbn;
//   %io_port_vbp = $IO_PORT @ATTACH &vbp;
//   %io_port_vbt = $IO_PORT @ATTACH &vbt;
//   %rt1 = (22, 26);
//   %rt2 = (17, 12);
//   %rt3 = (12, 26);
//   %rt4 = (17, 36);
//   #M1 @PLACE(12, 16) => @ORIENT("R0");
//   #M2 @PLACE(22, 16) => @ORIENT("MY");
//   #M3 @PLACE(12, 22) => @ORIENT("R0");
//   #M4 @PLACE(22, 22) => @ORIENT("MY");
//   #M5 @PLACE(12, 30) => @ORIENT("R0");
//   #M6 @PLACE(22, 30) => @ORIENT("MY");
//   #M7 @PLACE(12, 36) => @ORIENT("MY");
//   #M8 @PLACE(22, 36) => @ORIENT("R0");
//   #M9 @PLACE(17, 9) => @ORIENT("R0");
//   %p_inp @PLACE(7, 16) => @ORIENT("R0");
//   %p_inn @PLACE(27, 16) => @ORIENT("MY");
//   %p_out @PLACE(27, 26) => @ORIENT("MY");
//   %dp @PLACE(17, 16);
//   %#1 @PLACE(7, 36);
//   %#2 @PLACE(17, 16);
//   %cas_l @PLACE(7, 36);
//   %#3 @PLACE(7, 36);
//   %#4 @PLACE(7, 36);
//   %nmos_cascode_mirror @PLACE(17, 22);
//   %cas_r @PLACE(7, 36);
//   %#5 @PLACE(7, 36);
//   %#6 @PLACE(7, 36);
//   %pmos_cascode_mirror @PLACE(17, 30);
//   %cm @PLACE(7, 36);
//   %#7 @PLACE(7, 36);
//   %load_mirror @PLACE(17, 36);
//   %flow_ota @PLACE(7, 36);
//   %br_left @PLACE(12, -0.95);
//   %#8 @PLACE(7, 36);
//   %br_right @PLACE(22, 26);
//   %#9 @PLACE(7, 36);
//   %ground_stub_M9_s @PLACE(7, 36);
//   %ground_stub_M9_s::g @PLACE(17, 5) => @ORIENT("R0");
//   %supply_stub_M7_s @PLACE(7, 36);
//   %supply_stub_M7_s::s @PLACE(12, 40) => @ORIENT("R0");
//   %supply_stub_M8_s @PLACE(7, 36);
//   %supply_stub_M8_s::s @PLACE(22, 40) => @ORIENT("R0");
//   %bias_stub_M3_g @PLACE(7, 36);
//   %bias_stub_M3_g::b @PLACE(9, 22) => @ORIENT("MYR90");
//   %bias_stub_M4_g @PLACE(7, 36);
//   %bias_stub_M4_g::b @PLACE(25, 22) => @ORIENT("R270");
//   %bias_stub_M5_g @PLACE(7, 36);
//   %bias_stub_M5_g::b @PLACE(9, 30) => @ORIENT("MYR90");
//   %bias_stub_M6_g @PLACE(7, 36);
//   %bias_stub_M6_g::b @PLACE(25, 30) => @ORIENT("R270");
//   %bias_stub_M9_g @PLACE(7, 36);
//   %bias_stub_M9_g::b @PLACE(14, 9) => @ORIENT("MYR90");
//   %io_port_vdd @PLACE(3, 16) => @ORIENT("R0");
//   %io_port_vss @PLACE(3, 12.4) => @ORIENT("R0");
//   %io_port_vbn @PLACE(3, 9) => @ORIENT("R0");
//   %io_port_vbp @PLACE(3, 5) => @ORIENT("R0");
//   %io_port_vbt @PLACE(3, 1) => @ORIENT("R0");
//   &inp @WIRE(mode="straight") {%p_inp::pin #M1::g};
//   &inn @WIRE(mode="straight") {#M2::g %p_inn::pin};
//   &out @WIRE(mode="straight") {#M4::d %rt1};
//   &out @WIRE(mode="straight") {%rt1 #M6::d};
//   &out @WIRE(mode="straight") {%rt1 %p_out::pin};
//   &xa @WIRE(mode="straight") {#M1::d #M3::s};
//   &tail @WIRE(mode="straight") {%rt2 #M9::d};
//   &tail @WIRE(mode="straight") {%rt2 (12, 12) #M1::s};
//   &tail @WIRE(mode="straight") {%rt2 (22, 12) #M2::s};
//   &xb @WIRE(mode="straight") {#M2::d #M4::s};
//   &outn @WIRE(mode="straight") {#M3::d %rt3};
//   &outn @WIRE(mode="straight") {%rt3 #M5::d};
//   &outn @WIRE(mode="straight") {%rt3 (17, 26) %rt4};
//   &outn @WIRE(mode="straight") {#M7::g %rt4};
//   &outn @WIRE(mode="straight") {%rt4 #M8::g};
//   &ya @WIRE(mode="straight") {#M5::s #M7::d};
//   &yb @WIRE(mode="straight") {#M6::s #M8::d};
//   $JUNCTION @ATTACH %rt1 => @PLACE(22, 26);
//   $JUNCTION @ATTACH %rt2 => @PLACE(17, 12);
//   $JUNCTION @ATTACH %rt3 => @PLACE(12, 26);
//   $JUNCTION @ATTACH %rt4 => @PLACE(17, 36)
// }
ends telescopic

VDD (vdd 0) vsource dc=1.8
VBN (vbn 0) vsource dc=1.1
VBP (vbp 0) vsource dc=0.8
VBT (vbt 0) vsource dc=0.64
VIP (inp 0) vsource dc=0.9 mag=0.5
VIN (inn 0) vsource dc=0.9 mag=0.5 phase=180
XU1 (inp inn out vdd 0 vbn vbp vbt) telescopic
CL (out 0) capacitor c=2p
// @RNL {
//   &vdd @ADD-TO $SUPPLY_NET_SET;
//   {&vbt &vbn &vbp} @ADD-TO $BIAS_NET_SET;
//   %routed_nets = # @SELECT-NET;
//   %routed_nets @ROUTE-NET;
//
//   /* what the circuit is: the OTA driven by two sources, loaded by CL, with three bias sources */
//   %flow = {#XU1}(path) {#VIP #VIN}(source) {#CL}(load) @AS $SIGNAL_FLOW;
//
//   /* from left to right the supply source, the input sources (VIP first), the amplifier and the load */
//   %testbench_order = {#VDD #VIP #VIN #XU1 #CL} @ORDER("left-to-right");
//
//   /* the three bias sources in one row below the amplifier, in the order of its bias pins: vbt, vbn, vbp */
//   %bias_row = {#VBT #VBN #VBP} @ALIGN("y");
//   %bias_order = {#VBT #VBN #VBP} @ORDER("left-to-right");
//   %bias_below = {#XU1 {#VBT #VBN #VBP}} @ORDER("top-to-bottom");
//
//   /* only the sources and the load are oriented */
//   %upright_parts = {#VDD #VIP #VIN #VBT #VBN #VBP #CL} @ORIENT("R0")
// }
// @RNL(type="generated", priority="high", author="rnl-solver 0.1", hash="sig2:53458283e7e09dce.0b11fdc313c11a39") {
//   %ground_stub_VDD_n = $GROUND_STUB @ATTACH(gap=3) #VDD::n;
//   %ground_stub_VBN_n = $GROUND_STUB @ATTACH(gap=3) #VBN::n;
//   %ground_stub_VBP_n = $GROUND_STUB @ATTACH(gap=3) #VBP::n;
//   %ground_stub_VBT_n = $GROUND_STUB @ATTACH(gap=3) #VBT::n;
//   %ground_stub_VIP_n = $GROUND_STUB @ATTACH(gap=3) #VIP::n;
//   %ground_stub_VIN_n = $GROUND_STUB @ATTACH(gap=3) #VIN::n;
//   %ground_stub_XU1_vss = $GROUND_STUB @ATTACH(gap=3) #XU1:vss;
//   %ground_stub_CL_n = $GROUND_STUB @ATTACH(gap=3) #CL::n;
//   %supply_stub_VDD_p = $SUPPLY_STUB @ATTACH(gap=3) #VDD::p;
//   %supply_stub_XU1_vdd = $SUPPLY_STUB @ATTACH(gap=3) #XU1:vdd;
//   %bias_stub_VBT_p = $BIAS_STUB @ATTACH #VBT::p;
//   %bias_stub_XU1_vbt = $BIAS_STUB @ATTACH #XU1:vbt;
//   %bias_stub_VBN_p = $BIAS_STUB @ATTACH #VBN::p;
//   %bias_stub_XU1_vbn = $BIAS_STUB @ATTACH #XU1:vbn;
//   %bias_stub_VBP_p = $BIAS_STUB @ATTACH #VBP::p;
//   %bias_stub_XU1_vbp = $BIAS_STUB @ATTACH #XU1:vbp;
//   #VDD @PLACE(2, 15) => @ORIENT("R0");
//   #VBN @PLACE(9, 1) => @ORIENT("R0");
//   #VBP @PLACE(16, 1) => @ORIENT("R0");
//   #VBT @PLACE(2, 1) => @ORIENT("R0");
//   #VIP @PLACE(9, 15) => @ORIENT("R0");
//   #VIN @PLACE(16, 15) => @ORIENT("R0");
//   #XU1 @PLACE(28, 21) => @ORIENT("R0");
//   #CL @PLACE(40, 15) => @ORIENT("R0");
//   %flow @PLACE(20, 19);
//   %ground_stub_VDD_n @PLACE(20, 19);
//   %ground_stub_VDD_n::g @PLACE(2, 11) => @ORIENT("R0");
//   %ground_stub_VBN_n @PLACE(20, 19);
//   %ground_stub_VBN_n::g @PLACE(9, -3) => @ORIENT("R0");
//   %ground_stub_VBP_n @PLACE(20, 19);
//   %ground_stub_VBP_n::g @PLACE(16, -3) => @ORIENT("R0");
//   %ground_stub_VBT_n @PLACE(20, 19);
//   %ground_stub_VBT_n::g @PLACE(2, -3) => @ORIENT("R0");
//   %ground_stub_VIP_n @PLACE(20, 19);
//   %ground_stub_VIP_n::g @PLACE(9, 11) => @ORIENT("R0");
//   %ground_stub_VIN_n @PLACE(20, 19);
//   %ground_stub_VIN_n::g @PLACE(16, 11) => @ORIENT("R0");
//   %ground_stub_XU1_vss @PLACE(20, 19);
//   %ground_stub_XU1_vss::g @PLACE(34, 11) => @ORIENT("R0");
//   %ground_stub_CL_n @PLACE(20, 19);
//   %ground_stub_CL_n::g @PLACE(40, 11) => @ORIENT("R0");
//   %supply_stub_VDD_p @PLACE(20, 19);
//   %supply_stub_VDD_p::s @PLACE(2, 19) => @ORIENT("R0");
//   %supply_stub_XU1_vdd @PLACE(20, 19);
//   %supply_stub_XU1_vdd::s @PLACE(28, 31) => @ORIENT("R0");
//   %bias_stub_VBT_p @PLACE(20, 19);
//   %bias_stub_VBT_p::b @PLACE(2, 3) => @ORIENT("R0");
//   %bias_stub_XU1_vbt @PLACE(20, 19);
//   %bias_stub_XU1_vbt::b @PLACE(22, 13) => @ORIENT("R180");
//   %bias_stub_VBN_p @PLACE(20, 19);
//   %bias_stub_VBN_p::b @PLACE(9, 3) => @ORIENT("R0");
//   %bias_stub_XU1_vbn @PLACE(20, 19);
//   %bias_stub_XU1_vbn::b @PLACE(26, 13) => @ORIENT("R180");
//   %bias_stub_VBP_p @PLACE(20, 19);
//   %bias_stub_VBP_p::b @PLACE(16, 3) => @ORIENT("R0");
//   %bias_stub_XU1_vbp @PLACE(20, 19);
//   %bias_stub_XU1_vbp::b @PLACE(30, 13) => @ORIENT("R180");
//   &inp @WIRE(mode="straight") {#VIP::p (9, 23) #XU1:inp};
//   &inn @WIRE(mode="straight") {#VIN::p (16, 19) #XU1:inn};
//   &out @WIRE(mode="straight") {#XU1:out (40, 21) #CL::p}
// }
