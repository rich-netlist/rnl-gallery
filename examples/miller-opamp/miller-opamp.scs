// Two-stage Miller-compensated op-amp, in a unity-gain buffer testbench
// A five-transistor OTA first stage, a PMOS common-source second stage M6/M7 and the compensation RZ + CC,
// biased by a mirror of IREF. The top level connects it as a unity-gain buffer.
// @RNL(type="header") { @USE-PACKAGE(name="rnl-std-all", version="0.4"); @VERSION("0.4") }
simulator lang=spectre

model nch mos1 type=n vto=0.5 kp=200u lambda=0.1
model pch mos1 type=p vto=-0.5 kp=80u lambda=0.1

subckt miller2 inp inn out vdd vss
IREF (vdd nb) isource dc=20u
M8 (nb nb vss vss) nch w=4u l=1u
M5 (tail nb vss vss) nch w=8u l=1u
M1 (x inn tail vss) nch w=10u l=0.5u
M2 (y inp tail vss) nch w=10u l=0.5u
M3 (x x vdd vdd) pch w=10u l=0.5u
M4 (y x vdd vdd) pch w=10u l=0.5u
M6 (out y vdd vdd) pch w=40u l=0.5u
M7 (out nb vss vss) nch w=16u l=1u
RZ (y z) resistor r=2k
CC (z out) capacitor c=3p
// @RNL {
//   &vdd @ADD-TO $SUPPLY_NET_SET;
//   &vss @ADD-TO $GROUND_NET_SET;
//   $IO_PORT @ATTACH &inn => %p_inn;
//   $IO_PORT @ATTACH &inp => %p_inp;
//   $IO_PORT @ATTACH &out => %p_out;
//   %routed_nets = # @SELECT-NET;
//   %routed_nets @ROUTE-NET;
//
//   /* the static currents (15.2), for the solver to draw them downwards; not criteria */
//   {#IREF:p #M8:d #M5:d #M1:d #M2:d #M7:d #M3:s #M4:s #M6:s} @CURRENT("in");
//   {#IREF:n #M8:s #M5:s #M1:s #M2:s #M7:s #M3:d #M4:d #M6:d} @CURRENT("out");
//
//   /* what the circuit is: an OTA first stage, a common-source second stage M6/M7, the compensation RZ + CC, biased by a mirror of IREF */
//   %dp = #M1(left) #M2(right) #M5(tail) @AS $DIFFERENTIAL_PAIR_N;
//   %cm_load = {#M3}(ref) {#M4}(out) @AS $CURRENT_MIRROR_P;
//   %cm_bias = {#M8}(ref) {#M5 #M7}(out) @AS $CURRENT_MIRROR_N;
//   %amp1 = %dp(transconductor) %cm_load(load) @AS $TRANSCONDUCTOR_Z_AMPLIFIER;
//   %diode_connected = {#M3 #M8} @AS $DIODE_CONNECTED;
//   %bias = {#IREF #M8} @AS $BIAS_CIRCUIT;
//   %cs2 = #M6(input) #M7(load) @AS $COMMON_SOURCE_AMPLIFIER;
//   %comp = {#RZ #CC} @AS $BRANCH_HORIZONTAL;
//   %miller = %cs2(stage) %comp(compensation) @AS $MILLER_AMPLIFIER;
//   %casc = {%dp %cs2} @AS $CASCADE;
//   %flow_op = {%dp %cs2}(path) {&inp &inn}(source) {&out}(load) @AS $SIGNAL_FLOW;
//
//   /* the supply-to-ground paths, each a branch from the top down: the bias branch, the two sides of the pair (the
//      tail M5 is the pair's) and the second stage; the compensation is a branch from the left to the right */
//   %br_bias = {#IREF #M8} @AS $BRANCH;
//   %br_left = {#M3 #M1} @AS $BRANCH;
//   %br_right = {#M4 #M2} @AS $BRANCH;
//   %br_out = {#M6 #M7} @AS $BRANCH;
//
//   /* from left to right the bias branch, the first stage, the compensation, the second stage and the output port */
//   %stage_order = {%br_bias %amp1 %comp %br_out %p_out} @ORDER("left-to-right");
//
//   /* the block symbol drawn for the instances of miller2: the inverting input on top */
//   # @SET-SYMBOL(terminals=[[1, "inp"], [2, "inn"], [3, "out"], [4, "vp"], [5, "vn"]]) $OPAMP_INVERTED_SUPPLY
// }
// @RNL(type="generated", priority="high", author="rnl-solver 0.1", hash="sig2:ec9afde8cb1482fc.123e5ad0434d3a61", numbering="7ae55d03908d464d") {
//   %ground_stub_M8_s = $GROUND_STUB @ATTACH(gap=3) #M8::s;
//   %ground_stub_M5_s = $GROUND_STUB @ATTACH(gap=3) #M5::s;
//   %ground_stub_M7_s = $GROUND_STUB @ATTACH(gap=3) #M7::s;
//   %supply_stub_IREF_p = $SUPPLY_STUB @ATTACH(gap=3) #IREF::p;
//   %supply_stub_M3_s = $SUPPLY_STUB @ATTACH(gap=3) #M3::s;
//   %supply_stub_M4_s = $SUPPLY_STUB @ATTACH(gap=3) #M4::s;
//   %supply_stub_M6_s = $SUPPLY_STUB @ATTACH(gap=3) #M6::s;
//   %io_port_vdd = $IO_PORT @ATTACH &vdd;
//   %io_port_vss = $IO_PORT @ATTACH &vss;
//   %rt1 = (56, 18);
//   %rt2 = (8, 12);
//   %rt3 = (17, 8);
//   %rt4 = (32, 8);
//   %rt5 = (26, 12);
//   %rt6 = (20, 22);
//   %rt7 = (26, 26);
//   %rt8 = (32, 22);
//   %rt9 = (37, 22);
//   #IREF @PLACE(8, 16) => @ORIENT("R0");
//   #M8 @PLACE(8, 8) => @ORIENT("MY");
//   #M5 @PLACE(26, 8) => @ORIENT("MY");
//   #M1 @PLACE(20, 16) => @ORIENT("R0");
//   #M2 @PLACE(32, 16) => @ORIENT("MY");
//   #M3 @PLACE(20, 26) => @ORIENT("MY");
//   #M4 @PLACE(32, 26) => @ORIENT("R0");
//   #M6 @PLACE(56, 22) => @ORIENT("R0");
//   #M7 @PLACE(56, 8) => @ORIENT("R0");
//   #RZ @PLACE(43, 18) => @ORIENT("R90");
//   #CC @PLACE(49, 18) => @ORIENT("R90");
//   %p_inn @PLACE(15, 16) => @ORIENT("R0");
//   %p_inp @PLACE(37, 16) => @ORIENT("MY");
//   %p_out @PLACE(60, 18) => @ORIENT("MY");
//   %dp @PLACE(26, 16);
//   %#1 @PLACE(20, 16);
//   %#2 @PLACE(26, 16);
//   %cm_load @PLACE(15, 26);
//   %cm_bias @PLACE(2, 8);
//   %amp1 @PLACE(20, 16);
//   %#3 @PLACE(20, 16);
//   %#4 @PLACE(20, 16);
//   %bias @PLACE(20, 16);
//   %cs2 @PLACE(20, 16);
//   %#5 @PLACE(20, 16);
//   %#6 @PLACE(20, 16);
//   %comp @PLACE(47, 18);
//   %#7 @PLACE(20, 16);
//   %miller @PLACE(20, 16);
//   %#8 @PLACE(20, 16);
//   %casc @PLACE(20, 16);
//   %flow_op @PLACE(20, 16);
//   %br_bias @PLACE(8, -1.95);
//   %#9 @PLACE(20, 16);
//   %br_left @PLACE(20, -1.95);
//   %#10 @PLACE(20, 16);
//   %br_right @PLACE(32, -1.95);
//   %#11 @PLACE(20, 16);
//   %br_out @PLACE(56, 18.48);
//   %#12 @PLACE(20, 16);
//   %ground_stub_M8_s @PLACE(20, 16);
//   %ground_stub_M8_s::g @PLACE(8, 4) => @ORIENT("R0");
//   %ground_stub_M5_s @PLACE(20, 16);
//   %ground_stub_M5_s::g @PLACE(26, 4) => @ORIENT("R0");
//   %ground_stub_M7_s @PLACE(20, 16);
//   %ground_stub_M7_s::g @PLACE(56, 4) => @ORIENT("R0");
//   %supply_stub_IREF_p @PLACE(20, 16);
//   %supply_stub_IREF_p::s @PLACE(8, 20) => @ORIENT("R0");
//   %supply_stub_M3_s @PLACE(20, 16);
//   %supply_stub_M3_s::s @PLACE(20, 30) => @ORIENT("R0");
//   %supply_stub_M4_s @PLACE(20, 16);
//   %supply_stub_M4_s::s @PLACE(32, 30) => @ORIENT("R0");
//   %supply_stub_M6_s @PLACE(20, 16);
//   %supply_stub_M6_s::s @PLACE(56, 26) => @ORIENT("R0");
//   %io_port_vdd @PLACE(2, 4) => @ORIENT("R0");
//   %io_port_vss @PLACE(2, 0) => @ORIENT("R0");
//   &inp @WIRE(mode="straight") {#M2::g %p_inp::pin};
//   &inn @WIRE(mode="straight") {%p_inn::pin #M1::g};
//   &out @WIRE(mode="straight") {#CC::n %rt1};
//   &out @WIRE(mode="straight") {#M7::d %rt1};
//   &out @WIRE(mode="straight") {%rt1 #M6::d};
//   &out @WIRE(mode="straight") {%rt1 %p_out::pin};
//   &nb @WIRE(mode="straight") {#M8::d %rt2};
//   &nb @WIRE(mode="straight") {%rt2 #IREF::n};
//   &nb @WIRE(mode="straight") {%rt2 (17, 12) %rt3};
//   &nb @WIRE(mode="straight") {#M8::g %rt3};
//   &nb @WIRE(mode="straight") {%rt3 (17, 0) (32, 0) %rt4};
//   &nb @WIRE(mode="straight") {#M5::g %rt4};
//   &nb @WIRE(mode="straight") {%rt4 #M7::g};
//   &tail @WIRE(mode="straight") {#M1::s (20, 12) %rt5};
//   &tail @WIRE(mode="straight") {#M5::d %rt5};
//   &tail @WIRE(mode="straight") {%rt5 (32, 12) #M2::s};
//   &x @WIRE(mode="straight") {#M1::d %rt6};
//   &x @WIRE(mode="straight") {%rt6 #M3::d};
//   &x @WIRE(mode="straight") {%rt6 (26, 22) %rt7};
//   &x @WIRE(mode="straight") {#M3::g %rt7};
//   &x @WIRE(mode="straight") {%rt7 #M4::g};
//   &y @WIRE(mode="straight") {#M2::d %rt8};
//   &y @WIRE(mode="straight") {%rt8 #M4::d};
//   &y @WIRE(mode="straight") {%rt8 %rt9};
//   &y @WIRE(mode="straight") {%rt9 (37, 18) #RZ::p};
//   &y @WIRE(mode="straight") {%rt9 #M6::g};
//   &z @WIRE(mode="straight") {#RZ::n #CC::p};
//   $JUNCTION @ATTACH %rt1 => @PLACE(56, 18);
//   $JUNCTION @ATTACH %rt2 => @PLACE(8, 12);
//   $JUNCTION @ATTACH %rt3 => @PLACE(17, 8);
//   $JUNCTION @ATTACH %rt4 => @PLACE(32, 8);
//   $JUNCTION @ATTACH %rt5 => @PLACE(26, 12);
//   $JUNCTION @ATTACH %rt6 => @PLACE(20, 22);
//   $JUNCTION @ATTACH %rt7 => @PLACE(26, 26);
//   $JUNCTION @ATTACH %rt8 => @PLACE(32, 22);
//   $JUNCTION @ATTACH %rt9 => @PLACE(37, 22)
// }
ends miller2

VDD (vdd 0) vsource dc=1.8
VIN (in 0) vsource dc=0.9 mag=1
XU1 (in out out vdd 0) miller2
CL (out 0) capacitor c=2p
// @RNL {
//   &vdd @ADD-TO $SUPPLY_NET_SET;
//
//   /* the feedback from the output over the amplifier to the inverting input is how the reference draws it, not a
//      criterion: on which side a wire runs cannot be checked from the placement (G1), so the case states it as an
//      objective */
//   %routed_nets = # @SELECT-NET;
//   %routed_nets @ROUTE-NET;
//
//   /* from left to right the input source, the amplifier and the load; the supply source stands at least 4 to the left */
//   %testbench_order = {#VIN #XU1 #CL} @ORDER("left-to-right");
//   %supply_distance = #VDD {#VIN #XU1 #CL} @DISTANCE("left-to-right", min=4);
//
//   /* only the sources and the load are turned */
//   %upright_parts = {#VDD #VIN #CL} @ORIENT("R0");
// }
// @RNL(type="generated", priority="high", author="rnl-solver 0.1", hash="sig2:2083aee99bd9d85e.023cf5e5921e0ac5") {
//   %ground_stub_VDD_n = $GROUND_STUB @ATTACH(gap=3) #VDD::n;
//   %ground_stub_VIN_n = $GROUND_STUB @ATTACH(gap=3) #VIN::n;
//   %ground_stub_XU1_vn = $GROUND_STUB @ATTACH(gap=3) #XU1::vn;
//   %ground_stub_CL_n = $GROUND_STUB @ATTACH(gap=3) #CL::n;
//   %supply_stub_VDD_p = $SUPPLY_STUB @ATTACH(gap=3) #VDD::p;
//   %supply_stub_XU1_vp = $SUPPLY_STUB @ATTACH(gap=3) #XU1::vp;
//   %rt1 = (23, 4);
//   #VDD @PLACE(1, 0) => @ORIENT("R0");
//   #VIN @PLACE(8, 0) => @ORIENT("R0");
//   #XU1 @PLACE(15, 4) => @ORIENT("R0");
//   #CL @PLACE(23, 0) => @ORIENT("R0");
//   %ground_stub_VDD_n @PLACE(1, 2);
//   %ground_stub_VDD_n::g @PLACE(1, -4) => @ORIENT("R0");
//   %ground_stub_VIN_n @PLACE(1, 2);
//   %ground_stub_VIN_n::g @PLACE(8, -4) => @ORIENT("R0");
//   %ground_stub_XU1_vn @PLACE(1, 2);
//   %ground_stub_XU1_vn::g @PLACE(15, -2) => @ORIENT("R0");
//   %ground_stub_CL_n @PLACE(1, 2);
//   %ground_stub_CL_n::g @PLACE(23, -4) => @ORIENT("R0");
//   %supply_stub_VDD_p @PLACE(1, 2);
//   %supply_stub_VDD_p::s @PLACE(1, 4) => @ORIENT("R0");
//   %supply_stub_XU1_vp @PLACE(1, 2);
//   %supply_stub_XU1_vp::s @PLACE(15, 9) => @ORIENT("R0");
//   &in @WIRE(mode="straight") {#VIN::p (8, 3) #XU1::inp};
//   &out @WIRE(mode="straight") {#XU1::inn (8, 5) (8, 13) (23, 13) %rt1};
//   &out @WIRE(mode="straight") {#XU1::out %rt1};
//   &out @WIRE(mode="straight") {#CL::p %rt1};
//   $JUNCTION @ATTACH %rt1 => @PLACE(23, 4)
// }
