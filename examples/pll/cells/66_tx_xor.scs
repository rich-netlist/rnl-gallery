simulator lang=spectre
// @RNL(type="header") {
//   @VERSION("0.3");
//   @USE-PACKAGE(name="pll-semantics", version="0.3", path="../pll_semantics.rnl")
// }
subckt tx_xor_pdk110_66 (a b y vdd vss)
XI (a ab vdd vss) pll_inv_pdk110_48
XM (a ab b y vdd vss) tx_mux_pdk110_64
// @RNL(author="gemini-4-argon") {
//   # @SET-SYMBOL $XOR_2INPUT;
//
//   /* --- 1. Circuit Semantics --- */
//   %mux = {#XM}(mux_cells) @AS(role="xor_via_2to1_mux") $MULTIPLEXER_BANK;
//   {%pa #XI #XM %py} @AS(direction="left-to-right") $FLOW;
//
//   /* --- 2. Schematic Placement & Orientation --- */
//   %pa = $IO_PORT @ATTACH &a => @PLACE(2, 13)  => @ORIENT("R0");
//   %pb = $IO_PORT @ATTACH &b => @PLACE(2, 6)   => @ORIENT("R0");
//   %py = $IO_PORT @ATTACH &y => @PLACE(28, 12) => @ORIENT("MY");
//
//   #XI @PLACE(11, 11) => @ORIENT("R0");
//   #XM @PLACE(20, 12) => @ORIENT("R0");
//
//   /* --- 3. Explicit Manhattan Wiring --- */
//   %ja = (5, 13);
//   $JUNCTION @ATTACH %ja;
//   &a  @WIRE { %pa:p %ja #XM:a };
//   &a  @WIRE { %ja (5, 11) #XI:a };
//   &ab @WIRE { #XI:y #XM:b };
//   &b  @WIRE { %pb:p (20, 6) #XM:s };
//   &y  @WIRE { #XM:y %py:p };
//
//   /* --- 4. Annotations --- */
//   (15, 18) @TEXT("tx_xor_pdk110_66: 2-Input Exclusive-OR Gate (212 Instances in Arithmetic/Comparators)", halign="middle") => @SET-STYLE $title_style;
//   (15, 16.3) @TEXT("Implemented as 2-to-1 Multiplexer (XM): Selects a when b=0, or NOT(a) (via XI) when b=1", halign="middle") => @SET-STYLE $subtitle_style
// }
ends tx_xor_pdk110_66
