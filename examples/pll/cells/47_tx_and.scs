simulator lang=spectre
// @RNL(type="header") { @USE-PACKAGE(name="rnl-std-all", version="0.4"); @USE-PACKAGE(name="rnl-std-semantics", version="0.4");
//   @VERSION("0.4");
//   @USE-PACKAGE(name="pll-semantics", version="0.3", path="../pll_semantics.rnl")
// }
subckt tx_and_pdk110_47 (a b y vdd vss)
XN (a b n vdd vss) pll_nand2_pdk110_15
XI (n y vdd vss) pll_inv_pdk110_48
// @RNL(author="gemini-4-argon") {
//   # @SET-SYMBOL(terminals=[[1, "a"], [2, "b"], [3, "y"]]) $AND_2INPUT;
//
//   /* --- 1. Circuit Semantics --- */
//   /* rnl upgrade: CHAIN was removed in 0.4; retain the intended ordering or series topology explicitly (16.3) */
// {#XN #XI %py} @ORDER("left-to-right", priority="low");
//   {%pa #XN #XI %py} @AS $SIGNAL_FLOW; {%pa #XN #XI %py} @ORDER("left-to-right", priority="low");
//
//   /* --- 2. Schematic Placement & Orientation --- */
//   %pa = $IO_PORT @ATTACH &a => @PLACE(2, 11) => @ORIENT("R0");
//   %pb = $IO_PORT @ATTACH &b => @PLACE(2, 9)  => @ORIENT("R0");
//   %py = $IO_PORT @ATTACH &y => @PLACE(26, 10) => @ORIENT("MY");
//
//   #XN @PLACE(10, 10) => @ORIENT("R0");
//   #XI @PLACE(20, 10) => @ORIENT("R0");
//
//   /* --- 3. Explicit Manhattan Wiring --- */
//   &a @WIRE { %pa::pin #XN:a };
//   &b @WIRE { %pb::pin #XN:b };
//   &n @WIRE { #XN:y #XI:a };
//   &y @WIRE { #XI:y %py::pin };
//
//   /* --- 4. Annotations --- */
//   (14, 16) @TEXT("tx_and_pdk110_47: 2-Input Static CMOS AND Gate (650 Instances in Synthesized Logic)", halign="middle") => @SET-STYLE $title_style;
//   (14, 14.3) @TEXT("2-Input NAND Gate (XN: pll_nand2_pdk110_15) + Output Inverter (XI: pll_inv_pdk110_48)", halign="middle") => @SET-STYLE $subtitle_style
// }
ends tx_and_pdk110_47
