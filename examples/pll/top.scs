simulator lang=spectre
// @RNL(type="header") { @USE-PACKAGE(name="rnl-std-all", version="0.4"); @USE-PACKAGE(name="rnl-std-semantics", version="0.4");
//   @VERSION("0.4");
//   @USE-PACKAGE(name="pll-semantics", version="0.3", path="./pll_semantics.rnl")
// }
// @RNL { # @SELECT-PIN(recursive=true) => @REMOVE-FROM $LABEL_FILL_SET; $SUPPLY_NET_SET @REMOVE-FROM $PORT_FILL_SET; $GROUND_NET_SET @REMOVE-FROM $PORT_FILL_SET }
include "cells/00_pll_capture_rt4_r48_recenter109_v14.scs"
include "cells/01_lc_vco_physical_v14.scs"
include "cells/02_lc_core_physical_v14.scs"
include "cells/03_tx_inductor_pi.scs"
include "cells/04_tx_cap_bank_switched_v4.scs"
include "cells/05_tx_bias_mid_v5.scs"
include "cells/06_tx_reference_buffer.scs"
include "cells/07_pll_inv.scs"
include "cells/08_pll_inv.scs"
include "cells/09_pll_inv.scs"
include "cells/10_pll_inv.scs"
include "cells/11_tx_sampler.scs"
include "cells/12_pll_inv.scs"
include "cells/13_pll_tg.scs"
include "cells/14_cp_physical_v14.scs"
include "cells/15_pll_nand2.scs"
include "cells/16_pll_tg.scs"
include "cells/17_tx_loop_filter_v5.scs"
include "cells/18_pll_tg.scs"
include "cells/19_rf_light24s12_v14.scs"
include "cells/20_pll_inv.scs"
include "cells/21_bank_pulsetrip_v14.scs"
include "cells/22_ff_fbdelay50_v14.scs"
include "cells/23_pll_inv.scs"
include "cells/24_pll_inv.scs"
include "cells/25_pll_tspc_inv.scs"
include "cells/26_pll_inv.scs"
include "cells/27_pll_inv.scs"
include "cells/28_pll_inv.scs"
include "cells/29_pll_inv.scs"
include "cells/30_div3_fast_v14.scs"
include "cells/31_pll_inv.scs"
include "cells/32_nor_fast_v14.scs"
include "cells/33_ff_static_fast_v14.scs"
include "cells/34_ring_inv_latch_v14.scs"
include "cells/35_pll_tg.scs"
include "cells/36_pll_inv.scs"
include "cells/37_pll_inv.scs"
include "cells/38_pll_inv.scs"
include "cells/39_pll_inv.scs"
include "cells/40_pll_inv.scs"
include "cells/41_pll_inv.scs"
include "cells/42_ring_sync_singlephase_v14.scs"
include "cells/43_pll_tg.scs"
include "cells/44_ff_singlephase_v14.scs"
include "cells/45_pll_inv.scs"
include "cells/46_ring_tail_singlephase_v14.scs"
include "cells/47_tx_and.scs"
include "cells/48_pll_inv.scs"
include "cells/49_rt_noise_scale4_v14.scs"
include "cells/50_rtcomb_ff_v13.scs"
include "cells/51_pll_inv.scs"
include "cells/52_pll_inv.scs"
include "cells/53_validity_physical_v14.scs"
include "cells/54_cmp_physical_v14.scs"
include "cells/55_pll_inv.scs"
include "cells/56_pll_control_recenter109_v14.scs"
include "cells/57_tx_pll_config.scs"
include "cells/58_tx_dff_r0.scs"
include "cells/59_pll_inv.scs"
include "cells/60_tx_latch_r.scs"
include "cells/61_pll_tg.scs"
include "cells/62_pll_inv.scs"
include "cells/63_pll_tg.scs"
include "cells/64_tx_mux.scs"
include "cells/65_pll_tg.scs"
include "cells/66_tx_xor.scs"
include "cells/67_tx_or.scs"
include "cells/68_pll_nor2.scs"
include "cells/69_tx_fll_recenter109_v14.scs"
include "cells/70_tx_dff_r1.scs"
include "cells/71_tx_fll_counter.scs"
include "cells/72_pll_latch.scs"
include "cells/73_tx_tff.scs"
include "cells/74_tx_fll_snapshot.scs"
include "cells/75_tx_fll_dac.scs"
include "cells/76_pll_inv.scs"
include "cells/77_tx_pll_supervisor_capture_v14.scs"
include "cells/78_tx_cp_timing.scs"
include "cells/79_pll_inv.scs"
include "cells/80_tx_frequency_watchdog.scs"
XPLL (ref reset apply k0 k1 k2 k3 k4 k5 out qualified range_error cfg_ready frequency_good phase_good amp_good vdd vss) pll_capture_rt4_r48_recenter109_v14_pdk110_0
// @RNL(author="gemini-4-argon") {
//   /* --- 1. Circuit Semantics --- */
//   {#XPLL} @AS(purpose="top_level_PLL_chip_macro") $TAPERED_BUFFER_CHAIN;
//   {%pref #XPLL %pout} @AS $SIGNAL_FLOW; {%pref #XPLL %pout} @ORDER("left-to-right", priority="low");
//
//   /* --- 2. Schematic Placement & Orientation --- */
//   {&k1 &k2 &k3 &k4 &k5} @REMOVE-FROM $PORT_FILL_SET;
//   %pref   = $NET_LABEL @ATTACH &ref            => @PLACE(4, 28) => @ORIENT("R0");
//   %prst   = $NET_LABEL @ATTACH &reset          => @PLACE(4, 25) => @ORIENT("R0");
//   %papply = $NET_LABEL @ATTACH &apply          => @PLACE(4, 22) => @ORIENT("R0");
//   %pk     = $NET_LABEL @ATTACH &k0             => @PLACE(4, 16) => @ORIENT("R0");
//   %pk @TEXT("k<5:0>", key="netname");
//
//   %pout   = $NET_LABEL @ATTACH &out            => @PLACE(44, 28) => @ORIENT("MY");
//   %pqual  = $NET_LABEL @ATTACH &qualified      => @PLACE(44, 24) => @ORIENT("MY");
//   %prng   = $NET_LABEL @ATTACH &range_error    => @PLACE(44, 21) => @ORIENT("MY");
//   %prdy   = $NET_LABEL @ATTACH &cfg_ready      => @PLACE(44, 18) => @ORIENT("MY");
//   %pfrq   = $NET_LABEL @ATTACH &frequency_good => @PLACE(44, 15) => @ORIENT("MY");
//   %pph    = $NET_LABEL @ATTACH &phase_good     => @PLACE(44, 12) => @ORIENT("MY");
//   %pamp   = $NET_LABEL @ATTACH &amp_good       => @PLACE(44, 9)  => @ORIENT("MY");
//
//   %sup = $SUPPLY @ATTACH &vdd => @PLACE(24, 36);
//   %gnd = $GROUND @ATTACH &vss => @PLACE(24, 2);
//
//   #XPLL @PLACE(24, 20) => @ORIENT("R0");
//
//   /* --- 3. Explicit Manhattan & Single-Line Bus Wiring --- */
//   &ref   @WIRE { %pref::pin   #XPLL:ref };
//   &reset @WIRE { %prst::pin   #XPLL:reset };
//   &apply @WIRE { %papply::pin #XPLL:apply };
//   {&k0 &k1 &k2 &k3 &k4 &k5} @WIRE { %pk::pin #XPLL:k0 } => @TEXT("K<5:0>") => @SET-STYLE $bus_label_style;
//
//   &out            @WIRE { #XPLL:out            %pout::pin };
//   &qualified      @WIRE { #XPLL:qualified      %pqual::pin };
//   &range_error    @WIRE { #XPLL:range_error    %prng::pin };
//   &cfg_ready      @WIRE { #XPLL:cfg_ready      %prdy::pin };
//   &frequency_good @WIRE { #XPLL:frequency_good %pfrq::pin };
//   &phase_good     @WIRE { #XPLL:phase_good     %pph::pin };
//   &amp_good       @WIRE { #XPLL:amp_good       %pamp::pin };
//
//   &vdd @WIRE { %sup::pin #XPLL:vdd };
//   &vss @WIRE { #XPLL:vss %gnd::pin };
//
//   /* --- 4. Annotations --- */
//   (24, 44) @TEXT("top.scs: Top-Level Hierarchical Netlist Instantiating XPLL (pll_capture_rt4_r48_recenter109_v14_pdk110_0)", halign="middle") => @SET-STYLE $title_style;
//   (24, 42) @TEXT("Includes All 81 Hierarchical Cell Subcircuits (cells/00_*.scs .. cells/80_*.scs) and Unified PLL Semantic Package (pll_semantics.rnl)", halign="middle") => @SET-STYLE $subtitle_style
// }
